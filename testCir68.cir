.subckt DCSFQ 2 17
B01        5          3          jj1     area=1.32
B02        5          6          jj1     area=1
B03        9          10         jj1     area=1.5
B04        13         14         jj1     area=1.96
B05        15         16         jj1     area=1.96
IB01       0          8          pwl(0 0 5p 162.5u)
IB02       0          12         pwl(0 0 5p 260u)
L01        2          1          0.848p
L02        0          1          7.712p
L03        1          3          1.778p
L04        5          7          0.543p
L05        7          9          3.149p
L06        9          11         1.323p
L07        11         13         1.095p
L08        13         15         2.951p
L09        15         17         1.63p
LP01       0          6          0.398p
LP02       0          10         0.211p
LP03       0          14         0.276p
LP04       0          16         0.224p
LPR01      7          8          0.915p
LPR02      11         12         0.307p
LRB01      4          5          1p
LRB02      18         6          1p
LRB03      19         10         1p
LRB04      20         14         1p
LRB05      21         16         1p
RB01       3          4          8.56
RB02       18         5          11.30
RB03       19         9          7.53
RB04       20         13         5.77
RB05       21         15         5.77
.model jj1 jj(rtype=1, vg=2.8mV, cap=0.07pF, r0=160, rN=16, icrit=0.15mA)
.ends DCSFQ

.subckt CONFLU 1 2 3 4 14
B01 5 0 jmitll
B02 5 9 jmitll area=1.5
B03 6 0 jmitll
B04 6 10 jmitll area=1.5
B05 7 0 jmitll
B06 7 11 jmitll area=1.5
B07 8 0 jmitll
B08 8 12 jmitll area=1.5
B0L 14 0 jmitll
L01 1 5 0.5p
L02 2 6 0.5p
L03 3 7 0.5p
L04 4 8 0.5p
L05 9 13 0.5p
L06 10 13 0.5p
L07 11 13 0.5p
L08 12 13 0.5p
LC1 13 14 2p
I01 0 13 pwl(0 0 5p 800u)
.model jmitll jj(rtype=1, vg=2.8mV, cap=0.07pF, r0=160, rN=16, icrit=0.15mA)
.ends CONFLU

.subckt NEURON 11 5 4
B01        0          11         jmitll
B02        0          4          jmitll
B03        0          5          jmitll
IB0        0          11         pwl(0 0 5p 0u)
L02        11         2          5p
L03        5          6          5p
L04        3          4          5p
K01        L04        L03        0.6
R01        2          3          0.5
R02        3          0          0.075
R03        6          0          0.2
.ends NEURON

.subckt SYNAPSE 1 9
B01        7          2          jmitll
B02        0          7          jmitll
IB0        0          6          pwl(0 0 5p 100u)
L01        7          9          0.1p
L02        6          7          0.1p
R0L        9          0          1
X01 DCSFQ  1          2
.model jmitll jj(rtype=1, vg=2.8mV, cap=0.07pF, r0=160, rN=16, icrit=0.15mA)
.ends SYNAPSE

.subckt SYNEURON 1 2 4
X01 NEURON 1 2 3
X02 SYNAPSE 3 4
.ends SYNEURON

.subckt SPLITTER 1 11 10
# Junctions
B01	2	0	 jmitll
B02	4	0	 jmitll
B03	5	0	 jmitll
B04	6	0	 jmitll
B05	7	0	 jmitll
B06	6	8	 jmitll2
B07	7	9	 jmitll2

# Inductors
L01	1	2	0.5p
L02	2	3	0.5p
L03	3	5	0.5p
L04	3	4	0.5p
L05	5	7	0.5p
L06	4	6	0.5p
L07	9	11	0.5p
L08	8	10	0.5p

# Bias Currents
I01	3	0	 pwl(0 0 5p 250u)
I02	9	0	 pwl(0 0 5p 175u)
I03	8	0	 pwl(0 0 5p 175u)

# Resistors
R0L1    11  0   1
R0L2    10  0   1
R0L     3   0   1
.model jmitll jj(rtype=1, vg=2.8mV, cap=0.07pF, r0=160, rN=16, icrit=0.2mA)
.model jmitll2 jj(rtype=1, vg=2.8mV, cap=0.07pF, r0=160, rN=16, icrit=0.1mA)
.ends SPLITTER
VIN1 1 0 pwl(0 0 1.7993190396890966e-12 0 6.799319039689096e-12 -0.00041 1.1799319039689097e-11 0 1.1995290054347746e-11 0 1.6995290054347745e-11 -0.00041 2.1995290054347744e-11 0 1.21933566802383e-11 0 1.71933566802383e-11 -0.00041 2.21933566802383e-11 0 1.2216049947050581e-11 0 1.721604994705058e-11 -0.00041 2.221604994705058e-11 0 1.7719478673441063e-11 0 2.2719478673441062e-11 -0.00041 2.771947867344106e-11 0 3.4018883020024916e-11 0 3.901888302002492e-11 -0.00041 4.401888302002492e-11 0 4.075471254669724e-11 0 4.575471254669724e-11 -0.00041 5.075471254669724e-11 0 4.830772612495115e-11 0 5.330772612495115e-11 -0.00041 5.830772612495115e-11 0 7.647558591570841e-11 0 8.14755859157084e-11 -0.00041 8.64755859157084e-11 0 1.3705311672013413e-10 0 1.4205311672013414e-10 -0.00041 1.4705311672013415e-10 0 1.6991739929907157e-10 0 1.7491739929907158e-10 -0.00041 1.7991739929907159e-10 0 1.699302768024198e-10 0 1.749302768024198e-10 -0.00041 1.799302768024198e-10 0 1.926212234450889e-10 0 1.976212234450889e-10 -0.00041 2.0262122344508891e-10 0 1.9334620029428782e-10 0 1.9834620029428783e-10 -0.00041 2.0334620029428783e-10 0 2.04040203315961e-10 0 2.09040203315961e-10 -0.00041 2.14040203315961e-10 0 2.1252953361140636e-10 0 2.1752953361140637e-10 -0.00041 2.2252953361140638e-10 0 2.4402862013879133e-10 0 2.490286201387913e-10 -0.00041 2.540286201387913e-10 0 2.475687205607238e-10 0 2.525687205607238e-10 -0.00041 2.5756872056072377e-10 0 2.5063983195700727e-10 0 2.5563983195700725e-10 -0.00041 2.6063983195700723e-10 0 2.655620260882675e-10 0 2.705620260882675e-10 -0.00041 2.7556202608826746e-10 0 2.6593206807612436e-10 0 2.7093206807612434e-10 -0.00041 2.759320680761243e-10 0 2.672853761982964e-10 0 2.722853761982964e-10 -0.00041 2.772853761982964e-10 0 2.7758735726482085e-10 0 2.8258735726482084e-10 -0.00041 2.875873572648208e-10 0 2.8533283944455284e-10 0 2.903328394445528e-10 -0.00041 2.953328394445528e-10 0 3.027096245449594e-10 0 3.0770962454495936e-10 -0.00041 3.1270962454495935e-10 0 3.0684632540330643e-10 0 3.118463254033064e-10 -0.00041 3.168463254033064e-10 0 3.1132843303678774e-10 0 3.163284330367877e-10 -0.00041 3.213284330367877e-10 0 3.298493565665907e-10 0 3.348493565665907e-10 -0.00041 3.398493565665907e-10 0 3.4710149266782083e-10 0 3.521014926678208e-10 -0.00041 3.571014926678208e-10 0 3.503360854033268e-10 0 3.5533608540332677e-10 -0.00041 3.6033608540332675e-10 0 3.524436996121097e-10 0 3.574436996121097e-10 -0.00041 3.6244369961210966e-10 0 3.646766392097995e-10 0 3.6967663920979946e-10 -0.00041 3.7467663920979944e-10 0 3.700598812425033e-10 0 3.7505988124250327e-10 -0.00041 3.8005988124250325e-10 0 3.786067321796769e-10 0 3.836067321796769e-10 -0.00041 3.886067321796769e-10 0 3.8909395428237495e-10 0 3.9409395428237493e-10 -0.00041 3.990939542823749e-10 0 4.0141566072135257e-10 0 4.0641566072135255e-10 -0.00041 4.1141566072135254e-10 0 4.306973538544832e-10 0 4.356973538544832e-10 -0.00041 4.4069735385448316e-10 0 4.322342414403646e-10 0 4.372342414403646e-10 -0.00041 4.422342414403646e-10 0 4.468922905922228e-10 0 4.518922905922228e-10 -0.00041 4.568922905922228e-10 0 4.581346658829153e-10 0 4.631346658829153e-10 -0.00041 4.681346658829153e-10 0 4.771151700662108e-10 0 4.821151700662108e-10 -0.00041 4.871151700662108e-10 0 4.831050898076729e-10 0 4.881050898076729e-10 -0.00041 4.931050898076729e-10 0 4.877919364508719e-10 0 4.927919364508718e-10 -0.00041 4.977919364508718e-10 0 4.959630096156475e-10 0 5.009630096156475e-10 -0.00041 5.059630096156475e-10 0 4.986077023991869e-10 0 5.036077023991869e-10 -0.00041 5.086077023991869e-10 0 5.060659272892391e-10 0 5.110659272892391e-10 -0.00041 5.160659272892391e-10 0 5.071265478490254e-10 0 5.121265478490254e-10 -0.00041 5.171265478490254e-10 0 5.235960217857288e-10 0 5.285960217857287e-10 -0.00041 5.335960217857287e-10 0 5.463884034615218e-10 0 5.513884034615217e-10 -0.00041 5.563884034615217e-10 0 5.519094282069008e-10 0 5.569094282069008e-10 -0.00041 5.619094282069008e-10 0 5.835367377340055e-10 0 5.885367377340055e-10 -0.00041 5.935367377340055e-10 0 5.846137640484929e-10 0 5.896137640484929e-10 -0.00041 5.946137640484929e-10 0 5.874091919557482e-10 0 5.924091919557481e-10 -0.00041 5.974091919557481e-10 0 5.903816787860724e-10 0 5.953816787860723e-10 -0.00041 6.003816787860723e-10 0 5.980172481553579e-10 0 6.030172481553579e-10 -0.00041 6.080172481553579e-10 0 6.073747007603512e-10 0 6.123747007603512e-10 -0.00041 6.173747007603512e-10 0 6.127341288681855e-10 0 6.177341288681855e-10 -0.00041 6.227341288681855e-10 0 6.139796692092081e-10 0 6.18979669209208e-10 -0.00041 6.23979669209208e-10 0 6.339595827749056e-10 0 6.389595827749056e-10 -0.00041 6.439595827749056e-10 0 6.389342219294891e-10 0 6.439342219294891e-10 -0.00041 6.489342219294891e-10 0 6.400699210760945e-10 0 6.450699210760944e-10 -0.00041 6.500699210760944e-10 0 6.47782285351472e-10 0 6.52782285351472e-10 -0.00041 6.57782285351472e-10 0 )
VIN2 2 0 pwl(0 0 2.5390895707701274e-11 0 3.039089570770127e-11 0.00041 3.5390895707701275e-11 0 7.096379645503918e-11 0 7.596379645503917e-11 0.00041 8.096379645503917e-11 0 7.184909425258028e-11 0 7.684909425258028e-11 0.00041 8.184909425258027e-11 0 7.195052627848367e-11 0 7.695052627848366e-11 0.00041 8.195052627848366e-11 0 9.654918497977447e-11 0 1.0154918497977447e-10 0.00041 1.0654918497977446e-10 0 1.6940258319556595e-10 0 1.7440258319556595e-10 0.00041 1.7940258319556596e-10 0 1.995097000193286e-10 0 2.045097000193286e-10 0.00041 2.0950970001932862e-10 0 2.3326938192213023e-10 0 2.382693819221302e-10 0.00041 2.432693819221302e-10 0 3.591711794717271e-10 0 3.641711794717271e-10 0.00041 3.6917117947172706e-10 0 6.299343853399937e-10 0 6.349343853399937e-10 0.00041 6.399343853399936e-10 0 7.768277695943353e-10 0 7.818277695943353e-10 0.00041 7.868277695943353e-10 0 )
VIN3 3 0 pwl(0 0 2.8996595198445468e-11 0 3.399659519844547e-11 0.00041 3.899659519844547e-11 0 7.997645027173869e-11 0 8.497645027173869e-11 0.00041 8.997645027173868e-11 0 8.096678340119145e-11 0 8.596678340119145e-11 0.00041 9.096678340119145e-11 0 8.108024973525287e-11 0 8.608024973525286e-11 0.00041 9.108024973525286e-11 0 1.0859739336720527e-10 0 1.1359739336720526e-10 0.00041 1.1859739336720527e-10 0 1.9009441510012448e-10 0 1.950944151001245e-10 0.00041 2.000944151001245e-10 0 2.2377356273348607e-10 0 2.2877356273348607e-10 0.00041 2.3377356273348606e-10 0 2.6153863062475567e-10 0 2.6653863062475565e-10 0.00041 2.7153863062475563e-10 0 4.023779295785419e-10 0 4.073779295785419e-10 0.00041 4.1237792957854187e-10 0 7.052655836006704e-10 0 7.102655836006704e-10 0.00041 7.152655836006704e-10 0 )
X6 SPLITTER 1 6 7
X7 SPLITTER 7 8 9
X8 SPLITTER 2 10 11
X9 SPLITTER 11 12 13
X10 SPLITTER 3 14 15
X11 SPLITTER 15 16 17
X12 SPLITTER 4 18 19
X13 SPLITTER 19 20 21
VIN22 22 0 pwl(0 0 5p 118.092u)
X23 SYNEURON 22 6 23
VIN24 24 0 pwl(0 0 5p 119.946u)
X25 SYNEURON 24 10 25
VIN26 14 0 pwl(0 0 5p 125.011u)
X27 SYNEURON 14 5 27
VIN28 18 0 pwl(0 0 5p 119.384u)
X29 SYNEURON 18 5 29
X30 SYNEURON 5 5 30
X31 CONFLU 5 5 30 23 31
X32 CONFLU 5 5 31 25 32
X33 CONFLU 5 5 32 27 33
X34 CONFLU 5 5 33 29 34
VIN35 8 0 pwl(0 0 5p 116.614u)
X36 SYNEURON 8 5 36
VIN37 12 0 pwl(0 0 5p 121.489u)
X38 SYNEURON 12 5 38
VIN39 39 0 pwl(0 0 5p 121.432u)
X40 SYNEURON 39 16 40
VIN41 20 0 pwl(0 0 5p 121.028u)
X42 SYNEURON 20 5 42
X43 SYNEURON 5 5 43
X44 CONFLU 5 5 43 36 44
X45 CONFLU 5 5 44 38 45
X46 CONFLU 5 5 45 40 46
X47 CONFLU 5 5 46 42 47
VIN48 48 0 pwl(0 0 5p 117.487u)
X49 SYNEURON 48 9 49
VIN50 13 0 pwl(0 0 5p 119.259u)
X51 SYNEURON 13 5 51
VIN52 52 0 pwl(0 0 5p 123.401u)
X53 SYNEURON 52 17 53
VIN54 54 0 pwl(0 0 5p 124.001u)
X55 SYNEURON 54 21 55
X56 SYNEURON 5 5 56
X57 CONFLU 5 5 56 49 57
X58 CONFLU 5 5 57 51 58
X59 CONFLU 5 5 58 53 59
X60 CONFLU 5 5 59 55 60
.temp 4.2
    .model jmitll jj(rtype=1, vg=2.8mV, cap=0.07pF, r0=160, rN=16, icrit=0.15mA)
    .tran 0.008 220p 0 0.008p
    .print NODEV 34 0
.print NODEV 47 0
.print NODEV 60 0
.end
