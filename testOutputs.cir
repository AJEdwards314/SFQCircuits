.subckt DCSFQ 2 17
B01        5          3          jj1     area=1.32
B02        5          6          jj1     area=1
B03        9          10         jj1     area=1.5
B04        13         14         jj1     area=1.96
B05        15         16         jj1     area=1.96
IB01       0          8          pwl(0 0 5p 162.5u)
IB02       0          12         pwl(0 0 5p 260u)
L01        2          1          0.848p
L02        0          1          7.712p
L03        1          3          1.778p
L04        5          7          0.543p
L05        7          9          3.149p
L06        9          11         1.323p
L07        11         13         1.095p
L08        13         15         2.951p
L09        15         17         1.63p
LP01       0          6          0.398p
LP02       0          10         0.211p
LP03       0          14         0.276p
LP04       0          16         0.224p
LPR01      7          8          0.915p
LPR02      11         12         0.307p
LRB01      4          5          1p
LRB02      18         6          1p
LRB03      19         10         1p
LRB04      20         14         1p
LRB05      21         16         1p
RB01       3          4          8.56
RB02       18         5          11.30
RB03       19         9          7.53
RB04       20         13         5.77
RB05       21         15         5.77
.model jj1 jj(rtype=1, vg=2.8mV, cap=0.07pF, r0=160, rN=16, icrit=0.15mA)
.ends DCSFQ

.subckt CONFLUSMALL 1 2 6

B01 8 0  jmitll
B02 9 0  jmitll
B05 5 0  jmitll
L01 8 3  2p
L02 9 4  2p
L03 3 5  2p
L04 4 5  2p
L05 1 8  2p
L06 2 9  2p
L07 5 6  2p

I01 0 3 pwl(0 0 5p 100u)
I02 0 4 pwl(0 0 5p 150u)

.model jmitll jj(rtype=1, vg=2.8mV, cap=0.07pF, r0=160, rN=16, icrit=0.15mA)
.ends CONFLUSMALL

.subckt CONFLU 1 2 3 4 7
X01 CONFLUSMALL 1 2 5
X02 CONFLUSMALL 3 4 6
X03 CONFLUSMALL 5 6 7
.model jmitll jj(rtype=1, vg=2.8mV, cap=0.07pF, r0=160, rN=16, icrit=0.15mA)
.ends CONFLU

.subckt LIF_Neuron 1 2 3 4  5 6 7 8  106

# Excitatory Branch

R10 11 0 0.25
R11 22 0 0.25
R12 33 0 0.25
R13 44 0 0.25
L10 1 11 150p
L11 2 22 150p
L12 3 33 150p
L13 4 44 150p
B10 1 0 jmitll
B11 2 0 jmitll
B12 3 0 jmitll
B13 4 0 jmitll

# Inhibitory Branch

R20 55 0 0.25
R21 66 0 0.25
R22 77 0 0.25
R23 88 0 0.25
L20 5 55 150p
L21 6 66 150p
L22 7 77 150p
L23 8 88 150p

# Center Branch

R01 105 104 0.25
R02 100 0   0.25
L30 104 103 150p
L31 103 102 150p
L32 102 101 150p
L33 101 100 150p
L34 105 106 0.2p
B01 105 0 jmitll

K01 L30 L10 0.43
K02 L31 L11 0.43
K03 L32 L12 0.43
K04 L33 L13 0.43

K05 L30 L20 -0.43
K06 L31 L21 -0.43
K07 L32 L22 -0.43
K08 L33 L23 -0.43

I01 0 105 DC 150u

.model jmitll jj(rtype=1, vg=2.8mV, cap=0.07pF, r0=160, rN=16, icrit=0.1mA)
.ends LIF_Neuron

.subckt SYNAPSE 1 6 9
B01        7          1          jmitll
B02        0          7          jmitll
L01        7          9          0.1p
L02        6          7          0.1p
.model jmitll jj(rtype=1, vg=2.8mV, cap=0.07pF, r0=160, rN=16, icrit=0.15mA)
.ends SYNAPSE

.subckt SPLITTER 1 6 7
* Splitting Circuit w/ Output Buffers
# Junctions
B01	2	0	 jmitll
B02	4	0	 jmitll2
B03	5	0	 jmitll2

# Inductors
L01	1	2	1.2p
L02	2	3	1.2p
L03	3	5	1.6p
L04	3	4	1.6p
L05	5	7	1.6p
L06	4	6	1.6p

# Bias Currents
I01 0 3	 pwl(0 0 .5p .3m)

.model jmitll jj(rtype=1, vg=2.8mV, cap=0.07pF, r0=160, rN=16, icrit=0.35mA)
.model jmitll2 jj(rtype=1, vg=2.8mV, cap=0.07pF, r0=160, rN=16, icrit=0.25mA)
.ends SPLITTER

.subckt jtl 4 5
B01        3          7          jmod     area=2.16
B02        6          8          jmod     area=2.16
IB01       0          1          pwl(0      0 5p 280u)
L01        4          3          2p
L02        3          2          2.425p
L03        2          6          2.425p
L04        6          5          2.031p
LP01       0          7          0.086p
LP02       0          8          0.096p
LPR01      2          1          0.278p
LRB01      7          9          0.086p
LRB02      8          10         0.086p
RB01       9          3          5.23
RB02       10         6          5.23
.model jmod jj(rtype=1, vg=2.8mV, cap=0.07pF, r0=160, rN=16, icrit=0.15mA)
.ends jtl
