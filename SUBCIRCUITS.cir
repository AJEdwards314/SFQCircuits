# This .cir file contains all of the circuits utilized by the NSC lab.
# The purpose of this file is to execute each circuit and visualize the outputs in order to ensure
#   proper functionality before using in our main / larger circuits
# The circuits included are:
# Number        /   Name        /   Maker
#   1           JTL             NSC
#   2           DCSFQ           Repository
#   3           P2N             Research paper
#   4           Con. Buffer     NSC
#   5           P&N Sorter      NSC
#   6           JTLR            Repository
#   7           JTLRN           Repositroy w/ edits
#   8           P2N_Buffer      NSC
#   9           Synapse         NSC

# 1 - JTL ---------------------------------->

.subckt JTL 1 5

B01     2   0   jmitll  area=2.16
B02     4   0   jmitll  area=2.16
LO1     1   2   2p
L02     2   3   2p
LO3     3   4   2p
L04     4   5   2p

IB01    0   3   pwl(0 0 105p 0u)

.model jmitll jj(rtype=1, vg=2.8mV, cap=0.07pF, r0=160, rN=16, icrit=0.15mA)
.ends JTL

# 2 - DCSFQ_REPO ---------------------------------------------------->

.subckt DCSFQ 2 17

B01        5          3          jjmitll     area=1.32
B02        5          6          jjmitll     area=1
B03        9          10         jjmitll     area=1.5
B04        13         14         jjmitll     area=1.96
B05        15         16         jjmitll     area=1.96
L01        2          1          0.848p
L02        0          1          7.712p
L03        1          3          1.778p
L04        5          7          0.543p
L05        7          9          3.149p
L06        9          11         1.323p
L07        11         13         1.095p
L08        13         15         2.951p
L09        15         17         1.63p
LP01       0          6          0.398p
LP02       0          10         0.211p
LP03       0          14         0.276p
LP04       0          16         0.224p
LPR01      7          8          0.915p
LPR02      11         12         0.307p
LRB01      4          5          1p
LRB02      18         6          1p
LRB03      19         10         1p
LRB04      20         14         1p
LRB05      21         16         1p
RB01       3          4          8.56
RB02       18         5          11.30
RB03       19         9          7.53
RB04       20         13         5.77
RB05       21         15         5.77

IB01       0          8          pwl(0 0 5p 162.5u)
IB02       0          12         pwl(0 0 5p 260u)

.model jjmitll jj(rtype=1, vg=2.8mV, cap=0.07pF, r0=160, rN=16, icrit=0.15mA)
.ends DCSFQ

# 3 - P2N_PAPER ------------------------------------------------------>

.subckt P2N 1 13

B01 2 0  jmitll area=1.6667
B02 4 0  jmitll area=1.6667
B03 6 0  jmitll area=0.85
B04 8 0  jmitll area=1.6667
B05 10 0 jmitll area=1.6667
B06 12 0 jmitll area=1.6667
L01 1 2 2p
L02 2 3 2p
L03 3 4 2p
L04 7 8 2p
L05 8 9 2p
L06 9 10 2p
L07 10 11 2p
L08 11 12 2p
L09 12 13 2p
LM1 4 5 6p
LM2 6 7 6p
K01 LM1 LM2 -0.8
R01 5 0 1

IB1 0 3  pwl(0 0 5p 350u)
IB2 0 7  pwl(0 0 5p -315u)
IB3 0 11 pwl(0 0 5p -350u)

.model jmitll jj(rtype=1, vg=2.8mV, cap=0.07pF, r0=160, rN=16, icrit=0.15mA)
.ends P2N

# 4 - Confluence ------------------------------------------------->

.subckt CONFLU 1 2 6

B01 8 0  jmitll
B02 9 0  jmitll
B05 5 0  jmitll
L01 8 3  2p
L02 9 4  2p
L03 3 5  2p
L04 4 5  2p
L05 1 8  2p
L06 2 9  2p
L07 5 6  2p

I01 0 3 pwl(0 0 5p 0u)
I02 0 4 pwl(0 0 5p 0u)

.model jmitll jj(rtype=1, vg=2.8mV, cap=0.07pF, r0=160, rN=16, icrit=0.15mA)
.ends CONFLU

# 5 - P&N Sorter ------------------------------------------------>

.subckt P&N 1 4 6

B01 2 0 jmitll
B02 4 0 jmitll
B03 6 0 jmitll
L01 1 2 2p
L02 2 3 2p
L03 2 5 2p
L04 3 4 2p
L05 5 6 2p

I01 0 3 DC 700u
I02 0 5 DC -700u

.model jmitll jj(rtype=1, vg=2.8mV, cap=0.07pF, r0=160, rN=16, icrit=0.15mA)
.ends P&N

# 6 - JTL REPO -------------------------------------------------->

.subckt JTLR 4 5

B01        3          7          jmitll
B02        6          8          jmitll
L01        4          3          2p
L02        3          2          2.425p
L03        2          6          2.425p
L04        6          5          2.031p
LP01       0          7          0.086p
LP02       0          8          0.096p
LPR01      2          1          0.278p
LRB01      7          9          0.086p
LRB02      8          10         0.086p
RB01       9          3          5.23
RB02       10         6          5.23

IB01       0          1          pwl(0 0 5p 280u)

.model jmitll jj(rtype=1, vg=2.8mV, cap=0.07pF, r0=160, rN=16, icrit=0.15mA)
.ends JTLR

# 7 - JTL REPO w/ Modifications -------------------------------------------------->

.subckt JTLRN 4 5

B01        3          7          jmitll
B02        6          8          jmitll
L01        4          3          2p
L02        3          2          2.425p
L03        2          6          2.425p
L04        6          5          2.031p
LP01       0          7          0.086p
LP02       0          8          0.096p
LPR01      2          1          0.278p
LRB01      7          9          0.086p
LRB02      8          10         0.086p
RB01       9          3          5.23
RB02       10         6          5.23

IB01       0          1          pwl(0 0 5p -280u)

.model jmitll jj(rtype=1, vg=2.8mV, cap=0.07pF, r0=160, rN=16, icrit=0.15mA)
.ends JTLRN

# 8 - Buffer (maybe P2N) Book ---------------------------------------------->

.subckt P2N_BUFF 1 4

B01 2 0 jmitll
B02 2 3 jmitll
L01 1 2 1p
L02 3 4 1p

I01 0 3 pwl(0 0 5p -135u)

.model jmitll jj(rtype=1, vg=2.8mV, cap=0.07pF, r0=160, rN=16, icrit=0.15mA)
.ends BUFFER

# 9 - Synapse ------------------------------------------------------>

.subckt SYNAPSE 1 7

B01        7          1          jmitll
B02        0          7          jmitll
L01        7          9          0.1p
L02        6          7          0.1p

I01 0 6 pwl(0 0 5p 135u)

.model jmitll jj(rtype=1, vg=2.8mV, cap=0.07pF, r0=160, rN=16, icrit=0.15mA)
.ends SYNAPSE

# MAIN ------------------------------------------------>

# Input Voltages

VIN1 1 0 pwl({})
VIN2 5 0 pwl({})

# Subcircuits

X01 JTL 1 2
X02 DCSFQ 1 3
X03 P2N 1 4
X04 CONFLU 1 5 6
X05 P&N 1 7 8
X06 JTLR 1 9
X07 JTLRN 1 10
X08 P2N_BUFF 1 11
X09 SYNAPSE 1 12

RL1  2 0 2
RL2  3 0 2
RL3  4 0 2
RL4  6 0 2
RL5  7 0 2
RL6  8 0 2
RL7  9 0 2
RL8  10 0 2
RL9  11 0 2
RL10 12 0 2

# OUTPUTS ------------------------------------->

# These are the inputs

.print NODEV 1
.print NODEV 5

# These are the outputs (Voltage Only)

.print NODEV 2
.print NODEV 3
.print NODEV 4
.print NODEV 6
.print NODEV 7
.print NODEV 8
.print NODEV 9
.print NODEV 10
.print NODEV 11
.print NODEV 12

# Phase Outputs

.print NODEP 10
.print NODEP 6

# Temp, main JJ model, and transient setup

.temp 4.2
.model jmitll jj(rtype=1, vg=2.8mV, cap=0.07pF, r0=160, rN=16, icrit=0.15mA)
.tran 0.008p 1000p 0 0.008p
.end
