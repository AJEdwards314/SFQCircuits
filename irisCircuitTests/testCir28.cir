.subckt DCSFQ 2 17
B01        5          3          jj1     area=1.32
B02        5          6          jj1     area=1
B03        9          10         jj1     area=1.5
B04        13         14         jj1     area=1.96
B05        15         16         jj1     area=1.96
IB01       0          8          pwl(0 0 5p 162.5u)
IB02       0          12         pwl(0 0 5p 260u)
L01        2          1          0.848p
L02        0          1          7.712p
L03        1          3          1.778p
L04        5          7          0.543p
L05        7          9          3.149p
L06        9          11         1.323p
L07        11         13         1.095p
L08        13         15         2.951p
L09        15         17         1.63p
LP01       0          6          0.398p
LP02       0          10         0.211p
LP03       0          14         0.276p
LP04       0          16         0.224p
LPR01      7          8          0.915p
LPR02      11         12         0.307p
LRB01      4          5          1p
LRB02      18         6          1p
LRB03      19         10         1p
LRB04      20         14         1p
LRB05      21         16         1p
RB01       3          4          8.56
RB02       18         5          11.30
RB03       19         9          7.53
RB04       20         13         5.77
RB05       21         15         5.77
.model jj1 jj(rtype=1, vg=2.8mV, cap=0.07pF, r0=160, rN=16, icrit=0.15mA)
.ends DCSFQ

.subckt CONFLUSMALL 1 2 6

B01 8 0  jmitll
B02 9 0  jmitll
B05 5 0  jmitll
L01 8 3  2p
L02 9 4  2p
L03 3 5  2p
L04 4 5  2p
L05 1 8  2p
L06 2 9  2p
L07 5 6  2p

I01 0 3 pwl(0 0 5p 100u)
I02 0 4 pwl(0 0 5p 150u)

.model jmitll jj(rtype=1, vg=2.8mV, cap=0.07pF, r0=160, rN=16, icrit=0.15mA)
.ends CONFLUSMALL

.subckt CONFLU 1 2 3 4 7
X01 CONFLUSMALL 1 2 5
X02 CONFLUSMALL 3 4 6
X03 CONFLUSMALL 5 6 7
.model jmitll jj(rtype=1, vg=2.8mV, cap=0.07pF, r0=160, rN=16, icrit=0.15mA)
.ends CONFLU

.subckt LIF_Neuron 1 2 3 4  5 6 7 8  106

# Excitatory Branch

R10 11 0 0.25
R11 22 0 0.25
R12 33 0 0.25
R13 44 0 0.25
L10 1 11 150p
L11 2 22 150p
L12 3 33 150p
L13 4 44 150p
B10 1 0 jmitll
B11 2 0 jmitll
B12 3 0 jmitll
B13 4 0 jmitll

# Inhibitory Branch

R20 55 0 0.25
R21 66 0 0.25
R22 77 0 0.25
R23 88 0 0.25
L20 5 55 150p
L21 6 66 150p
L22 7 77 150p
L23 8 88 150p

# Center Branch

R01 105 104 0.25
R02 100 0   0.25
L30 104 103 150p
L31 103 102 150p
L32 102 101 150p
L33 101 100 150p
L34 105 106 0.2p
B01 105 0 jmitll

K01 L30 L10 0.43
K02 L31 L11 0.43
K03 L32 L12 0.43
K04 L33 L13 0.43

K05 L30 L20 -0.43
K06 L31 L21 -0.43
K07 L32 L22 -0.43
K08 L33 L23 -0.43

I01 0 105 DC 150u

.model jmitll jj(rtype=1, vg=2.8mV, cap=0.07pF, r0=160, rN=16, icrit=0.1mA)
.ends LIF_Neuron

.subckt SYNAPSE 1 6 9
B01        7          1          jmitll
B02        0          7          jmitll
L01        7          9          0.1p
L02        6          7          0.1p
.model jmitll jj(rtype=1, vg=2.8mV, cap=0.07pF, r0=160, rN=16, icrit=0.15mA)
.ends SYNAPSE

.subckt SPLITTER 1 6 7
* Splitting Circuit w/ Output Buffers
# Junctions
B01	2	0	 jmitll
B02	4	0	 jmitll2
B03	5	0	 jmitll2

# Inductors
L01	1	2	1.2p
L02	2	3	1.2p
L03	3	5	1.6p
L04	3	4	1.6p
L05	5	7	1.6p
L06	4	6	1.6p

# Bias Currents
I01 0 3	 pwl(0 0 .5p .3m)

.model jmitll jj(rtype=1, vg=2.8mV, cap=0.07pF, r0=160, rN=16, icrit=0.35mA)
.model jmitll2 jj(rtype=1, vg=2.8mV, cap=0.07pF, r0=160, rN=16, icrit=0.25mA)
.ends SPLITTER

.subckt jtl 4 5
B01        3          7          jmod     area=2.16
B02        6          8          jmod     area=2.16
IB01       0          1          pwl(0      0 5p 280u)
L01        4          3          2p
L02        3          2          2.425p
L03        2          6          2.425p
L04        6          5          2.031p
LP01       0          7          0.086p
LP02       0          8          0.096p
LPR01      2          1          0.278p
LRB01      7          9          0.086p
LRB02      8          10         0.086p
RB01       9          3          5.23
RB02       10         6          5.23
.model jmod jj(rtype=1, vg=2.8mV, cap=0.07pF, r0=160, rN=16, icrit=0.15mA)
.ends jtl

VIN1 1 0 pwl(0 0 4.4394552317512766e-11 0 5.4394552317512764e-11 0.00021 6.439455231751276e-11 0 1.2596232043478194e-10 0 1.3596232043478193e-10 0.00021 1.4596232043478192e-10 0 1.4596232043478195e-10 0 1.5596232043478194e-10 0.00021 1.6596232043478193e-10 0 1.6596232043478193e-10 0 1.7596232043478192e-10 0.00021 1.8596232043478192e-10 0 1.8596232043478194e-10 0 1.9596232043478193e-10 0.00021 2.0596232043478192e-10 0 3.0215106416019927e-10 0 3.121510641601993e-10 0.00021 3.221510641601993e-10 0 3.560377003735778e-10 0 3.660377003735778e-10 0.00021 3.7603770037357784e-10 0 4.164618089996091e-10 0 4.264618089996091e-10 0.00021 4.364618089996091e-10 0 6.418046873256672e-10 0 6.518046873256671e-10 0.00021 6.618046873256671e-10 0 1.126424933761073e-09 0 1.136424933761073e-09 0.00021 1.1464249337610729e-09 0 1.3893391943925724e-09 0 1.3993391943925724e-09 0.00021 1.4093391943925724e-09 0 1.4093391943925724e-09 0 1.4193391943925723e-09 0.00021 1.4293391943925723e-09 0 1.5709697875607109e-09 0 1.5809697875607108e-09 0.00021 1.5909697875607108e-09 0 1.5909697875607108e-09 0 1.6009697875607108e-09 0.00021 1.6109697875607107e-09 0 1.6623216265276876e-09 0 1.6723216265276876e-09 0.00021 1.6823216265276875e-09 0 1.7302362688912506e-09 0 1.7402362688912505e-09 0.00021 1.7502362688912505e-09 0 1.98222896111033e-09 0 1.99222896111033e-09 0.00021 2.0022289611103303e-09 0 2.0105497644857897e-09 0 2.02054976448579e-09 0.00021 2.03054976448579e-09 0 2.0351186556560574e-09 0 2.0451186556560576e-09 0.00021 2.0551186556560578e-09 0 2.1544962087061392e-09 0 2.1644962087061394e-09 0.00021 2.1744962087061396e-09 0 2.174496208706139e-09 0 2.1844962087061393e-09 0.00021 2.1944962087061395e-09 0 2.194496208706139e-09 0 2.2044962087061392e-09 0.00021 2.2144962087061394e-09 0 2.250698858118566e-09 0 2.2606988581185663e-09 0.00021 2.2706988581185664e-09 0 2.312662715556422e-09 0 2.322662715556422e-09 0.00021 2.3326627155564224e-09 0 2.4516769963596743e-09 0 2.4616769963596745e-09 0.00021 2.4716769963596747e-09 0 2.4847706032264507e-09 0 2.494770603226451e-09 0.00021 2.504770603226451e-09 0 2.520627464294301e-09 0 2.5306274642943014e-09 0.00021 2.5406274642943015e-09 0 2.6687948525327246e-09 0 2.6787948525327248e-09 0.00021 2.688794852532725e-09 0 2.8068119413425655e-09 0 2.8168119413425657e-09 0.00021 2.826811941342566e-09 0 2.832688683226613e-09 0 2.8426886832266133e-09 0.00021 2.8526886832266135e-09 0 2.852688683226613e-09 0 2.8626886832266133e-09 0.00021 2.8726886832266134e-09 0 2.9474131136783947e-09 0 2.957413113678395e-09 0.00021 2.967413113678395e-09 0 2.990479049940025e-09 0 3.0004790499400253e-09 0.00021 3.0104790499400255e-09 0 3.058853857437414e-09 0 3.0688538574374144e-09 0.00021 3.0788538574374145e-09 0 3.1427516342589984e-09 0 3.1527516342589986e-09 0.00021 3.1627516342589988e-09 0 3.2413252857708194e-09 0 3.2513252857708196e-09 0.00021 3.2613252857708198e-09 0 3.4755788308358644e-09 0 3.4855788308358646e-09 0.00021 3.4955788308358648e-09 0 3.4955788308358644e-09 0 3.5055788308358645e-09 0.00021 3.5155788308358647e-09 0 3.6051383247377814e-09 0 3.6151383247377815e-09 0.00021 3.6251383247377817e-09 0 3.6950773270633214e-09 0 3.7050773270633216e-09 0.00021 3.7150773270633217e-09 0 3.846921360529686e-09 0 3.856921360529686e-09 0.00021 3.8669213605296855e-09 0 3.8948407184613825e-09 0 3.904840718461382e-09 0.00021 3.914840718461382e-09 0 3.932335491606974e-09 0 3.942335491606974e-09 0.00021 3.952335491606974e-09 0 3.997704076925179e-09 0 4.007704076925179e-09 0.00021 4.017704076925179e-09 0 4.0188616191934945e-09 0 4.028861619193494e-09 0.00021 4.038861619193494e-09 0 4.078527418313912e-09 0 4.088527418313912e-09 0.00021 4.098527418313912e-09 0 4.098527418313913e-09 0 4.1085274183139124e-09 0.00021 4.118527418313912e-09 0 4.2187681742858285e-09 0 4.228768174285828e-09 0.00021 4.238768174285828e-09 0 4.4011072276921725e-09 0 4.411107227692172e-09 0.00021 4.421107227692172e-09 0 4.445275425655205e-09 0 4.4552754256552045e-09 0.00021 4.465275425655204e-09 0 4.698293901872042e-09 0 4.708293901872042e-09 0.00021 4.718293901872042e-09 0 4.718293901872043e-09 0 4.7282939018720425e-09 0.00021 4.738293901872042e-09 0 4.738293901872043e-09 0 4.748293901872043e-09 0.00021 4.758293901872043e-09 0 4.7582939018720434e-09 0 4.768293901872043e-09 0.00021 4.778293901872043e-09 0 4.8141379852428616e-09 0 4.824137985242861e-09 0.00021 4.834137985242861e-09 0 4.888997606082808e-09 0 4.898997606082808e-09 0.00021 4.908997606082808e-09 0 4.931873030945483e-09 0 4.941873030945482e-09 0.00021 4.951873030945482e-09 0 4.951873030945483e-09 0 4.961873030945483e-09 0.00021 4.9718730309454825e-09 0 5.101676662199243e-09 0 5.111676662199243e-09 0.00021 5.121676662199243e-09 0 5.141473775435911e-09 0 5.151473775435911e-09 0.00021 5.161473775435911e-09 0 5.161473775435912e-09 0 5.1714737754359115e-09 0.00021 5.181473775435911e-09 0 5.212258282811774e-09 0 5.222258282811774e-09 0.00021 5.232258282811774e-09 0 5.2359782542183045e-09 0 5.245978254218304e-09 0.00021 5.255978254218304e-09 0 5.269252024227732e-09 0 5.279252024227732e-09 0.00021 5.289252024227732e-09 0 5.289401694308895e-09 0 5.299401694308895e-09 0.00021 5.3094016943088944e-09 0 5.330615007029308e-09 0 5.340615007029307e-09 0.00021 5.350615007029307e-09 0 5.410431379777227e-09 0 5.420431379777227e-09 0.00021 5.430431379777226e-09 0 5.430431379777227e-09 0 5.440431379777227e-09 0.00021 5.450431379777227e-09 0 5.5127797477683085e-09 0 5.522779747768308e-09 0.00021 5.532779747768308e-09 0 5.743187968788196e-09 0 5.753187968788196e-09 0.00021 5.763187968788195e-09 0 5.812367439166373e-09 0 5.822367439166373e-09 0.00021 5.832367439166373e-09 0 6.1081696540669405e-09 0 6.11816965406694e-09 0.00021 6.12816965406694e-09 0 6.148721427384691e-09 0 6.158721427384691e-09 0.00021 6.16872142738469e-09 0 6.25158924958503e-09 0 6.26158924958503e-09 0.00021 6.2715892495850296e-09 0 6.413095179802777e-09 0 6.423095179802777e-09 0.00021 6.433095179802777e-09 0 6.480774516838549e-09 0 6.4907745168385486e-09 0.00021 6.500774516838548e-09 0 6.540299697739744e-09 0 6.550299697739743e-09 0.00021 6.560299697739743e-09 0 6.5883574908315506e-09 0 6.59835749083155e-09 0.00021 6.60835749083155e-09 0 6.608357490831551e-09 0 6.618357490831551e-09 0.00021 6.6283574908315504e-09 0 6.950378393234098e-09 0 6.9603783932340975e-09 0.00021 6.970378393234097e-09 0 7.084004012071118e-09 0 7.094004012071118e-09 0.00021 7.104004012071118e-09 0 7.125758583497091e-09 0 7.135758583497091e-09 0.00021 7.145758583497091e-09 0 7.266161174611573e-09 0 7.276161174611573e-09 0.00021 7.286161174611573e-09 0 7.347354009546045e-09 0 7.3573540095460444e-09 0.00021 7.367354009546044e-09 0 7.367354009546045e-09 0 7.377354009546045e-09 0.00021 7.3873540095460445e-09 0 7.457943857529704e-09 0 7.467943857529703e-09 0.00021 7.477943857529703e-09 0 7.571037708466236e-09 0 7.581037708466236e-09 0.00021 7.591037708466235e-09 0 7.611449405231532e-09 0 7.621449405231532e-09 0.00021 7.631449405231532e-09 0 7.631449405231532e-09 0 7.641449405231532e-09 0.00021 7.651449405231531e-09 0 7.831124876327955e-09 0 7.841124876327954e-09 0.00021 7.851124876327954e-09 0 7.998107605279225e-09 0 8.008107605279225e-09 0.00021 8.018107605279224e-09 0 8.302470276236317e-09 0 8.312470276236317e-09 0.00021 8.322470276236316e-09 0 8.322470276236316e-09 0 8.332470276236316e-09 0.00021 8.342470276236316e-09 0 8.537333753040005e-09 0 8.547333753040005e-09 0.00021 8.557333753040004e-09 0 8.74887697074026e-09 0 8.758876970740259e-09 0.00021 8.768876970740259e-09 0 9.003708755962612e-09 0 9.013708755962612e-09 0.00021 9.023708755962612e-09 0 9.178798253991295e-09 0 9.188798253991295e-09 0.00021 9.198798253991295e-09 0 9.206477731790308e-09 0 9.216477731790308e-09 0.00021 9.226477731790307e-09 0 9.393830796493577e-09 0 9.403830796493576e-09 0.00021 9.413830796493576e-09 0 9.435138496739377e-09 0 9.445138496739377e-09 0.00021 9.455138496739377e-09 0 9.483881679811548e-09 0 9.493881679811548e-09 0.00021 9.503881679811548e-09 0 9.59889347206086e-09 0 9.608893472060859e-09 0.00021 9.618893472060859e-09 0 9.665959975840202e-09 0 9.675959975840202e-09 0.00021 9.685959975840202e-09 0 9.735117639110818e-09 0 9.745117639110818e-09 0.00021 9.755117639110818e-09 0 9.755117639110818e-09 0 9.765117639110818e-09 0.00021 9.775117639110818e-09 0 9.800308481854916e-09 0 9.810308481854915e-09 0.00021 9.820308481854915e-09 0 1.010229331349491e-08 0 1.011229331349491e-08 0.00021 1.012229331349491e-08 0 1.012229331349491e-08 0 1.013229331349491e-08 0.00021 1.0142293313494909e-08 0 1.0233673663619615e-08 0 1.0243673663619615e-08 0.00021 1.0253673663619615e-08 0 1.0253673663619615e-08 0 1.0263673663619614e-08 0.00021 1.0273673663619614e-08 0 1.0371728511880457e-08 0 1.0381728511880457e-08 0.00021 1.0391728511880457e-08 0 1.0420821564008178e-08 0 1.0430821564008177e-08 0.00021 1.0440821564008177e-08 0 1.0504951870882968e-08 0 1.0514951870882968e-08 0.00021 1.0524951870882967e-08 0 1.0524951870882967e-08 0 1.0534951870882967e-08 0.00021 1.0544951870882967e-08 0 1.0597147327511537e-08 0 1.0607147327511537e-08 0.00021 1.0617147327511537e-08 0 1.0617147327511537e-08 0 1.0627147327511536e-08 0.00021 1.0637147327511536e-08 0 1.0661826725760155e-08 0 1.0671826725760155e-08 0.00021 1.0681826725760155e-08 0 1.0732952724688293e-08 0 1.0742952724688293e-08 0.00021 1.0752952724688293e-08 0 1.0769392595017717e-08 0 1.0779392595017717e-08 0.00021 1.0789392595017717e-08 0 1.0789392595017717e-08 0 1.0799392595017717e-08 0.00021 1.0809392595017716e-08 0 1.0835489992965952e-08 0 1.0845489992965952e-08 0.00021 1.0855489992965951e-08 0 1.0859908771805266e-08 0 1.0869908771805266e-08 0.00021 1.0879908771805265e-08 0 1.0879908771805265e-08 0 1.0889908771805265e-08 0.00021 1.0899908771805265e-08 0 1.1068044988008543e-08 0 1.1078044988008542e-08 0.00021 1.1088044988008542e-08 0 1.1194129891522402e-08 0 1.1204129891522402e-08 0.00021 1.1214129891522402e-08 0 1.1257050839001137e-08 0 1.1267050839001136e-08 0.00021 1.1277050839001136e-08 0 1.142190060903704e-08 0 1.143190060903704e-08 0.00021 1.144190060903704e-08 0 1.14611283149227e-08 0 1.1471128314922699e-08 0.00021 1.1481128314922699e-08 0 1.1484032337464874e-08 0 1.1494032337464873e-08 0.00021 1.1504032337464873e-08 0 1.1518585598819043e-08 0 1.1528585598819043e-08 0.00021 1.1538585598819043e-08 0 1.1744801467908944e-08 0 1.1754801467908944e-08 0.00021 1.1764801467908944e-08 0 1.1779853877027752e-08 0 1.1789853877027752e-08 0.00021 1.1799853877027751e-08 0 1.1924075507092998e-08 0 1.1934075507092998e-08 0.00021 1.1944075507092998e-08 0 1.2013438793239803e-08 0 1.2023438793239802e-08 0.00021 1.2033438793239802e-08 0 1.2038693904815843e-08 0 1.2048693904815843e-08 0.00021 1.2058693904815843e-08 0 1.2083320054137179e-08 0 1.2093320054137178e-08 0.00021 1.2103320054137178e-08 0 1.2109557224669062e-08 0 1.2119557224669062e-08 0.00021 1.2129557224669062e-08 0 1.2132744600803558e-08 0 1.2142744600803558e-08 0.00021 1.2152744600803557e-08 0 1.2234695404874333e-08 0 1.2244695404874332e-08 0.00021 1.2254695404874332e-08 0 1.2367586767376568e-08 0 1.2377586767376568e-08 0.00021 1.2387586767376568e-08 0 1.2387586767376568e-08 0 1.2397586767376568e-08 0.00021 1.2407586767376567e-08 0 1.2546865296642773e-08 0 1.2556865296642773e-08 0.00021 1.2566865296642773e-08 0 1.2621277621717718e-08 0 1.2631277621717718e-08 0.00021 1.2641277621717718e-08 0 1.2798362703339305e-08 0 1.2808362703339304e-08 0.00021 1.2818362703339304e-08 0 1.2818362703339304e-08 0 1.2828362703339304e-08 0.00021 1.2838362703339304e-08 0 1.2912078743088317e-08 0 1.2922078743088316e-08 0.00021 1.2932078743088316e-08 0 1.2932078743088316e-08 0 1.2942078743088316e-08 0.00021 1.2952078743088316e-08 0 1.2993443442065994e-08 0 1.3003443442065994e-08 0.00021 1.3013443442065993e-08 0 1.3183979264434781e-08 0 1.3193979264434781e-08 0.00021 1.3203979264434781e-08 0 1.32644156858572e-08 0 1.32744156858572e-08 0.00021 1.32844156858572e-08 0 1.3553258895778028e-08 0 1.3563258895778027e-08 0.00021 1.3573258895778027e-08 0 1.3575158645866737e-08 0 1.3585158645866736e-08 0.00021 1.3595158645866736e-08 0 1.3890611577362658e-08 0 1.3900611577362658e-08 0.00021 1.3910611577362657e-08 0 1.3910611577362657e-08 0 1.3920611577362657e-08 0.00021 1.3930611577362657e-08 0 1.4082790743214425e-08 0 1.4092790743214425e-08 0.00021 1.4102790743214425e-08 0 1.4139364049670813e-08 0 1.4149364049670813e-08 0.00021 1.4159364049670813e-08 0 1.4203230186532402e-08 0 1.4213230186532401e-08 0.00021 1.4223230186532401e-08 0 1.4258559213189043e-08 0 1.4268559213189043e-08 0.00021 1.4278559213189043e-08 0 1.430947493335391e-08 0 1.4319474933353909e-08 0.00021 1.4329474933353909e-08 0 1.4536419766814551e-08 0 1.4546419766814551e-08 0.00021 1.455641976681455e-08 0 1.4632491865643448e-08 0 1.4642491865643448e-08 0.00021 1.4652491865643448e-08 0 1.4673920607148467e-08 0 1.4683920607148467e-08 0.00021 1.4693920607148467e-08 0 1.4697424079440168e-08 0 1.4707424079440168e-08 0.00021 1.4717424079440168e-08 0 1.4717424079440168e-08 0 1.4727424079440167e-08 0.00021 1.4737424079440167e-08 0 1.490911903410714e-08 0 1.4919119034107143e-08 0.00021 1.4929119034107144e-08 0 1.5118641750683875e-08 0 1.5128641750683877e-08 0.00021 1.5138641750683878e-08 0 1.5173392004635545e-08 0 1.5183392004635547e-08 0.00021 1.5193392004635548e-08 0 1.5250320073680763e-08 0 1.5260320073680764e-08 0.00021 1.5270320073680765e-08 0 1.540671596313662e-08 0 1.541671596313662e-08 0.00021 1.5426715963136622e-08 0 1.5547903575259945e-08 0 1.5557903575259946e-08 0.00021 1.5567903575259948e-08 0 1.5619931437165683e-08 0 1.5629931437165684e-08 0.00021 1.5639931437165686e-08 0 1.565077694165721e-08 0 1.566077694165721e-08 0.00021 1.567077694165721e-08 0 1.570658376235203e-08 0 1.571658376235203e-08 0.00021 1.572658376235203e-08 0 1.5902198698016227e-08 0 1.5912198698016228e-08 0.00021 1.592219869801623e-08 0 1.6036036982394186e-08 0 1.6046036982394187e-08 0.00021 1.605603698239419e-08 0 1.6056036982394185e-08 0 1.6066036982394187e-08 0.00021 1.6076036982394188e-08 0 1.6096297394775957e-08 0 1.6106297394775958e-08 0.00021 1.611629739477596e-08 0 1.6422548480867667e-08 0 1.643254848086767e-08 0.00021 1.644254848086767e-08 0 1.6468569325539913e-08 0 1.6478569325539914e-08 0.00021 1.6488569325539916e-08 0 1.6568440808000684e-08 0 1.6578440808000686e-08 0.00021 1.6588440808000687e-08 0 1.6622118976448805e-08 0 1.6632118976448806e-08 0.00021 1.6642118976448807e-08 0 1.6670203815980063e-08 0 1.6680203815980064e-08 0.00021 1.6690203815980065e-08 0 1.670863712315012e-08 0 1.6718637123150123e-08 0.00021 1.6728637123150124e-08 0 1.6758021544734085e-08 0 1.6768021544734087e-08 0.00021 1.6778021544734088e-08 0 1.6943305101564134e-08 0 1.6953305101564135e-08 0.00021 1.6963305101564136e-08 0 1.7033066444977743e-08 0 1.7043066444977744e-08 0.00021 1.7053066444977746e-08 0 1.7053066444977743e-08 0 1.7063066444977744e-08 0.00021 1.7073066444977745e-08 0 1.7126365223409504e-08 0 1.7136365223409505e-08 0.00021 1.7146365223409507e-08 0 1.7220027305604385e-08 0 1.7230027305604387e-08 0.00021 1.7240027305604388e-08 0 1.729195845919646e-08 0 1.730195845919646e-08 0.00021 1.7311958459196462e-08 0 1.7392288942339057e-08 0 1.7402288942339058e-08 0.00021 1.741228894233906e-08 0 1.7449674244956382e-08 0 1.7459674244956384e-08 0.00021 1.7469674244956385e-08 0 1.7550805668615668e-08 0 1.756080566861567e-08 0.00021 1.757080566861567e-08 0 1.758601605734109e-08 0 1.7596016057341092e-08 0.00021 1.7606016057341094e-08 0 1.761676227725649e-08 0 1.7626762277256492e-08 0.00021 1.7636762277256493e-08 0 1.773749681516652e-08 0 1.774749681516652e-08 0.00021 1.7757496815166523e-08 0 1.7872975260812184e-08 0 1.7882975260812185e-08 0.00021 1.7892975260812187e-08 0 1.7892975260812183e-08 0 1.7902975260812185e-08 0.00021 1.7912975260812186e-08 0 1.7981201207026875e-08 0 1.7991201207026876e-08 0.00021 1.8001201207026878e-08 0 1.805700594356675e-08 0 1.8067005943566752e-08 0.00021 1.8077005943566753e-08 0 1.8113358461796142e-08 0 1.8123358461796144e-08 0.00021 1.8133358461796145e-08 0 1.8208927817742046e-08 0 1.8218927817742047e-08 0.00021 1.822892781774205e-08 0 1.824152468530601e-08 0 1.8251524685306013e-08 0.00021 1.8261524685306014e-08 0 1.831740307991001e-08 0 1.832740307991001e-08 0.00021 1.833740307991001e-08 0 1.8340480362016424e-08 0 1.8350480362016425e-08 0.00021 1.8360480362016427e-08 0 1.8360480362016423e-08 0 1.8370480362016425e-08 0.00021 1.8380480362016426e-08 0 1.8432384208491382e-08 0 1.8442384208491384e-08 0.00021 1.8452384208491385e-08 0 1.8457521397980573e-08 0 1.8467521397980574e-08 0.00021 1.8477521397980576e-08 0 1.854410546162736e-08 0 1.855410546162736e-08 0.00021 1.856410546162736e-08 0 1.881862313104823e-08 0 1.882862313104823e-08 0.00021 1.8838623131048232e-08 0 1.8959308035663363e-08 0 1.8969308035663364e-08 0.00021 1.8979308035663366e-08 0 1.8979308035663362e-08 0 1.8989308035663364e-08 0.00021 1.8999308035663365e-08 0 1.8999308035663362e-08 0 1.9009308035663363e-08 0.00021 1.9019308035663365e-08 0 1.901930803566336e-08 0 1.9029308035663363e-08 0.00021 1.9039308035663364e-08 0 1.9139558821506375e-08 0 1.9149558821506376e-08 0.00021 1.9159558821506377e-08 0 1.9252313837509593e-08 0 1.9262313837509595e-08 0.00021 1.9272313837509596e-08 0 1.9314767033336702e-08 0 1.9324767033336703e-08 0.00021 1.9334767033336705e-08 0 1.93347670333367e-08 0 1.9344767033336703e-08 0.00021 1.9354767033336704e-08 0 1.93547670333367e-08 0 1.9364767033336702e-08 0.00021 1.9374767033336704e-08 0 1.93747670333367e-08 0 1.9384767033336702e-08 0.00021 1.9394767033336703e-08 0 1.93947670333367e-08 0 1.94047670333367e-08 0.00021 1.9414767033336703e-08 0 1.943398744573463e-08 0 1.9443987445734632e-08 0.00021 1.9453987445734633e-08 0 1.950028624825292e-08 0 1.9510286248252922e-08 0.00021 1.9520286248252923e-08 0 1.9548687710913887e-08 0 1.955868771091389e-08 0.00021 1.956868771091389e-08 0 1.9579874777246234e-08 0 1.9589874777246235e-08 0.00021 1.9599874777246237e-08 0 1.9644013191300956e-08 0 1.9654013191300958e-08 0.00021 1.966401319130096e-08 0 1.968544261330643e-08 0 1.9695442613306432e-08 0.00021 1.9705442613306433e-08 0 1.976705879602209e-08 0 1.9777058796022093e-08 0.00021 1.9787058796022094e-08 0 1.9812167375563367e-08 0 1.9822167375563368e-08 0.00021 1.983216737556337e-08 0 1.9995961715128672e-08 0 2.0005961715128673e-08 0.00021 2.0015961715128675e-08 0 2.001596171512867e-08 0 2.0025961715128673e-08 0.00021 2.0035961715128674e-08 0 2.0134260701570252e-08 0 2.0144260701570254e-08 0.00021 2.0154260701570255e-08 0 2.0511149469115134e-08 0 2.0521149469115136e-08 0.00021 2.0531149469115137e-08 0 2.0574978581089818e-08 0 2.058497858108982e-08 0.00021 2.059497858108982e-08 0 2.0741896514793887e-08 0 2.0751896514793888e-08 0.00021 2.076189651479389e-08 0 2.0890360366208434e-08 0 2.0900360366208435e-08 0.00021 2.0910360366208437e-08 0 2.1117527194661246e-08 0 2.1127527194661248e-08 0.00021 2.113752719466125e-08 0 2.126965859794755e-08 0 2.1279658597947553e-08 0.00021 2.1289658597947554e-08 0 2.128965859794755e-08 0 2.1299658597947552e-08 0.00021 2.1309658597947554e-08 0 2.1411091456732045e-08 0 2.1421091456732046e-08 0.00021 2.1431091456732048e-08 0 2.147512913264568e-08 0 2.1485129132645682e-08 0.00021 2.1495129132645683e-08 0 2.1530937455778184e-08 0 2.1540937455778186e-08 0.00021 2.1550937455778187e-08 0 2.1695244579676922e-08 0 2.1705244579676923e-08 0.00021 2.1715244579676925e-08 0 2.1860996273266333e-08 0 2.1870996273266335e-08 0.00021 2.1880996273266336e-08 0 2.1882376208067626e-08 0 2.1892376208067627e-08 0.00021 2.190237620806763e-08 0 2.1924545356847596e-08 0 2.1934545356847597e-08 0.00021 2.19445453568476e-08 0 2.2145056475656906e-08 0 2.2155056475656907e-08 0.00021 2.216505647565691e-08 0 2.2222966818347497e-08 0 2.22329668183475e-08 0.00021 2.22429668183475e-08 0 2.2242966818347497e-08 0 2.2252966818347498e-08 0.00021 2.22629668183475e-08 0 2.279527560211488e-08 0 2.2805275602114882e-08 0.00021 2.2815275602114884e-08 0 2.281527560211488e-08 0 2.2825275602114882e-08 0.00021 2.2835275602114883e-08 0 2.284406462624226e-08 0 2.285406462624226e-08 0.00021 2.286406462624226e-08 0 2.2872922133124294e-08 0 2.2882922133124296e-08 0.00021 2.2892922133124297e-08 0 2.2934900291908754e-08 0 2.2944900291908755e-08 0.00021 2.2954900291908757e-08 0 2.2971190798290723e-08 0 2.2981190798290724e-08 0.00021 2.2991190798290726e-08 0 2.3017776336362808e-08 0 2.302777633636281e-08 0.00021 2.303777633636281e-08 0 2.3037776336362808e-08 0 2.304777633636281e-08 0.00021 2.305777633636281e-08 0 2.3057776336362807e-08 0 2.306777633636281e-08 0.00021 2.307777633636281e-08 0 2.328050031542468e-08 0 2.3290500315424683e-08 0.00021 2.3300500315424684e-08 0 2.330050031542468e-08 0 2.3310500315424682e-08 0.00021 2.3320500315424684e-08 0 2.344157999146092e-08 0 2.345157999146092e-08 0.00021 2.3461579991460922e-08 0 2.372630199885141e-08 0 2.3736301998851412e-08 0.00021 2.3746301998851413e-08 0 2.382719326271307e-08 0 2.383719326271307e-08 0.00021 2.3847193262713072e-08 0 2.40295263382816e-08 0 2.4039526338281603e-08 0.00021 2.4049526338281604e-08 0 2.411454953596287e-08 0 2.412454953596287e-08 0.00021 2.4134549535962873e-08 0 2.4231246747923835e-08 0 2.4241246747923836e-08 0.00021 2.4251246747923838e-08 0 2.4408321696339704e-08 0 2.4418321696339705e-08 0.00021 2.4428321696339706e-08 0 2.4558801394906683e-08 0 2.4568801394906684e-08 0.00021 2.4578801394906686e-08 0 2.466723240401899e-08 0 2.467723240401899e-08 0.00021 2.4687232404018992e-08 0 2.478572180292062e-08 0 2.4795721802920622e-08 0.00021 2.4805721802920624e-08 0 2.4876924502470566e-08 0 2.4886924502470567e-08 0.00021 2.489692450247057e-08 0 2.5089649500454722e-08 0 2.5099649500454723e-08 0.00021 2.5109649500454725e-08 0 2.514476287784295e-08 0 2.5154762877842953e-08 0.00021 2.5164762877842954e-08 0 2.516476287784295e-08 0 2.5174762877842952e-08 0.00021 2.5184762877842954e-08 0 2.5251397136551783e-08 0 2.5261397136551784e-08 0.00021 2.5271397136551785e-08 0 2.5426050851512473e-08 0 2.5436050851512474e-08 0.00021 2.5446050851512475e-08 0 2.5446050851512472e-08 0 2.5456050851512474e-08 0.00021 2.5466050851512475e-08 0 2.5489660833304263e-08 0 2.5499660833304265e-08 0.00021 2.5509660833304266e-08 0 2.551817170323976e-08 0 2.552817170323976e-08 0.00021 2.5538171703239762e-08 0 2.5571808098179967e-08 0 2.5581808098179968e-08 0.00021 2.559180809817997e-08 0 2.5598074837370564e-08 0 2.5608074837370565e-08 0.00021 2.5618074837370566e-08 0 2.5707367895844777e-08 0 2.571736789584478e-08 0.00021 2.572736789584478e-08 0 2.582051902418724e-08 0 2.583051902418724e-08 0.00021 2.5840519024187243e-08 0 2.584051902418724e-08 0 2.585051902418724e-08 0.00021 2.5860519024187242e-08 0 2.597115920829549e-08 0 2.598115920829549e-08 0.00021 2.5991159208295492e-08 0 2.607477655178563e-08 0 2.608477655178563e-08 0.00021 2.6094776551785632e-08 0 2.6232566209955094e-08 0 2.6242566209955095e-08 0.00021 2.6252566209955096e-08 0 2.6488608361632492e-08 0 2.6498608361632493e-08 0.00021 2.6508608361632495e-08 0 2.6516387862826245e-08 0 2.6526387862826247e-08 0.00021 2.6536387862826248e-08 0 2.6536387862826245e-08 0 2.6546387862826246e-08 0.00021 2.6556387862826248e-08 0 2.6569304665745873e-08 0 2.6579304665745874e-08 0.00021 2.6589304665745875e-08 0 2.6708187489583326e-08 0 2.6718187489583328e-08 0.00021 2.672818748958333e-08 0 2.6787267101735634e-08 0 2.6797267101735636e-08 0.00021 2.6807267101735637e-08 0 2.693441299858195e-08 0 2.694441299858195e-08 0.00021 2.695441299858195e-08 0 2.6954412998581948e-08 0 2.696441299858195e-08 0.00021 2.697441299858195e-08 0 2.7601216236415845e-08 0 2.7611216236415847e-08 0.00021 2.7621216236415848e-08 0 2.7621216236415845e-08 0 2.7631216236415846e-08 0.00021 2.7641216236415848e-08 0 2.7667168922038816e-08 0 2.7677168922038817e-08 0.00021 2.768716892203882e-08 0 2.774993995721396e-08 0 2.7759939957213963e-08 0.00021 2.7769939957213964e-08 0 2.7795463651222932e-08 0 2.7805463651222933e-08 0.00021 2.7815463651222935e-08 0 2.7897815854936165e-08 0 2.7907815854936166e-08 0.00021 2.7917815854936168e-08 0 2.793378510589939e-08 0 2.794378510589939e-08 0.00021 2.7953785105899392e-08 0 2.796694415913917e-08 0 2.7976944159139172e-08 0.00021 2.7986944159139173e-08 0 2.809297028329924e-08 0 2.8102970283299242e-08 0.00021 2.8112970283299244e-08 0 2.8207879614550463e-08 0 2.8217879614550464e-08 0.00021 2.8227879614550465e-08 0 2.8248424944819098e-08 0 2.82584249448191e-08 0.00021 2.82684249448191e-08 0 2.8268424944819098e-08 0 2.82784249448191e-08 0.00021 2.82884249448191e-08 0 2.8334855103513e-08 0 2.8344855103513e-08 0.00021 2.8354855103513003e-08 0 2.8396281703463703e-08 0 2.8406281703463705e-08 0.00021 2.8416281703463706e-08 0 2.8440273610768912e-08 0 2.8450273610768913e-08 0.00021 2.8460273610768915e-08 0 2.8493860527115408e-08 0 2.850386052711541e-08 0.00021 2.851386052711541e-08 0 2.8513860527115407e-08 0 2.852386052711541e-08 0.00021 2.853386052711541e-08 0 2.8551400374668206e-08 0 2.8561400374668208e-08 0.00021 2.857140037466821e-08 0 2.8716451759055852e-08 0 2.8726451759055854e-08 0.00021 2.8736451759055855e-08 0 2.8736451759055852e-08 0 2.8746451759055853e-08 0.00021 2.8756451759055855e-08 0 2.875645175905585e-08 0 2.8766451759055853e-08 0.00021 2.8776451759055854e-08 0 2.877645175905585e-08 0 2.8786451759055852e-08 0.00021 2.8796451759055854e-08 0 2.8827073191726858e-08 0 2.883707319172686e-08 0.00021 2.884707319172686e-08 0 2.8902603004600597e-08 0 2.8912603004600598e-08 0.00021 2.89226030046006e-08 0 2.894685911757949e-08 0 2.8956859117579493e-08 0.00021 2.8966859117579494e-08 0 2.896685911757949e-08 0 2.8976859117579492e-08 0.00021 2.8986859117579494e-08 0 2.898685911757949e-08 0 2.8996859117579492e-08 0.00021 2.9006859117579493e-08 0 2.905961572370647e-08 0 2.906961572370647e-08 0.00021 2.907961572370647e-08 0 2.909374960354029e-08 0 2.910374960354029e-08 0.00021 2.911374960354029e-08 0 2.9195237730461e-08 0 2.9205237730461003e-08 0.00021 2.9215237730461004e-08 0 2.9392245707394697e-08 0 2.9402245707394698e-08 0.00021 2.94122457073947e-08 0 2.9412245707394696e-08 0 2.9422245707394698e-08 0.00021 2.94322457073947e-08 0 2.9432245707394696e-08 0 2.9442245707394697e-08 0.00021 2.94522457073947e-08 0 2.9642496635485672e-08 0 2.9652496635485674e-08 0.00021 2.9662496635485675e-08 0 2.9662496635485672e-08 0 2.9672496635485673e-08 0.00021 2.9682496635485675e-08 0 2.9803864444581584e-08 0 2.981386444458158e-08 0.00021 2.982386444458158e-08 0 3.000580350347675e-08 0 3.001580350347675e-08 0.00021 3.002580350347675e-08 0 3.0025803503476755e-08 0 3.003580350347675e-08 0.00021 3.004580350347675e-08 0 3.02671989880124e-08 0 3.02771989880124e-08 0.00021 3.02871989880124e-08 0 3.0300354900402376e-08 0 3.0310354900402374e-08 0.00021 3.032035490040237e-08 0 3.032342338096275e-08 0 3.0333423380962746e-08 0.00021 3.0343423380962744e-08 0 3.034342338096275e-08 0 3.035342338096275e-08 0.00021 3.036342338096275e-08 0 3.039790164213314e-08 0 3.040790164213314e-08 0.00021 3.0417901642133136e-08 0 3.049049821151655e-08 0 3.050049821151655e-08 0.00021 3.051049821151655e-08 0 3.0636028376054444e-08 0 3.064602837605444e-08 0.00021 3.065602837605444e-08 0 3.070075412617762e-08 0 3.071075412617762e-08 0.00021 3.0720754126177616e-08 0 3.0787390290801024e-08 0 3.079739029080102e-08 0.00021 3.080739029080102e-08 0 3.089453299813261e-08 0 3.090453299813261e-08 0.00021 3.0914532998132606e-08 0 3.096831959137251e-08 0 3.097831959137251e-08 0.00021 3.098831959137251e-08 0 3.0988319591372515e-08 0 3.099831959137251e-08 0.00021 3.100831959137251e-08 0 3.100831959137252e-08 0 3.1018319591372516e-08 0.00021 3.1028319591372514e-08 0 3.102831959137252e-08 0 3.103831959137252e-08 0.00021 3.1048319591372517e-08 0 3.1123944836004734e-08 0 3.113394483600473e-08 0.00021 3.114394483600473e-08 0 3.1143944836004737e-08 0 3.1153944836004735e-08 0.00021 3.116394483600473e-08 0 3.124896746897759e-08 0 3.125896746897759e-08 0.00021 3.1268967468977585e-08 0 3.126896746897759e-08 0 3.127896746897759e-08 0.00021 3.128896746897759e-08 0 3.1288967468977595e-08 0 3.129896746897759e-08 0.00021 3.130896746897759e-08 0 3.131871745196494e-08 0 3.1328717451964937e-08 0.00021 3.1338717451964935e-08 0 3.138981460260215e-08 0 3.1399814602602145e-08 0.00021 3.140981460260214e-08 0 3.14714371472001e-08 0 3.14814371472001e-08 0.00021 3.1491437147200096e-08 0 3.1522554844663055e-08 0 3.1532554844663054e-08 0.00021 3.154255484466305e-08 0 3.173938388825487e-08 0 3.1749383888254866e-08 0.00021 3.1759383888254864e-08 0 3.176606950529458e-08 0 3.177606950529458e-08 0.00021 3.1786069505294576e-08 0 3.1845753545948545e-08 0 3.185575354594854e-08 0.00021 3.186575354594854e-08 0 3.186797819316316e-08 0 3.187797819316316e-08 0.00021 3.188797819316316e-08 0 3.191411108200881e-08 0 3.192411108200881e-08 0.00021 3.193411108200881e-08 0 3.1934111082008816e-08 0 3.1944111082008814e-08 0.00021 3.195411108200881e-08 0 3.195411108200882e-08 0 3.1964111082008817e-08 0.00021 3.1974111082008815e-08 0 3.2113749566370395e-08 0 3.212374956637039e-08 0.00021 3.213374956637039e-08 0 3.213403931475441e-08 0 3.214403931475441e-08 0.00021 3.2154039314754406e-08 0 3.233142560599118e-08 0 3.234142560599118e-08 0.00021 3.2351425605991176e-08 0 3.244974211183595e-08 0 3.245974211183595e-08 0.00021 3.2469742111835946e-08 0 3.248584899265455e-08 0 3.249584899265455e-08 0.00021 3.2505848992654545e-08 0 3.2527714229519115e-08 0 3.253771422951911e-08 0.00021 3.254771422951911e-08 0 3.26289792695051e-08 0 3.26389792695051e-08 0.00021 3.26489792695051e-08 0 3.2680124532694215e-08 0 3.269012453269421e-08 0.00021 3.270012453269421e-08 0 3.283228484267128e-08 0 3.284228484267128e-08 0.00021 3.2852284842671277e-08 0 3.303148378410205e-08 0 3.304148378410205e-08 0.00021 3.3051483784102047e-08 0 3.3073854307888756e-08 0 3.3083854307888754e-08 0.00021 3.309385430788875e-08 0 3.313141738873292e-08 0 3.3141417388732916e-08 0.00021 3.3151417388732914e-08 0 3.329021237315972e-08 0 3.330021237315972e-08 0.00021 3.3310212373159716e-08 0 3.33523033439257e-08 0 3.3362303343925696e-08 0.00021 3.3372303343925694e-08 0 3.3433867954682795e-08 0 3.3443867954682794e-08 0.00021 3.345386795468279e-08 0 3.34538679546828e-08 0 3.3463867954682796e-08 0.00021 3.3473867954682794e-08 0 3.356463754624062e-08 0 3.357463754624062e-08 0.00021 3.3584637546240615e-08 0 3.378494700154068e-08 0 3.379494700154068e-08 0.00021 3.380494700154068e-08 0 3.3804947001540684e-08 0 3.381494700154068e-08 0.00021 3.382494700154068e-08 0 3.409682106003092e-08 0 3.410682106003092e-08 0.00021 3.411682106003092e-08 0 3.4116821060030925e-08 0 3.4126821060030923e-08 0.00021 3.413682106003092e-08 0 3.413682106003093e-08 0 3.4146821060030926e-08 0.00021 3.4156821060030924e-08 0 3.419671364567591e-08 0 3.4206713645675905e-08 0.00021 3.4216713645675904e-08 0 3.4515987752842634e-08 0 3.452598775284263e-08 0.00021 3.453598775284263e-08 0 3.458053510568756e-08 0 3.459053510568756e-08 0.00021 3.460053510568756e-08 0 3.46335152105811e-08 0 3.4643515210581096e-08 0.00021 3.4653515210581094e-08 0 3.46535152105811e-08 0 3.46635152105811e-08 0.00021 3.46735152105811e-08 0 3.470834045079055e-08 0 3.471834045079055e-08 0.00021 3.4728340450790545e-08 0 3.491070189533128e-08 0 3.4920701895331275e-08 0.00021 3.493070189533127e-08 0 3.497252299132096e-08 0 3.4982522991320956e-08 0.00021 3.4992522991320954e-08 0 3.499252299132096e-08 0 3.500252299132096e-08 0.00021 3.501252299132096e-08 0 3.531615830887819e-08 0 3.5326158308878186e-08 0.00021 3.5336158308878185e-08 0 3.544387845923752e-08 0 3.5453878459237516e-08 0.00021 3.5463878459237514e-08 0 3.5595213392895234e-08 0 3.560521339289523e-08 0.00021 3.561521339289523e-08 0 3.5810149581036496e-08 0 3.5820149581036495e-08 0.00021 3.583014958103649e-08 0 3.595280226708243e-08 0 3.596280226708243e-08 0.00021 3.597280226708243e-08 0 3.603678212100977e-08 0 3.604678212100977e-08 0.00021 3.605678212100977e-08 0 3.609774430996495e-08 0 3.610774430996495e-08 0.00021 3.611774430996495e-08 0 3.6117744309964955e-08 0 3.612774430996495e-08 0.00021 3.613774430996495e-08 0 3.659355092491145e-08 0 3.660355092491145e-08 0.00021 3.661355092491145e-08 0 3.6613550924911454e-08 0 3.662355092491145e-08 0.00021 3.663355092491145e-08 0 3.6705570266560104e-08 0 3.67155702665601e-08 0.00021 3.67255702665601e-08 0 3.6729539978984316e-08 0 3.6739539978984314e-08 0.00021 3.674953997898431e-08 0 3.679798990176477e-08 0 3.680798990176477e-08 0.00021 3.681798990176477e-08 0 3.689072673480749e-08 0 3.690072673480749e-08 0.00021 3.6910726734807485e-08 0 3.691192261019028e-08 0 3.692192261019028e-08 0.00021 3.693192261019028e-08 0 3.700589832203443e-08 0 3.701589832203443e-08 0.00021 3.7025898322034426e-08 0 3.7082281026259644e-08 0 3.709228102625964e-08 0.00021 3.710228102625964e-08 0 3.7173969976091115e-08 0 3.718396997609111e-08 0.00021 3.719396997609111e-08 0 3.724041412966061e-08 0 3.7250414129660606e-08 0.00021 3.7260414129660604e-08 0 3.733932863616953e-08 0 3.7349328636169526e-08 0.00021 3.7359328636169524e-08 0 3.7371389184671797e-08 0 3.7381389184671795e-08 0.00021 3.739138918467179e-08 0 3.759948851337613e-08 0 3.760948851337613e-08 0.00021 3.7619488513376125e-08 0 3.7654623764362165e-08 0 3.7664623764362163e-08 0.00021 3.767462376436216e-08 0 3.768460053082417e-08 0 3.7694600530824165e-08 0.00021 3.7704600530824163e-08 0 3.770460053082417e-08 0 3.771460053082417e-08 0.00021 3.7724600530824166e-08 0 3.774861620808061e-08 0 3.775861620808061e-08 0.00021 3.776861620808061e-08 0 3.778108242505417e-08 0 3.7791082425054166e-08 0.00021 3.7801082425054164e-08 0 3.781852575705778e-08 0 3.782852575705778e-08 0.00021 3.7838525757057775e-08 0 3.795838612720998e-08 0 3.796838612720998e-08 0.00021 3.797838612720998e-08 0 3.812074542078043e-08 0 3.8130745420780425e-08 0.00021 3.8140745420780424e-08 0 3.821114938155717e-08 0 3.822114938155717e-08 0.00021 3.8231149381557166e-08 0 3.828586985135314e-08 0 3.8295869851353135e-08 0.00021 3.830586985135313e-08 0 3.834427924400372e-08 0 3.8354279244003716e-08 0.00021 3.8364279244003714e-08 0 3.84636438894104e-08 0 3.8473643889410396e-08 0.00021 3.8483643889410394e-08 0 3.84836438894104e-08 0 3.84936438894104e-08 0.00021 3.8503643889410397e-08 0 3.850894054441413e-08 0 3.851894054441413e-08 0.00021 3.852894054441413e-08 0 3.8528940544414136e-08 0 3.8538940544414134e-08 0.00021 3.854894054441413e-08 0 3.859578167073169e-08 0 3.860578167073169e-08 0.00021 3.861578167073169e-08 0 3.865949913034866e-08 0 3.866949913034866e-08 0.00021 3.867949913034866e-08 0 3.86954540113851e-08 0 3.8705454011385096e-08 0.00021 3.8715454011385094e-08 0 3.8749076979872743e-08 0 3.875907697987274e-08 0.00021 3.876907697987274e-08 0 3.8774277319385994e-08 0 3.878427731938599e-08 0.00021 3.879427731938599e-08 0 3.882583049701102e-08 0 3.883583049701102e-08 0.00021 3.8845830497011016e-08 0 3.884583049701102e-08 0 3.885583049701102e-08 0.00021 3.886583049701102e-08 0 3.8865830497011025e-08 0 3.887583049701102e-08 0.00021 3.888583049701102e-08 0 3.899602014302151e-08 0 3.9006020143021505e-08 0.00021 3.90160201430215e-08 0 3.9136574308659016e-08 0 3.9146574308659014e-08 0.00021 3.915657430865901e-08 0 3.915657430865902e-08 0 3.916657430865902e-08 0.00021 3.9176574308659015e-08 0 3.917657430865902e-08 0 3.918657430865902e-08 0.00021 3.919657430865902e-08 0 3.9231369933505724e-08 0 3.924136993350572e-08 0.00021 3.925136993350572e-08 0 3.937268446866788e-08 0 3.938268446866788e-08 0.00021 3.9392684468667875e-08 0 3.9560682346756506e-08 0 3.9570682346756504e-08 0.00021 3.95806823467565e-08 0 3.9583683659380084e-08 0 3.959368365938008e-08 0.00021 3.960368365938008e-08 0 3.960368365938009e-08 0 3.9613683659380085e-08 0.00021 3.962368365938008e-08 0 3.9699752062428974e-08 0 3.970975206242897e-08 0.00021 3.971975206242897e-08 0 3.982149272993797e-08 0 3.983149272993797e-08 0.00021 3.9841492729937965e-08 0 3.984796278603819e-08 0 3.985796278603819e-08 0.00021 3.986796278603819e-08 0 3.9867962786038195e-08 0 3.9877962786038193e-08 0.00021 3.988796278603819e-08 0 3.996935571007495e-08 0 3.997935571007495e-08 0.00021 3.9989355710074945e-08 0 3.998935571007495e-08 0 3.999935571007495e-08 0.00021 4.000935571007495e-08 0 4.0009355710074954e-08 0 4.001935571007495e-08 0.00021 4.002935571007495e-08 0 4.0118442880663065e-08 0 4.012844288066306e-08 0.00021 4.013844288066306e-08 0 4.039879272541424e-08 0 4.040879272541424e-08 0.00021 4.0418792725414236e-08 0 4.051641965505377e-08 0 4.052641965505377e-08 0.00021 4.053641965505377e-08 0 4.0536419655053775e-08 0 4.054641965505377e-08 0.00021 4.055641965505377e-08 0 4.055641965505378e-08 0 4.0566419655053775e-08 0.00021 4.0576419655053774e-08 0 4.0749443114479867e-08 0 4.0759443114479865e-08 0.00021 4.076944311447986e-08 0 4.081601650417184e-08 0 4.082601650417184e-08 0.00021 4.083601650417184e-08 0 4.0907833931874e-08 0 4.0917833931873997e-08 0.00021 4.0927833931873995e-08 0 4.099862587233562e-08 0 4.100862587233562e-08 0.00021 4.1018625872335616e-08 0 4.1095179962373e-08 0 4.1105179962373e-08 0.00021 4.1115179962372996e-08 0 4.1126715472473906e-08 0 4.1136715472473904e-08 0.00021 4.11467154724739e-08 0 4.1186569700972e-08 0 4.1196569700971995e-08 0.00021 4.120656970097199e-08 0 4.126792143247924e-08 0 4.127792143247924e-08 0.00021 4.128792143247924e-08 0 4.13153338102403e-08 0 4.1325333810240296e-08 0.00021 4.1335333810240294e-08 0 4.1427020422645655e-08 0 4.143702042264565e-08 0.00021 4.144702042264565e-08 0 4.1546958382702814e-08 0 4.155695838270281e-08 0.00021 4.156695838270281e-08 0 4.161602420095891e-08 0 4.162602420095891e-08 0.00021 4.163602420095891e-08 0 4.169749444619623e-08 0 4.170749444619623e-08 0.00021 4.1717494446196225e-08 0 4.1721174998999045e-08 0 4.173117499899904e-08 0.00021 4.174117499899904e-08 0 4.178502349988242e-08 0 4.179502349988242e-08 0.00021 4.1805023499882417e-08 0 4.180502349988242e-08 0 4.181502349988242e-08 0.00021 4.182502349988242e-08 0 4.182958262280391e-08 0 4.1839582622803906e-08 0.00021 4.1849582622803904e-08 0 4.201147579951395e-08 0 4.202147579951395e-08 0.00021 4.2031475799513946e-08 0 4.2170512311950784e-08 0 4.218051231195078e-08 0.00021 4.219051231195078e-08 0 4.231293638018725e-08 0 4.2322936380187245e-08 0.00021 4.233293638018724e-08 0 4.233293638018725e-08 0 4.234293638018725e-08 0.00021 4.2352936380187246e-08 0 4.2525283523807166e-08 0 4.2535283523807164e-08 0.00021 4.254528352380716e-08 0 4.258300409271484e-08 0 4.259300409271484e-08 0.00021 4.260300409271484e-08 0 4.2622095562089525e-08 0 4.263209556208952e-08 0.00021 4.264209556208952e-08 0 4.264209556208953e-08 0 4.2652095562089526e-08 0.00021 4.2662095562089524e-08 0 4.276967833796175e-08 0 4.2779678337961745e-08 0.00021 4.278967833796174e-08 0 4.278967833796175e-08 0 4.279967833796175e-08 0.00021 4.2809678337961746e-08 0 4.285847946552161e-08 0 4.2868479465521606e-08 0.00021 4.2878479465521604e-08 0 4.2908704793910914e-08 0 4.291870479391091e-08 0.00021 4.292870479391091e-08 0 4.312571709355704e-08 0 4.313571709355704e-08 0.00021 4.314571709355704e-08 0 4.319764800878967e-08 0 4.3207648008789667e-08 0.00021 4.3217648008789665e-08 0 4.328405030212724e-08 0 4.3294050302127235e-08 0.00021 4.3304050302127234e-08 0 4.331625326616859e-08 0 4.332625326616859e-08 0.00021 4.3336253266168586e-08 0 4.334215872441455e-08 0 4.3352158724414546e-08 0.00021 4.3362158724414544e-08 0 4.343631720411612e-08 0 4.3446317204116116e-08 0.00021 4.3456317204116114e-08 0 4.354673252290604e-08 0 4.355673252290604e-08 0.00021 4.356673252290604e-08 0 4.359036639169507e-08 0 4.360036639169507e-08 0.00021 4.361036639169507e-08 0 4.378087040678419e-08 0 4.379087040678419e-08 0.00021 4.3800870406784186e-08 0 4.383775550183302e-08 0 4.3847755501833015e-08 0.00021 4.3857755501833014e-08 0 4.385775550183302e-08 0 4.386775550183302e-08 0.00021 4.3877755501833016e-08 0 4.3918351546881515e-08 0 4.392835154688151e-08 0.00021 4.393835154688151e-08 0 4.3950489254116905e-08 0 4.3960489254116904e-08 0.00021 4.39704892541169e-08 0 4.397048925411691e-08 0 4.3980489254116906e-08 0.00021 4.3990489254116905e-08 0 4.399048925411691e-08 0 4.400048925411691e-08 0.00021 4.401048925411691e-08 0 4.4010489254116914e-08 0 4.402048925411691e-08 0.00021 4.403048925411691e-08 0 4.413442560577106e-08 0 4.414442560577106e-08 0.00021 4.4154425605771057e-08 0 4.418792558100547e-08 0 4.419792558100547e-08 0.00021 4.420792558100547e-08 0 4.42083630325314e-08 0 4.42183630325314e-08 0.00021 4.4228363032531396e-08 0 4.4408779525356744e-08 0 4.441877952535674e-08 0.00021 4.442877952535674e-08 0 4.4456012848807986e-08 0 4.4466012848807984e-08 0.00021 4.447601284880798e-08 0 4.4517002140608305e-08 0 4.45270021406083e-08 0.00021 4.45370021406083e-08 0 4.4548899194855583e-08 0 4.455889919485558e-08 0.00021 4.456889919485558e-08 0 4.4571800602223405e-08 0 4.45818006022234e-08 0.00021 4.45918006022234e-08 0 4.4608304179381033e-08 0 4.461830417938103e-08 0.00021 4.462830417938103e-08 0 4.4659794122798216e-08 0 4.4669794122798214e-08 0.00021 4.467979412279821e-08 0 4.476652898776816e-08 0 4.477652898776816e-08 0.00021 4.478652898776816e-08 0 4.4786528987768164e-08 0 4.479652898776816e-08 0.00021 4.480652898776816e-08 0 4.4942104444560034e-08 0 4.495210444456003e-08 0.00021 4.496210444456003e-08 0 4.497477407948099e-08 0 4.498477407948099e-08 0.00021 4.499477407948099e-08 0 4.4994774079480993e-08 0 4.500477407948099e-08 0.00021 4.501477407948099e-08 0 4.503277896435554e-08 0 4.504277896435554e-08 0.00021 4.5052778964355536e-08 0 4.508952708968899e-08 0 4.509952708968899e-08 0.00021 4.5109527089688987e-08 0 4.510952708968899e-08 0 4.511952708968899e-08 0.00021 4.512952708968899e-08 0 4.515560096611828e-08 0 4.5165600966118276e-08 0.00021 4.5175600966118274e-08 0 4.522683446515342e-08 0 4.523683446515342e-08 0.00021 4.524683446515342e-08 0 4.5311655101469824e-08 0 4.532165510146982e-08 0.00021 4.533165510146982e-08 0 4.559052437656647e-08 0 4.560052437656647e-08 0.00021 4.561052437656647e-08 0 4.562379211204216e-08 0 4.563379211204216e-08 0.00021 4.564379211204216e-08 0 4.5643792112042165e-08 0 4.565379211204216e-08 0.00021 4.566379211204216e-08 0 4.566379211204217e-08 0 4.5673792112042166e-08 0.00021 4.5683792112042164e-08 0 4.568379211204217e-08 0 4.569379211204217e-08 0.00021 4.5703792112042167e-08 0 4.589251554479074e-08 0 4.590251554479074e-08 0.00021 4.5912515544790737e-08 0 4.593594950996605e-08 0 4.5945949509966046e-08 0.00021 4.5955949509966044e-08 0 4.596053469307276e-08 0 4.597053469307276e-08 0.00021 4.5980534693072755e-08 0 4.600213323674238e-08 0 4.6012133236742375e-08 0.00021 4.602213323674237e-08 0 4.618092624322811e-08 0 4.619092624322811e-08 0.00021 4.6200926243228106e-08 0 4.625348686003994e-08 0 4.626348686003994e-08 0.00021 4.6273486860039935e-08 0 4.6362013946443834e-08 0 4.637201394644383e-08 0.00021 4.638201394644383e-08 0 4.643235552823984e-08 0 4.644235552823984e-08 0.00021 4.645235552823984e-08 0 4.6452355528239844e-08 0 4.646235552823984e-08 0.00021 4.647235552823984e-08 0 4.647235552823985e-08 0 4.6482355528239845e-08 0.00021 4.649235552823984e-08 0 4.649235552823985e-08 0 4.650235552823985e-08 0.00021 4.6512355528239846e-08 0 4.651235552823985e-08 0 4.652235552823985e-08 0.00021 4.653235552823985e-08 0 4.6532355528239855e-08 0 4.6542355528239853e-08 0.00021 4.655235552823985e-08 0 4.655235552823986e-08 0 4.6562355528239856e-08 0.00021 4.6572355528239854e-08 0 4.6652871817940406e-08 0 4.6662871817940404e-08 0.00021 4.66728718179404e-08 0 4.667287181794041e-08 0 4.6682871817940407e-08 0.00021 4.6692871817940405e-08 0 4.669287181794041e-08 0 4.670287181794041e-08 0.00021 4.671287181794041e-08 0 4.676741200293328e-08 0 4.6777412002933277e-08 0.00021 4.6787412002933275e-08 0 4.6789853985665586e-08 0 4.6799853985665584e-08 0.00021 4.680985398566558e-08 0 4.686287751764781e-08 0 4.687287751764781e-08 0.00021 4.688287751764781e-08 0 4.6894940177622774e-08 0 4.690494017762277e-08 0.00021 4.691494017762277e-08 0 4.691494017762278e-08 0 4.6924940177622775e-08 0.00021 4.693494017762277e-08 0 4.730642168690115e-08 0 4.731642168690115e-08 0.00021 4.7326421686901145e-08 0 4.74390703062453e-08 0 4.74490703062453e-08 0.00021 4.7459070306245296e-08 0 4.749751965054721e-08 0 4.750751965054721e-08 0.00021 4.751751965054721e-08 0 4.765079921374756e-08 0 4.766079921374756e-08 0.00021 4.7670799213747556e-08 0 4.7844685892585616e-08 0 4.7854685892585614e-08 0.00021 4.786468589258561e-08 0 4.801028002040766e-08 0 4.8020280020407657e-08 0.00021 4.8030280020407655e-08 0 4.803028002040766e-08 0 4.804028002040766e-08 0.00021 4.805028002040766e-08 0 4.814671552443763e-08 0 4.815671552443763e-08 0.00021 4.8166715524437626e-08 0 4.825184874188632e-08 0 4.826184874188632e-08 0.00021 4.8271848741886315e-08 0 4.851548997024677e-08 0 4.852548997024677e-08 0.00021 4.8535489970246765e-08 0 4.853548997024677e-08 0 4.854548997024677e-08 0.00021 4.855548997024677e-08 0 4.8555489970246774e-08 0 4.856548997024677e-08 0.00021 4.857548997024677e-08 0 4.857548997024678e-08 0 4.8585489970246775e-08 0.00021 4.8595489970246773e-08 0 4.8599544896686983e-08 0 4.860954489668698e-08 0.00021 4.861954489668698e-08 0 4.878267498810859e-08 0 4.879267498810859e-08 0.00021 4.8802674988108586e-08 0 4.885426528230752e-08 0 4.886426528230752e-08 0.00021 4.887426528230752e-08 0 4.89043661505848e-08 0 4.89143661505848e-08 0.00021 4.8924366150584795e-08 0 4.892669371120921e-08 0 4.893669371120921e-08 0.00021 4.894669371120921e-08 0 4.904531628307835e-08 0 4.905531628307835e-08 0.00021 4.906531628307835e-08 0 4.91902539994701e-08 0 4.92002539994701e-08 0.00021 4.92102539994701e-08 0 4.925810727136022e-08 0 4.926810727136022e-08 0.00021 4.927810727136022e-08 0 4.9407362813707094e-08 0 4.941736281370709e-08 0.00021 4.942736281370709e-08 0 4.945874791181175e-08 0 4.946874791181175e-08 0.00021 4.947874791181175e-08 0 4.948581685198141e-08 0 4.949581685198141e-08 0.00021 4.950581685198141e-08 0 4.9505816851981414e-08 0 4.951581685198141e-08 0.00021 4.952581685198141e-08 0 4.952581685198142e-08 0 4.9535816851981415e-08 0.00021 4.954581685198141e-08 0 4.9611390568830956e-08 0 4.9621390568830955e-08 0.00021 4.963139056883095e-08 0 4.9671439361235696e-08 0 4.9681439361235694e-08 0.00021 4.969143936123569e-08 0 4.996417314302187e-08 0 4.997417314302187e-08 0.00021 4.998417314302187e-08 0 5.001123025094333e-08 0 5.0021230250943327e-08 0.00021 5.0031230250943325e-08 0 5.0033478137261466e-08 0 5.0043478137261464e-08 0.00021 5.005347813726146e-08 0 5.011256563222155e-08 0 5.012256563222155e-08 0.00021 5.013256563222155e-08 0 5.0132565632221554e-08 0 5.014256563222155e-08 0.00021 5.015256563222155e-08 0 5.0152565632221556e-08 0 5.0162565632221555e-08 0.00021 5.017256563222155e-08 0 5.019099018192831e-08 0 5.020099018192831e-08 0.00021 5.0210990181928306e-08 0 5.021099018192831e-08 0 5.022099018192831e-08 0.00021 5.023099018192831e-08 0 5.0230990181928316e-08 0 5.0240990181928314e-08 0.00021 5.025099018192831e-08 0 5.031391637372491e-08 0 5.0323916373724907e-08 0.00021 5.0333916373724905e-08 0 5.0352688633867273e-08 0 5.036268863386727e-08 0.00021 5.037268863386727e-08 0 5.0372688633867276e-08 0 5.0382688633867274e-08 0.00021 5.039268863386727e-08 0 5.063796521321994e-08 0 5.064796521321994e-08 0.00021 5.065796521321994e-08 0 5.0682196753691564e-08 0 5.069219675369156e-08 0.00021 5.070219675369156e-08 0 5.070953932028989e-08 0 5.071953932028989e-08 0.00021 5.0729539320289885e-08 0 5.0831540382019834e-08 0 5.084154038201983e-08 0.00021 5.085154038201983e-08 0 5.0978922669011845e-08 0 5.098892266901184e-08 0.00021 5.099892266901184e-08 0 5.108760681172842e-08 0 5.109760681172842e-08 0.00021 5.110760681172842e-08 0 5.1107606811728426e-08 0 5.1117606811728424e-08 0.00021 5.112760681172842e-08 0 5.1168086656788864e-08 0 5.117808665678886e-08 0.00021 5.118808665678886e-08 0 5.127133708479533e-08 0 5.128133708479533e-08 0.00021 5.129133708479533e-08 0 5.1291337084795334e-08 0 5.130133708479533e-08 0.00021 5.131133708479533e-08 0 5.1434893099335954e-08 0 5.144489309933595e-08 0.00021 5.145489309933595e-08 0 5.1472068857126186e-08 0 5.1482068857126184e-08 0.00021 5.149206885712618e-08 0 5.154395816348511e-08 0 5.155395816348511e-08 0.00021 5.1563958163485105e-08 0 5.158935957691013e-08 0 5.1599359576910127e-08 0.00021 5.1609359576910125e-08 0 5.160935957691013e-08 0 5.161935957691013e-08 0.00021 5.162935957691013e-08 0 5.165893140356275e-08 0 5.1668931403562745e-08 0.00021 5.1678931403562743e-08 0 5.167893140356275e-08 0 5.168893140356275e-08 0.00021 5.1698931403562746e-08 0 5.169893140356275e-08 0 5.170893140356275e-08 0.00021 5.171893140356275e-08 0 5.180431750513379e-08 0 5.181431750513379e-08 0.00021 5.182431750513379e-08 0 5.205423456359147e-08 0 5.206423456359147e-08 0.00021 5.2074234563591466e-08 0 5.219676445158891e-08 0 5.220676445158891e-08 0.00021 5.221676445158891e-08 0 5.227132240338426e-08 0 5.228132240338426e-08 0.00021 5.229132240338426e-08 0 5.2291322403384266e-08 0 5.2301322403384264e-08 0.00021 5.231132240338426e-08 0 5.239880979789299e-08 0 5.240880979789299e-08 0.00021 5.241880979789299e-08 0 5.2418809797892996e-08 0 5.2428809797892994e-08 0.00021 5.243880979789299e-08 0 5.244935891239526e-08 0 5.245935891239526e-08 0.00021 5.246935891239526e-08 0 5.2544655778771896e-08 0 5.2554655778771894e-08 0.00021 5.256465577877189e-08 0 5.264015046410512e-08 0 5.265015046410512e-08 0.00021 5.266015046410512e-08 0 5.2725627791167004e-08 0 5.2735627791167e-08 0.00021 5.2745627791167e-08 0 5.2989536469408114e-08 0 5.299953646940811e-08 0.00021 5.300953646940811e-08 0 5.323419536437595e-08 0 5.324419536437595e-08 0.00021 5.3254195364375946e-08 0 5.326116519561686e-08 0 5.327116519561686e-08 0.00021 5.3281165195616855e-08 0 5.342505359136364e-08 0 5.343505359136364e-08 0.00021 5.3445053591363636e-08 0 5.348642166163099e-08 0 5.349642166163099e-08 0.00021 5.350642166163099e-08 0 5.3506421661630996e-08 0 5.3516421661630994e-08 0.00021 5.352642166163099e-08 0 5.3561726947568054e-08 0 5.357172694756805e-08 0.00021 5.358172694756805e-08 0 5.3627743050907993e-08 0 5.363774305090799e-08 0.00021 5.364774305090799e-08 0 5.3655957008929676e-08 0 5.3665957008929675e-08 0.00021 5.367595700892967e-08 0 5.388430162361375e-08 0 5.3894301623613746e-08 0.00021 5.3904301623613744e-08 0 5.4014138878186694e-08 0 5.402413887818669e-08 0.00021 5.403413887818669e-08 0 5.40341388781867e-08 0 5.4044138878186695e-08 0.00021 5.405413887818669e-08 0 5.40541388781867e-08 0 5.40641388781867e-08 0.00021 5.4074138878186696e-08 0 5.4083257619266087e-08 0 5.4093257619266085e-08 0.00021 5.410325761926608e-08 0 5.411885523545922e-08 0 5.4128855235459216e-08 0.00021 5.4138855235459214e-08 0 5.422203002999275e-08 0 5.423203002999275e-08 0.00021 5.424203002999275e-08 0 5.4242030029992755e-08 0 5.425203002999275e-08 0.00021 5.426203002999275e-08 0 5.4618672926099644e-08 0 5.462867292609964e-08 0.00021 5.463867292609964e-08 0 5.465398835824713e-08 0 5.466398835824713e-08 0.00021 5.4673988358247126e-08 0 5.467398835824713e-08 0 5.468398835824713e-08 0.00021 5.469398835824713e-08 0 5.4734767943376693e-08 0 5.474476794337669e-08 0.00021 5.475476794337669e-08 0 5.478341140067168e-08 0 5.479341140067168e-08 0.00021 5.480341140067168e-08 0 5.4803411400671684e-08 0 5.481341140067168e-08 0.00021 5.482341140067168e-08 0 5.482489502557558e-08 0 5.4834895025575575e-08 0.00021 5.484489502557557e-08 0 5.4850633366234955e-08 0 5.4860633366234954e-08 0.00021 5.487063336623495e-08 0 5.500289950786108e-08 0 5.501289950786108e-08 0.00021 5.5022899507861076e-08 0 5.503894638471706e-08 0 5.504894638471706e-08 0.00021 5.505894638471706e-08 0 5.5275065505466807e-08 0 5.5285065505466805e-08 0.00021 5.52950655054668e-08 0 5.529506550546681e-08 0 5.530506550546681e-08 0.00021 5.5315065505466806e-08 0 5.531506550546681e-08 0 5.532506550546681e-08 0.00021 5.533506550546681e-08 0 5.5335065505466815e-08 0 5.534506550546681e-08 0.00021 5.535506550546681e-08 0 5.5368402963616106e-08 0 5.5378402963616104e-08 0.00021 5.53884029636161e-08 0 5.538840296361611e-08 0 5.539840296361611e-08 0.00021 5.5408402963616105e-08 0 5.556432115261462e-08 0 5.5574321152614616e-08 0.00021 5.5584321152614614e-08 0 5.5641858100681774e-08 0 5.565185810068177e-08 0.00021 5.566185810068177e-08 0 5.566185810068178e-08 0 5.5671858100681775e-08 0.00021 5.5681858100681774e-08 0 5.5687069044004235e-08 0 5.569706904400423e-08 0.00021 5.570706904400423e-08 0 5.58141861028897e-08 0 5.58241861028897e-08 0.00021 5.5834186102889696e-08 0 5.592830193739758e-08 0 5.593830193739758e-08 0.00021 5.594830193739758e-08 0 5.5972880305533985e-08 0 5.598288030553398e-08 0.00021 5.599288030553398e-08 0 5.599481111327042e-08 0 5.600481111327042e-08 0.00021 5.601481111327042e-08 0 5.603538841774066e-08 0 5.6045388417740656e-08 0.00021 5.6055388417740655e-08 0 5.622047754447551e-08 0 5.623047754447551e-08 0.00021 5.624047754447551e-08 0 5.6320769701974136e-08 0 5.6330769701974134e-08 0.00021 5.634076970197413e-08 0 5.634076970197414e-08 0 5.6350769701974137e-08 0.00021 5.6360769701974135e-08 0 5.636076970197414e-08 0 5.637076970197414e-08 0.00021 5.638076970197414e-08 0 5.6380769701974144e-08 0 5.639076970197414e-08 0.00021 5.640076970197414e-08 0 5.654093542034143e-08 0 5.655093542034143e-08 0.00021 5.6560935420341425e-08 0 5.66718655375174e-08 0 5.66818655375174e-08 0.00021 5.6691865537517396e-08 0 5.6729063070954774e-08 0 5.673906307095477e-08 0.00021 5.674906307095477e-08 0 5.678852509297524e-08 0 5.6798525092975235e-08 0.00021 5.6808525092975233e-08 0 5.6828064008839985e-08 0 5.683806400883998e-08 0.00021 5.684806400883998e-08 0 5.684806400883999e-08 0 5.6858064008839986e-08 0.00021 5.6868064008839984e-08 0 5.701418562718864e-08 0 5.702418562718864e-08 0.00021 5.703418562718864e-08 0 5.721593241877132e-08 0 5.722593241877132e-08 0.00021 5.723593241877132e-08 0 5.7294634278787336e-08 0 5.7304634278787334e-08 0.00021 5.731463427878733e-08 0 5.731463427878734e-08 0 5.732463427878734e-08 0.00021 5.7334634278787335e-08 0 5.73553662662811e-08 0 5.73653662662811e-08 0.00021 5.73753662662811e-08 0 5.738530705407987e-08 0 5.739530705407987e-08 0.00021 5.740530705407987e-08 0 5.7458718587544074e-08 0 5.746871858754407e-08 0.00021 5.747871858754407e-08 0 5.7501834138844934e-08 0 5.751183413884493e-08 0.00021 5.752183413884493e-08 0 5.771535141158652e-08 0 5.7725351411586516e-08 0.00021 5.7735351411586514e-08 0 5.7743042300079755e-08 0 5.775304230007975e-08 0.00021 5.776304230007975e-08 0 5.785061037401799e-08 0 5.7860610374017985e-08 0.00021 5.787061037401798e-08 0 5.79751006875424e-08 0 5.79851006875424e-08 0.00021 5.79951006875424e-08 0 5.8023902238423985e-08 0 5.803390223842398e-08 0.00021 5.804390223842398e-08 0 5.806980349190672e-08 0 5.8079803491906716e-08 0.00021 5.8089803491906714e-08 0 5.814998226911275e-08 0 5.815998226911275e-08 0.00021 5.816998226911275e-08 0 5.825263242160039e-08 0 5.826263242160039e-08 0.00021 5.827263242160039e-08 0 5.835175131666392e-08 0 5.8361751316663916e-08 0.00021 5.8371751316663914e-08 0 5.837175131666392e-08 0 5.838175131666392e-08 0.00021 5.839175131666392e-08 0 5.8466627939410824e-08 0 5.847662793941082e-08 0.00021 5.848662793941082e-08 0 5.86630213731112e-08 0 5.86730213731112e-08 0.00021 5.86830213731112e-08 0 5.879757347024531e-08 0 5.880757347024531e-08 0.00021 5.8817573470245307e-08 0 5.881757347024531e-08 0 5.882757347024531e-08 0.00021 5.883757347024531e-08 0 5.887931752466385e-08 0 5.8889317524663845e-08 0.00021 5.889931752466384e-08 0 5.889931752466385e-08 0 5.890931752466385e-08 0.00021 5.8919317524663846e-08 0 5.8995768822501463e-08 0 5.900576882250146e-08 0.00021 5.901576882250146e-08 0 5.9015768822501466e-08 0 5.9025768822501464e-08 0.00021 5.903576882250146e-08 0 5.907882261600735e-08 0 5.908882261600735e-08 0.00021 5.9098822616007346e-08 0 5.912193268721654e-08 0 5.913193268721654e-08 0.00021 5.914193268721654e-08 0 5.917440408314028e-08 0 5.918440408314028e-08 0.00021 5.919440408314028e-08 0 5.91959823573513e-08 0 5.92059823573513e-08 0.00021 5.9215982357351296e-08 0 5.922123335909929e-08 0 5.923123335909929e-08 0.00021 5.9241233359099286e-08 0 5.9363804818024774e-08 0 5.937380481802477e-08 0.00021 5.938380481802477e-08 0 5.9383804818024777e-08 0 5.9393804818024775e-08 0.00021 5.940380481802477e-08 0 5.951070147516883e-08 0 5.952070147516883e-08 0.00021 5.953070147516883e-08 0 5.9538732061128107e-08 0 5.9548732061128105e-08 0.00021 5.95587320611281e-08 0 5.96655730035703e-08 0 5.96755730035703e-08 0.00021 5.968557300357029e-08 0 5.968557300357029e-08 0 5.969557300357029e-08 0.00021 5.970557300357029e-08 0 5.989932433515835e-08 0 5.990932433515835e-08 0.00021 5.991932433515834e-08 0 5.993730048096821e-08 0 5.994730048096821e-08 0.00021 5.99573004809682e-08 0 5.996620556942994e-08 0 5.997620556942994e-08 0.00021 5.998620556942994e-08 0 6.00864110968538e-08 0 6.00964110968538e-08 0.00021 6.01064110968538e-08 0 6.01064110968538e-08 0 6.01164110968538e-08 0.00021 6.01264110968538e-08 0 6.01264110968538e-08 0 6.01364110968538e-08 0.00021 6.01464110968538e-08 0 6.018246778437788e-08 0 6.019246778437788e-08 0.00021 6.020246778437788e-08 0 6.020246778437788e-08 0 6.021246778437788e-08 0.00021 6.022246778437788e-08 0 6.022246778437788e-08 0 6.023246778437787e-08 0.00021 6.024246778437787e-08 0 6.024246778437787e-08 0 6.025246778437787e-08 0.00021 6.026246778437787e-08 0 6.037894967693244e-08 0 6.038894967693244e-08 0.00021 6.039894967693244e-08 0 6.040945588953609e-08 0 6.041945588953608e-08 0.00021 6.042945588953608e-08 0 6.048247810580172e-08 0 6.049247810580172e-08 0.00021 6.050247810580172e-08 0 6.082137178149685e-08 0 6.083137178149685e-08 0.00021 6.084137178149685e-08 0 6.088086814496828e-08 0 6.089086814496828e-08 0.00021 6.090086814496828e-08 0 6.093420581430533e-08 0 6.094420581430532e-08 0.00021 6.095420581430532e-08 0 6.095420581430532e-08 0 6.096420581430532e-08 0.00021 6.097420581430532e-08 0 6.099029579830737e-08 0 6.100029579830737e-08 0.00021 6.101029579830736e-08 0 6.104024583316544e-08 0 6.105024583316544e-08 0.00021 6.106024583316544e-08 0 6.106249238159588e-08 0 6.107249238159588e-08 0.00021 6.108249238159588e-08 0 6.130240683193909e-08 0 6.131240683193909e-08 0.00021 6.132240683193909e-08 0 6.16855210196907e-08 0 6.169552101969069e-08 0.00021 6.170552101969069e-08 0 6.173729381646157e-08 0 6.174729381646156e-08 0.00021 6.175729381646156e-08 0 6.175729381646156e-08 0 6.176729381646156e-08 0.00021 6.177729381646156e-08 0 6.195273021530417e-08 0 6.196273021530417e-08 0.00021 6.197273021530416e-08 0 6.213012629532761e-08 0 6.214012629532761e-08 0.00021 6.215012629532761e-08 0 6.21891353246199e-08 0 6.21991353246199e-08 0.00021 6.22091353246199e-08 0 6.228236577995634e-08 0 6.229236577995634e-08 0.00021 6.230236577995634e-08 0 6.230236577995634e-08 0 6.231236577995634e-08 0.00021 6.232236577995634e-08 0 6.244330538072468e-08 0 6.245330538072468e-08 0.00021 6.246330538072468e-08 0 6.253998696742533e-08 0 6.254998696742533e-08 0.00021 6.255998696742533e-08 0 6.256688940985866e-08 0 6.257688940985866e-08 0.00021 6.258688940985866e-08 0 6.263841964412232e-08 0 6.264841964412232e-08 0.00021 6.265841964412232e-08 0 6.265954172915644e-08 0 6.266954172915643e-08 0.00021 6.267954172915643e-08 0 6.273197076293204e-08 0 6.274197076293204e-08 0.00021 6.275197076293204e-08 0 6.276044248491882e-08 0 6.277044248491882e-08 0.00021 6.278044248491882e-08 0 6.285148840680317e-08 0 6.286148840680317e-08 0.00021 6.287148840680317e-08 0 6.287148840680317e-08 0 6.288148840680317e-08 0.00021 6.289148840680316e-08 0 6.289148840680316e-08 0 6.290148840680316e-08 0.00021 6.291148840680316e-08 0 6.291148840680316e-08 0 6.292148840680316e-08 0.00021 6.293148840680316e-08 0 6.293148840680316e-08 0 6.294148840680315e-08 0.00021 6.295148840680315e-08 0 6.298166873387591e-08 0 6.299166873387591e-08 0.00021 6.300166873387591e-08 0 6.3065740126179e-08 0 6.3075740126179e-08 0.00021 6.3085740126179e-08 0 6.3085740126179e-08 0 6.3095740126179e-08 0.00021 6.3105740126179e-08 0 6.311707638826313e-08 0 6.312707638826313e-08 0.00021 6.313707638826312e-08 0 6.314084421953445e-08 0 6.315084421953445e-08 0.00021 6.316084421953444e-08 0 6.317410412670714e-08 0 6.318410412670714e-08 0.00021 6.319410412670714e-08 0 6.319410412670714e-08 0 6.320410412670714e-08 0.00021 6.321410412670714e-08 0 6.32845149776603e-08 0 6.32945149776603e-08 0.00021 6.33045149776603e-08 0 6.332255021974711e-08 0 6.33325502197471e-08 0.00021 6.33425502197471e-08 0 6.342242638025308e-08 0 6.343242638025308e-08 0.00021 6.344242638025308e-08 0 6.345074694951473e-08 0 6.346074694951473e-08 0.00021 6.347074694951473e-08 0 6.410282878413593e-08 0 6.411282878413593e-08 0.00021 6.412282878413593e-08 0 6.412282878413593e-08 0 6.413282878413593e-08 0.00021 6.414282878413593e-08 0 6.419062222035738e-08 0 6.420062222035738e-08 0.00021 6.421062222035738e-08 0 6.427665449222976e-08 0 6.428665449222976e-08 0.00021 6.429665449222976e-08 0 6.430526055120865e-08 0 6.431526055120864e-08 0.00021 6.432526055120864e-08 0 6.437247436890912e-08 0 6.438247436890912e-08 0.00021 6.439247436890912e-08 0 6.439247436890912e-08 0 6.440247436890912e-08 0.00021 6.441247436890911e-08 0 6.44439472263848e-08 0 6.44539472263848e-08 0.00021 6.44639472263848e-08 0 6.46840124496432e-08 0 6.469401244964319e-08 0.00021 6.470401244964319e-08 0 6.476659187261862e-08 0 6.477659187261862e-08 0.00021 6.478659187261862e-08 0 6.488113106437957e-08 0 6.489113106437957e-08 0.00021 6.490113106437957e-08 0 6.49795438774302e-08 0 6.498954387743019e-08 0.00021 6.499954387743019e-08 0 6.499954387743019e-08 0 6.500954387743019e-08 0.00021 6.501954387743019e-08 0 6.505699907644296e-08 0 6.506699907644296e-08 0.00021 6.507699907644295e-08 0 6.515828051920657e-08 0 6.516828051920657e-08 0.00021 6.517828051920657e-08 0 6.52225350393e-08 0 6.523253503929999e-08 0.00021 6.524253503929999e-08 0 6.527104502273258e-08 0 6.528104502273258e-08 0.00021 6.529104502273258e-08 0 6.529104502273258e-08 0 6.530104502273258e-08 0.00021 6.531104502273258e-08 0 6.534524480246929e-08 0 6.535524480246929e-08 0.00021 6.536524480246929e-08 0 6.545519752774764e-08 0 6.546519752774763e-08 0.00021 6.547519752774763e-08 0 6.548434180804533e-08 0 6.549434180804533e-08 0.00021 6.550434180804533e-08 0 6.550542023212938e-08 0 6.551542023212938e-08 0.00021 6.552542023212938e-08 0 6.553345752454815e-08 0 6.554345752454815e-08 0.00021 6.555345752454815e-08 0 6.580624962620642e-08 0 6.581624962620642e-08 0.00021 6.582624962620642e-08 0 6.586351233565247e-08 0 6.587351233565246e-08 0.00021 6.588351233565246e-08 0 6.599630549355813e-08 0 6.600630549355813e-08 0.00021 6.601630549355813e-08 0 6.6100941345537e-08 0 6.611094134553699e-08 0.00021 6.612094134553699e-08 0 6.612094134553699e-08 0 6.613094134553699e-08 0.00021 6.614094134553699e-08 0 6.620660523287325e-08 0 6.621660523287325e-08 0.00021 6.622660523287324e-08 0 6.631832117318917e-08 0 6.632832117318917e-08 0.00021 6.633832117318917e-08 0 6.636174082159392e-08 0 6.637174082159392e-08 0.00021 6.638174082159392e-08 0 6.63846846148319e-08 0 6.63946846148319e-08 0.00021 6.64046846148319e-08 0 6.64046846148319e-08 0 6.64146846148319e-08 0.00021 6.64246846148319e-08 0 6.64246846148319e-08 0 6.643468461483189e-08 0.00021 6.644468461483189e-08 0 6.652725697461623e-08 0 6.653725697461622e-08 0.00021 6.654725697461622e-08 0 6.654725697461622e-08 0 6.655725697461622e-08 0.00021 6.656725697461622e-08 0 6.656725697461622e-08 0 6.657725697461622e-08 0.00021 6.658725697461621e-08 0 6.668840869981373e-08 0 6.669840869981373e-08 0.00021 6.670840869981373e-08 0 6.671047297057797e-08 0 6.672047297057797e-08 0.00021 6.673047297057796e-08 0 6.673047297057796e-08 0 6.674047297057796e-08 0.00021 6.675047297057796e-08 0 6.675047297057796e-08 0 6.676047297057796e-08 0.00021 6.677047297057796e-08 0 6.683106682206288e-08 0 6.684106682206288e-08 0.00021 6.685106682206287e-08 0 6.685106682206287e-08 0 6.686106682206287e-08 0.00021 6.687106682206287e-08 0 6.703743016146501e-08 0 6.704743016146501e-08 0.00021 6.705743016146501e-08 0 6.705743016146501e-08 0 6.7067430161465e-08 0.00021 6.7077430161465e-08 0 6.712220328262603e-08 0 6.713220328262603e-08 0.00021 6.714220328262603e-08 0 6.719324421116837e-08 0 6.720324421116837e-08 0.00021 6.721324421116836e-08 0 6.726606814989549e-08 0 6.727606814989548e-08 0.00021 6.728606814989548e-08 0 6.736623168412821e-08 0 6.737623168412821e-08 0.00021 6.73862316841282e-08 0 6.745047906961257e-08 0 6.746047906961257e-08 0.00021 6.747047906961257e-08 0 6.747047906961257e-08 0 6.748047906961257e-08 0.00021 6.749047906961256e-08 0 6.774703555131531e-08 0 6.77570355513153e-08 0.00021 6.77670355513153e-08 0 6.790035397666486e-08 0 6.791035397666486e-08 0.00021 6.792035397666485e-08 0 6.81252166894181e-08 0 6.81352166894181e-08 0.00021 6.81452166894181e-08 0 6.819144570060563e-08 0 6.820144570060562e-08 0.00021 6.821144570060562e-08 0 6.821144570060562e-08 0 6.822144570060562e-08 0.00021 6.823144570060562e-08 0 6.823144570060562e-08 0 6.824144570060562e-08 0.00021 6.825144570060561e-08 0 6.825284947640013e-08 0 6.826284947640013e-08 0.00021 6.827284947640013e-08 0 6.827284947640013e-08 0 6.828284947640013e-08 0.00021 6.829284947640013e-08 0 6.830150838397087e-08 0 6.831150838397087e-08 0.00021 6.832150838397087e-08 0 6.857033912632447e-08 0 6.858033912632446e-08 0.00021 6.859033912632446e-08 0 6.859033912632446e-08 0 6.860033912632446e-08 0.00021 6.861033912632446e-08 0 6.877985691905004e-08 0 6.878985691905003e-08 0.00021 6.879985691905003e-08 0 6.880479069762917e-08 0 6.881479069762916e-08 0.00021 6.882479069762916e-08 0 6.884932921056148e-08 0 6.885932921056148e-08 0.00021 6.886932921056148e-08 0 6.88964052518789e-08 0 6.89064052518789e-08 0.00021 6.89164052518789e-08 0 6.89691475744514e-08 0 6.89791475744514e-08 0.00021 6.898914757445139e-08 0 6.903128501892831e-08 0 6.90412850189283e-08 0.00021 6.90512850189283e-08 0 6.908500871924139e-08 0 6.909500871924139e-08 0.00021 6.910500871924139e-08 0 6.911137186112028e-08 0 6.912137186112028e-08 0.00021 6.913137186112028e-08 0 6.939694765509833e-08 0 6.940694765509833e-08 0.00021 6.941694765509832e-08 0 6.941694765509832e-08 0 6.942694765509832e-08 0.00021 6.943694765509832e-08 0 6.947737028195498e-08 0 6.948737028195498e-08 0.00021 6.949737028195498e-08 0 6.95091964343737e-08 0 6.95191964343737e-08 0.00021 6.95291964343737e-08 0 6.964905015104393e-08 0 6.965905015104393e-08 0.00021 6.966905015104393e-08 0 6.977815197011158e-08 0 6.978815197011158e-08 0.00021 6.979815197011158e-08 0 6.979815197011158e-08 0 6.980815197011158e-08 0.00021 6.981815197011157e-08 0 6.981815197011157e-08 0 6.982815197011157e-08 0.00021 6.983815197011157e-08 0 6.984382418365977e-08 0 6.985382418365977e-08 0.00021 6.986382418365976e-08 0 6.993991129624133e-08 0 6.994991129624133e-08 0.00021 6.995991129624132e-08 0 7.016627041863604e-08 0 7.017627041863603e-08 0.00021 7.018627041863603e-08 0 7.018627041863603e-08 0 7.019627041863603e-08 0.00021 7.020627041863603e-08 0 7.027593573079979e-08 0 7.028593573079979e-08 0.00021 7.029593573079979e-08 0 7.037336972753221e-08 0 7.03833697275322e-08 0.00021 7.03933697275322e-08 0 7.040509844850062e-08 0 7.041509844850062e-08 0.00021 7.042509844850062e-08 0 7.053980314573454e-08 0 7.054980314573454e-08 0.00021 7.055980314573454e-08 0 7.064903296121504e-08 0 7.065903296121503e-08 0.00021 7.066903296121503e-08 0 7.071041145863984e-08 0 7.072041145863984e-08 0.00021 7.073041145863984e-08 0 7.073041145863984e-08 0 7.074041145863984e-08 0.00021 7.075041145863984e-08 0 7.075888190812333e-08 0 7.076888190812333e-08 0.00021 7.077888190812333e-08 0 7.077888190812333e-08 0 7.078888190812332e-08 0.00021 7.079888190812332e-08 0 7.097075416639027e-08 0 7.098075416639027e-08 0.00021 7.099075416639026e-08 0 7.102762593225148e-08 0 7.103762593225148e-08 0.00021 7.104762593225148e-08 0 7.104762593225148e-08 0 7.105762593225148e-08 0.00021 7.106762593225148e-08 0 7.11186647062866e-08 0 7.11286647062866e-08 0.00021 7.11386647062866e-08 0 7.121005523970894e-08 0 7.122005523970893e-08 0.00021 7.123005523970893e-08 0 7.130324042227832e-08 0 7.131324042227832e-08 0.00021 7.132324042227832e-08 0 7.140892138724871e-08 0 7.141892138724871e-08 0.00021 7.142892138724871e-08 0 7.144083349711462e-08 0 7.145083349711462e-08 0.00021 7.146083349711462e-08 0 7.146391634409911e-08 0 7.147391634409911e-08 0.00021 7.148391634409911e-08 0 7.156232784156553e-08 0 7.157232784156553e-08 0.00021 7.158232784156553e-08 0 7.161086506571553e-08 0 7.162086506571553e-08 0.00021 7.163086506571553e-08 0 7.169122157951403e-08 0 7.170122157951402e-08 0.00021 7.171122157951402e-08 0 7.172301632547235e-08 0 7.173301632547235e-08 0.00021 7.174301632547234e-08 0 7.177457993061643e-08 0 7.178457993061642e-08 0.00021 7.179457993061642e-08 0 7.180101911561194e-08 0 7.181101911561193e-08 0.00021 7.182101911561193e-08 0 7.185385529432742e-08 0 7.186385529432742e-08 0.00021 7.187385529432742e-08 0 7.192697665147944e-08 0 7.193697665147944e-08 0.00021 7.194697665147944e-08 0 7.201048228132036e-08 0 7.202048228132036e-08 0.00021 7.203048228132036e-08 0 7.203048228132036e-08 0 7.204048228132036e-08 0.00021 7.205048228132036e-08 0 7.205048228132036e-08 0 7.206048228132035e-08 0.00021 7.207048228132035e-08 0 7.207278207949619e-08 0 7.208278207949619e-08 0.00021 7.209278207949619e-08 0 7.220688875002665e-08 0 7.221688875002665e-08 0.00021 7.222688875002665e-08 0 7.23549644088892e-08 0 7.23649644088892e-08 0.00021 7.23749644088892e-08 0 7.246667988333825e-08 0 7.247667988333824e-08 0.00021 7.248667988333824e-08 0 7.251671492840839e-08 0 7.252671492840839e-08 0.00021 7.253671492840839e-08 0 7.257317845093752e-08 0 7.258317845093752e-08 0.00021 7.259317845093752e-08 0 7.264236614304638e-08 0 7.265236614304638e-08 0.00021 7.266236614304638e-08 0 7.271514796989934e-08 0 7.272514796989934e-08 0.00021 7.273514796989934e-08 0 7.285841809538841e-08 0 7.286841809538841e-08 0.00021 7.287841809538841e-08 0 7.29498628823078e-08 0 7.29598628823078e-08 0.00021 7.296986288230779e-08 0 7.296986288230779e-08 0 7.297986288230779e-08 0.00021 7.298986288230779e-08 0 7.30418240987234e-08 0 7.305182409872339e-08 0.00021 7.306182409872339e-08 0 7.306182409872339e-08 0 7.307182409872339e-08 0.00021 7.308182409872339e-08 0 7.318603226024007e-08 0 7.319603226024007e-08 0.00021 7.320603226024007e-08 0 7.327746056916408e-08 0 7.328746056916408e-08 0.00021 7.329746056916408e-08 0 7.329795491666192e-08 0 7.330795491666192e-08 0.00021 7.331795491666191e-08 0 7.339360693953693e-08 0 7.340360693953693e-08 0.00021 7.341360693953692e-08 0 7.342877805219466e-08 0 7.343877805219466e-08 0.00021 7.344877805219466e-08 0 7.348028194158982e-08 0 7.349028194158982e-08 0.00021 7.350028194158982e-08 0 7.362716283573649e-08 0 7.363716283573648e-08 0.00021 7.364716283573648e-08 0 7.36472144274756e-08 0 7.36572144274756e-08 0.00021 7.36672144274756e-08 0 7.374182440033429e-08 0 7.375182440033429e-08 0.00021 7.376182440033429e-08 0 7.392055752768955e-08 0 7.393055752768955e-08 0.00021 7.394055752768954e-08 0 7.406538924187141e-08 0 7.407538924187141e-08 0.00021 7.408538924187141e-08 0 7.409845731210318e-08 0 7.410845731210318e-08 0.00021 7.411845731210318e-08 0 7.435781907784589e-08 0 7.436781907784589e-08 0.00021 7.437781907784589e-08 0 7.437781907784589e-08 0 7.438781907784588e-08 0.00021 7.439781907784588e-08 0 7.439781907784588e-08 0 7.440781907784588e-08 0.00021 7.441781907784588e-08 0 7.447651295814255e-08 0 7.448651295814255e-08 0.00021 7.449651295814255e-08 0 7.453990081129974e-08 0 7.454990081129973e-08 0.00021 7.455990081129973e-08 0 7.469304856590566e-08 0 7.470304856590566e-08 0.00021 7.471304856590565e-08 0 7.477866699642686e-08 0 7.478866699642686e-08 0.00021 7.479866699642686e-08 0 7.48435618993985e-08 0 7.48535618993985e-08 0.00021 7.486356189939849e-08 0 7.486356189939849e-08 0 7.487356189939849e-08 0.00021 7.488356189939849e-08 0 7.488356189939849e-08 0 7.489356189939849e-08 0.00021 7.490356189939849e-08 0 7.491463465148233e-08 0 7.492463465148233e-08 0.00021 7.493463465148233e-08 0 7.496231816541376e-08 0 7.497231816541376e-08 0.00021 7.498231816541376e-08 0 7.521996815415654e-08 0 7.522996815415654e-08 0.00021 7.523996815415654e-08 0 7.537599028734242e-08 0 7.538599028734242e-08 0.00021 7.539599028734241e-08 0 7.581200292710703e-08 0 7.582200292710703e-08 0.00021 7.583200292710703e-08 0 7.583200292710703e-08 0 7.584200292710703e-08 0.00021 7.585200292710703e-08 0 7.596038073469449e-08 0 7.597038073469449e-08 0.00021 7.598038073469449e-08 0 7.598232504989641e-08 0 7.59923250498964e-08 0.00021 7.60023250498964e-08 0 7.602942735470213e-08 0 7.603942735470212e-08 0.00021 7.604942735470212e-08 0 7.607218169940534e-08 0 7.608218169940534e-08 0.00021 7.609218169940533e-08 0 7.612944243215867e-08 0 7.613944243215866e-08 0.00021 7.614944243215866e-08 0 7.61532648761514e-08 0 7.61632648761514e-08 0.00021 7.61732648761514e-08 0 7.619073356968728e-08 0 7.620073356968727e-08 0.00021 7.621073356968727e-08 0 7.621073356968727e-08 0 7.622073356968727e-08 0.00021 7.623073356968727e-08 0 7.6375209255285e-08 0 7.638520925528499e-08 0.00021 7.639520925528499e-08 0 7.640724600880048e-08 0 7.641724600880048e-08 0.00021 7.642724600880048e-08 0 7.668299678985769e-08 0 7.669299678985769e-08 0.00021 7.670299678985769e-08 0 7.674529105310257e-08 0 7.675529105310257e-08 0.00021 7.676529105310257e-08 0 7.681108407665033e-08 0 7.682108407665032e-08 0.00021 7.683108407665032e-08 0 7.685785116392925e-08 0 7.686785116392925e-08 0.00021 7.687785116392925e-08 0 7.687968070047551e-08 0 7.688968070047551e-08 0.00021 7.68996807004755e-08 0 7.698349421244981e-08 0 7.699349421244981e-08 0.00021 7.700349421244981e-08 0 7.700349421244981e-08 0 7.701349421244981e-08 0.00021 7.70234942124498e-08 0 7.713938742131799e-08 0 7.714938742131799e-08 0.00021 7.715938742131798e-08 0 7.738349143592181e-08 0 7.73934914359218e-08 0.00021 7.74034914359218e-08 0 7.756486674497732e-08 0 7.757486674497732e-08 0.00021 7.758486674497732e-08 0 7.772263712993797e-08 0 7.773263712993797e-08 0.00021 7.774263712993797e-08 0 7.777068826755403e-08 0 7.778068826755402e-08 0.00021 7.779068826755402e-08 0 7.783293716611985e-08 0 7.784293716611985e-08 0.00021 7.785293716611985e-08 0 7.797965849366075e-08 0 7.798965849366074e-08 0.00021 7.799965849366074e-08 0 7.801490758299353e-08 0 7.802490758299353e-08 0.00021 7.803490758299352e-08 0 7.808459608776213e-08 0 7.809459608776213e-08 0.00021 7.810459608776213e-08 0 7.815603651450103e-08 0 7.816603651450103e-08 0.00021 7.817603651450103e-08 0 7.826744260802764e-08 0 7.827744260802764e-08 0.00021 7.828744260802764e-08 0 7.83288623742421e-08 0 7.833886237424209e-08 0.00021 7.834886237424209e-08 0 7.836890223515413e-08 0 7.837890223515413e-08 0.00021 7.838890223515412e-08 0 7.841737542678309e-08 0 7.842737542678308e-08 0.00021 7.843737542678308e-08 0 7.850315418080272e-08 0 7.851315418080272e-08 0.00021 7.852315418080271e-08 0 7.861915229970742e-08 0 7.862915229970742e-08 0.00021 7.863915229970742e-08 0 7.863915229970742e-08 0 7.864915229970742e-08 0.00021 7.865915229970741e-08 0 7.871845529945934e-08 0 7.872845529945934e-08 0.00021 7.873845529945934e-08 0 7.884717268608495e-08 0 7.885717268608495e-08 0.00021 7.886717268608495e-08 0 7.890142856865663e-08 0 7.891142856865663e-08 0.00021 7.892142856865663e-08 0 7.892142856865663e-08 0 7.893142856865663e-08 0.00021 7.894142856865662e-08 0 7.900958957896699e-08 0 7.901958957896698e-08 0.00021 7.902958957896698e-08 0 7.90730609749133e-08 0 7.90830609749133e-08 0.00021 7.90930609749133e-08 0 7.911687148587773e-08 0 7.912687148587773e-08 0.00021 7.913687148587772e-08 0 7.915730433072006e-08 0 7.916730433072006e-08 0.00021 7.917730433072006e-08 0 7.919210721175918e-08 0 7.920210721175918e-08 0.00021 7.921210721175918e-08 0 7.921210721175918e-08 0 7.922210721175917e-08 0.00021 7.923210721175917e-08 0 7.926869062940129e-08 0 7.927869062940128e-08 0.00021 7.928869062940128e-08 0 7.93293952986629e-08 0 7.93393952986629e-08 0.00021 7.93493952986629e-08 0 7.93493952986629e-08 0 7.93593952986629e-08 0.00021 7.93693952986629e-08 0 7.93693952986629e-08 0 7.937939529866289e-08 0.00021 7.938939529866289e-08 0 7.938939529866289e-08 0 7.939939529866289e-08 0.00021 7.940939529866289e-08 0 7.942493799797318e-08 0 7.943493799797318e-08 0.00021 7.944493799797318e-08 0 7.944493799797318e-08 0 7.945493799797318e-08 0.00021 7.946493799797317e-08 0 7.954775094151467e-08 0 7.955775094151466e-08 0.00021 7.956775094151466e-08 0 7.959656136188984e-08 0 7.960656136188984e-08 0.00021 7.961656136188984e-08 0 7.963528337459687e-08 0 7.964528337459687e-08 0.00021 7.965528337459687e-08 0 7.967427763685501e-08 0 7.968427763685501e-08 0.00021 7.969427763685501e-08 0 7.978701605153297e-08 0 7.979701605153297e-08 0.00021 7.980701605153297e-08 0 7.983622342197272e-08 0 7.984622342197272e-08 0.00021 7.985622342197272e-08 0 7.985622342197272e-08 0 7.986622342197271e-08 0.00021 7.987622342197271e-08 0 7.990832524404229e-08 0 7.991832524404229e-08 0.00021 7.992832524404229e-08 0 7.992832524404229e-08 0 7.993832524404229e-08 0.00021 7.994832524404229e-08 0 7.994832524404229e-08 0 7.995832524404228e-08 0.00021 7.996832524404228e-08 0 7.99746029502118e-08 0 7.99846029502118e-08 0.00021 7.99946029502118e-08 0 7.999991248455274e-08 0 8.000991248455274e-08 0.00021 8.001991248455274e-08 0 8.004114651224051e-08 0 8.005114651224051e-08 0.00021 8.00611465122405e-08 0 8.009408202826346e-08 0 8.010408202826346e-08 0.00021 8.011408202826346e-08 0 8.011408202826346e-08 0 8.012408202826345e-08 0.00021 8.013408202826345e-08 0 8.013905361927806e-08 0 8.014905361927806e-08 0.00021 8.015905361927806e-08 0 8.040745253381804e-08 0 8.041745253381804e-08 0.00021 8.042745253381804e-08 0 8.053520547235224e-08 0 8.054520547235224e-08 0.00021 8.055520547235224e-08 0 8.060217488909394e-08 0 8.061217488909393e-08 0.00021 8.062217488909393e-08 0 8.070532871386848e-08 0 8.071532871386848e-08 0.00021 8.072532871386848e-08 0 8.072532871386848e-08 0 8.073532871386848e-08 0.00021 8.074532871386847e-08 0 8.074532871386847e-08 0 8.075532871386847e-08 0.00021 8.076532871386847e-08 0 8.079719839982186e-08 0 8.080719839982186e-08 0.00021 8.081719839982186e-08 0 8.083138674176962e-08 0 8.084138674176962e-08 0.00021 8.085138674176962e-08 0 8.085408070221934e-08 0 8.086408070221934e-08 0.00021 8.087408070221934e-08 0 8.089398199579607e-08 0 8.090398199579606e-08 0.00021 8.091398199579606e-08 0 8.100113449972304e-08 0 8.101113449972304e-08 0.00021 8.102113449972304e-08 0 8.111173002761368e-08 0 8.112173002761367e-08 0.00021 8.113173002761367e-08 0 8.115646857238506e-08 0 8.116646857238506e-08 0.00021 8.117646857238506e-08 0 8.133546151841648e-08 0 8.134546151841648e-08 0.00021 8.135546151841648e-08 0 8.139613157904338e-08 0 8.140613157904338e-08 0.00021 8.141613157904337e-08 0 8.163339603205835e-08 0 8.164339603205835e-08 0.00021 8.165339603205835e-08 0 8.175395304517242e-08 0 8.176395304517242e-08 0.00021 8.177395304517242e-08 0 8.179793733365431e-08 0 8.180793733365431e-08 0.00021 8.18179373336543e-08 0 8.18336302707079e-08 0 8.18436302707079e-08 0.00021 8.18536302707079e-08 0 8.19047043111009e-08 0 8.19147043111009e-08 0.00021 8.19247043111009e-08 0 8.221895764656586e-08 0 8.222895764656586e-08 0.00021 8.223895764656586e-08 0 8.223895764656586e-08 0 8.224895764656586e-08 0.00021 8.225895764656586e-08 0 8.225895764656586e-08 0 8.226895764656585e-08 0.00021 8.227895764656585e-08 0 8.227895764656585e-08 0 8.228895764656585e-08 0.00021 8.229895764656585e-08 0 8.229895764656585e-08 0 8.230895764656585e-08 0.00021 8.231895764656585e-08 0 8.231895764656585e-08 0 8.232895764656584e-08 0.00021 8.233895764656584e-08 0 8.233895764656584e-08 0 8.234895764656584e-08 0.00021 8.235895764656584e-08 0 8.252982978827255e-08 0 8.253982978827255e-08 0.00021 8.254982978827255e-08 0 8.264844400796397e-08 0 8.265844400796397e-08 0.00021 8.266844400796397e-08 0 8.271056696764048e-08 0 8.272056696764048e-08 0.00021 8.273056696764048e-08 0 8.27388822625085e-08 0 8.27488822625085e-08 0.00021 8.27588822625085e-08 0 8.275961721363274e-08 0 8.276961721363274e-08 0.00021 8.277961721363274e-08 0 8.285047998722927e-08 0 8.286047998722927e-08 0.00021 8.287047998722927e-08 0 8.289208527455818e-08 0 8.290208527455817e-08 0.00021 8.291208527455817e-08 0 8.292088154113844e-08 0 8.293088154113844e-08 0.00021 8.294088154113844e-08 0 8.2984304494316e-08 0 8.2994304494316e-08 0.00021 8.3004304494316e-08 0 8.305858745030245e-08 0 8.306858745030245e-08 0.00021 8.307858745030244e-08 0 8.32111641288531e-08 0 8.32211641288531e-08 0.00021 8.32311641288531e-08 0 8.32311641288531e-08 0 8.32411641288531e-08 0.00021 8.32511641288531e-08 0 8.335052906655579e-08 0 8.336052906655579e-08 0.00021 8.337052906655578e-08 0 8.337052906655578e-08 0 8.338052906655578e-08 0.00021 8.339052906655578e-08 0 8.348270235617486e-08 0 8.349270235617486e-08 0.00021 8.350270235617486e-08 0 8.350270235617486e-08 0 8.351270235617486e-08 0.00021 8.352270235617486e-08 0 8.356503214721724e-08 0 8.357503214721724e-08 0.00021 8.358503214721724e-08 0 8.378137432823269e-08 0 8.379137432823268e-08 0.00021 8.380137432823268e-08 0 8.380137432823268e-08 0 8.381137432823268e-08 0.00021 8.382137432823268e-08 0 8.385250604482214e-08 0 8.386250604482213e-08 0.00021 8.387250604482213e-08 0 8.390700428239423e-08 0 8.391700428239423e-08 0.00021 8.392700428239423e-08 0 8.411537745789466e-08 0 8.412537745789465e-08 0.00021 8.413537745789465e-08 0 8.433532795740257e-08 0 8.434532795740257e-08 0.00021 8.435532795740257e-08 0 8.471179134407376e-08 0 8.472179134407376e-08 0.00021 8.473179134407376e-08 0 8.478103175934382e-08 0 8.479103175934382e-08 0.00021 8.480103175934382e-08 0 8.480103175934382e-08 0 8.481103175934382e-08 0.00021 8.482103175934382e-08 0 8.492173918128479e-08 0 8.493173918128479e-08 0.00021 8.494173918128478e-08 0 8.494173918128478e-08 0 8.495173918128478e-08 0.00021 8.496173918128478e-08 0 8.517598364636032e-08 0 8.518598364636032e-08 0.00021 8.519598364636032e-08 0 8.526895122319316e-08 0 8.527895122319315e-08 0.00021 8.528895122319315e-08 0 8.54993702298785e-08 0 8.55093702298785e-08 0.00021 8.55193702298785e-08 0 8.55193702298785e-08 0 8.55293702298785e-08 0.00021 8.55393702298785e-08 0 8.55393702298785e-08 0 8.55493702298785e-08 0.00021 8.555937022987849e-08 0 8.581329382650425e-08 0 8.582329382650425e-08 0.00021 8.583329382650425e-08 0 8.584633252936814e-08 0 8.585633252936814e-08 0.00021 8.586633252936814e-08 0 8.5870570433924e-08 0 8.5880570433924e-08 0.00021 8.5890570433924e-08 0 8.60958620365389e-08 0 8.61058620365389e-08 0.00021 8.61158620365389e-08 0 8.619262554172335e-08 0 8.620262554172335e-08 0.00021 8.621262554172334e-08 0 8.6299295333037e-08 0 8.6309295333037e-08 0.00021 8.6319295333037e-08 0 8.640114000320483e-08 0 8.641114000320483e-08 0.00021 8.642114000320482e-08 0 8.644468191315247e-08 0 8.645468191315247e-08 0.00021 8.646468191315247e-08 0 8.658299059300867e-08 0 8.659299059300867e-08 0.00021 8.660299059300867e-08 0 8.667620200024972e-08 0 8.668620200024972e-08 0.00021 8.669620200024972e-08 0 8.684117370705712e-08 0 8.685117370705712e-08 0.00021 8.686117370705712e-08 0 8.686117370705712e-08 0 8.687117370705712e-08 0.00021 8.688117370705711e-08 0 8.688120532754984e-08 0 8.689120532754983e-08 0.00021 8.690120532754983e-08 0 8.690120532754983e-08 0 8.691120532754983e-08 0.00021 8.692120532754983e-08 0 8.697796771356352e-08 0 8.698796771356351e-08 0.00021 8.699796771356351e-08 0 8.699796771356351e-08 0 8.700796771356351e-08 0.00021 8.701796771356351e-08 0 8.701796771356351e-08 0 8.702796771356351e-08 0.00021 8.70379677135635e-08 0 8.704426601622764e-08 0 8.705426601622763e-08 0.00021 8.706426601622763e-08 0 8.715708328949765e-08 0 8.716708328949765e-08 0.00021 8.717708328949765e-08 0 8.722815933092884e-08 0 8.723815933092884e-08 0.00021 8.724815933092883e-08 0 8.728575526122785e-08 0 8.729575526122785e-08 0.00021 8.730575526122785e-08 0 8.73082400827826e-08 0 8.731824008278259e-08 0.00021 8.732824008278259e-08 0 8.740190886721425e-08 0 8.741190886721425e-08 0.00021 8.742190886721425e-08 0 8.742190886721425e-08 0 8.743190886721424e-08 0.00021 8.744190886721424e-08 0 8.744190886721424e-08 0 8.745190886721424e-08 0.00021 8.746190886721424e-08 0 8.774097749806039e-08 0 8.775097749806039e-08 0.00021 8.776097749806039e-08 0 8.78130032512203e-08 0 8.78230032512203e-08 0.00021 8.78330032512203e-08 0 8.78330032512203e-08 0 8.78430032512203e-08 0.00021 8.78530032512203e-08 0 8.788990385187309e-08 0 8.789990385187308e-08 0.00021 8.790990385187308e-08 0 8.790990385187308e-08 0 8.791990385187308e-08 0.00021 8.792990385187308e-08 0 8.792990385187308e-08 0 8.793990385187308e-08 0.00021 8.794990385187307e-08 0 8.803178569056728e-08 0 8.804178569056728e-08 0.00021 8.805178569056728e-08 0 8.811080344491123e-08 0 8.812080344491123e-08 0.00021 8.813080344491123e-08 0 8.813080344491123e-08 0 8.814080344491122e-08 0.00021 8.815080344491122e-08 0 8.824355902858088e-08 0 8.825355902858088e-08 0.00021 8.826355902858088e-08 0 8.82997138070772e-08 0 8.83097138070772e-08 0.00021 8.83197138070772e-08 0 8.83197138070772e-08 0 8.83297138070772e-08 0.00021 8.83397138070772e-08 0 8.83397138070772e-08 0 8.83497138070772e-08 0.00021 8.83597138070772e-08 0 8.840549224240265e-08 0 8.841549224240264e-08 0.00021 8.842549224240264e-08 0 8.850545673622861e-08 0 8.85154567362286e-08 0.00021 8.85254567362286e-08 0 8.865560179164044e-08 0 8.866560179164044e-08 0.00021 8.867560179164043e-08 0 8.872313180939676e-08 0 8.873313180939676e-08 0.00021 8.874313180939676e-08 0 8.87714567198129e-08 0 8.878145671981289e-08 0.00021 8.879145671981289e-08 0 8.885615727174299e-08 0 8.886615727174299e-08 0.00021 8.887615727174299e-08 0 8.891352457487196e-08 0 8.892352457487196e-08 0.00021 8.893352457487196e-08 0 8.900908095575002e-08 0 8.901908095575002e-08 0.00021 8.902908095575002e-08 0 8.90741428978665e-08 0 8.90841428978665e-08 0.00021 8.90941428978665e-08 0 8.914003466524162e-08 0 8.915003466524162e-08 0.00021 8.916003466524161e-08 0 8.917716098748143e-08 0 8.918716098748143e-08 0.00021 8.919716098748143e-08 0 8.919716098748143e-08 0 8.920716098748142e-08 0.00021 8.921716098748142e-08 0 8.930492889533763e-08 0 8.931492889533763e-08 0.00021 8.932492889533763e-08 0 8.938046322414831e-08 0 8.939046322414831e-08 0.00021 8.940046322414831e-08 0 8.948834569368855e-08 0 8.949834569368854e-08 0.00021 8.950834569368854e-08 0 8.974089935849821e-08 0 8.975089935849821e-08 0.00021 8.976089935849821e-08 0 8.985194460292111e-08 0 8.98619446029211e-08 0.00021 8.98719446029211e-08 0 8.987890524008464e-08 0 8.988890524008464e-08 0.00021 8.989890524008464e-08 0 8.989890524008464e-08 0 8.990890524008463e-08 0.00021 8.991890524008463e-08 0 8.991890524008463e-08 0 8.992890524008463e-08 0.00021 8.993890524008463e-08 0 8.993890524008463e-08 0 8.994890524008463e-08 0.00021 8.995890524008462e-08 0 9.003271550147815e-08 0 9.004271550147815e-08 0.00021 9.005271550147814e-08 0 9.014530444929142e-08 0 9.015530444929141e-08 0.00021 9.016530444929141e-08 0 9.016530444929141e-08 0 9.017530444929141e-08 0.00021 9.018530444929141e-08 0 9.018530444929141e-08 0 9.019530444929141e-08 0.00021 9.02053044492914e-08 0 9.03146919413966e-08 0 9.03246919413966e-08 0.00021 9.03346919413966e-08 0 9.034926545961064e-08 0 9.035926545961064e-08 0.00021 9.036926545961064e-08 0 9.040255763286656e-08 0 9.041255763286655e-08 0.00021 9.042255763286655e-08 0 9.045512622271026e-08 0 9.046512622271026e-08 0.00021 9.047512622271026e-08 0 9.047512622271026e-08 0 9.048512622271025e-08 0.00021 9.049512622271025e-08 0 9.061132369251039e-08 0 9.062132369251039e-08 0.00021 9.063132369251039e-08 0 9.064050522252617e-08 0 9.065050522252617e-08 0.00021 9.066050522252617e-08 0 9.066050522252617e-08 0 9.067050522252617e-08 0.00021 9.068050522252616e-08 0 9.069372579046077e-08 0 9.070372579046077e-08 0.00021 9.071372579046076e-08 0 9.076098675767411e-08 0 9.077098675767411e-08 0.00021 9.078098675767411e-08 0 9.090254068434064e-08 0 9.091254068434064e-08 0.00021 9.092254068434064e-08 0 9.092254068434064e-08 0 9.093254068434064e-08 0.00021 9.094254068434064e-08 0 9.094254068434064e-08 0 9.095254068434064e-08 0.00021 9.096254068434063e-08 0 9.099422350044824e-08 0 9.100422350044824e-08 0.00021 9.101422350044824e-08 0 9.107695205105344e-08 0 9.108695205105344e-08 0.00021 9.109695205105344e-08 0 9.109695205105344e-08 0 9.110695205105344e-08 0.00021 9.111695205105343e-08 0 9.123422328972772e-08 0 9.124422328972772e-08 0.00021 9.125422328972772e-08 0 9.132141129437513e-08 0 9.133141129437512e-08 0.00021 9.134141129437512e-08 0 9.135267383903992e-08 0 9.136267383903992e-08 0.00021 9.137267383903992e-08 0 9.167369337855901e-08 0 9.168369337855901e-08 0.00021 9.169369337855901e-08 0 9.193822189014254e-08 0 9.194822189014254e-08 0.00021 9.195822189014253e-08 0 9.232856323537352e-08 0 9.233856323537352e-08 0.00021 9.234856323537352e-08 0 9.234856323537352e-08 0 9.235856323537352e-08 0.00021 9.236856323537352e-08 0 9.23701952637306e-08 0 9.23801952637306e-08 0.00021 9.239019526373059e-08 0 9.275804147992153e-08 0 9.276804147992153e-08 0.00021 9.277804147992152e-08 0 9.290006182709488e-08 0 9.291006182709488e-08 0.00021 9.292006182709487e-08 0 9.298121720390718e-08 0 9.299121720390718e-08 0.00021 9.300121720390717e-08 0 9.321432508227243e-08 0 9.322432508227243e-08 0.00021 9.323432508227243e-08 0 9.331766475427565e-08 0 9.332766475427565e-08 0.00021 9.333766475427565e-08 0 9.339540028770839e-08 0 9.340540028770839e-08 0.00021 9.341540028770839e-08 0 9.352027275276909e-08 0 9.353027275276908e-08 0.00021 9.354027275276908e-08 0 9.358336135241311e-08 0 9.359336135241311e-08 0.00021 9.360336135241311e-08 0 9.362407671156508e-08 0 9.363407671156508e-08 0.00021 9.364407671156507e-08 0 9.370792628181356e-08 0 9.371792628181355e-08 0.00021 9.372792628181355e-08 0 9.384586188524733e-08 0 9.385586188524733e-08 0.00021 9.386586188524733e-08 0 9.423362192355669e-08 0 9.424362192355669e-08 0.00021 9.425362192355669e-08 0 9.425362192355669e-08 0 9.426362192355669e-08 0.00021 9.427362192355669e-08 0 9.428447002370124e-08 0 9.429447002370123e-08 0.00021 9.430447002370123e-08 0 9.432982206394007e-08 0 9.433982206394007e-08 0.00021 9.434982206394007e-08 0 9.444560302613903e-08 0 9.445560302613902e-08 0.00021 9.446560302613902e-08 0 9.446560302613902e-08 0 9.447560302613902e-08 0.00021 9.448560302613902e-08 0 9.4591176370037e-08 0 9.4601176370037e-08 0.00021 9.4611176370037e-08 0 9.462033514964262e-08 0 9.463033514964262e-08 0.00021 9.464033514964261e-08 0 9.472680980091212e-08 0 9.473680980091211e-08 0.00021 9.474680980091211e-08 0 9.475349019453031e-08 0 9.47634901945303e-08 0.00021 9.47734901945303e-08 0 9.47734901945303e-08 0 9.47834901945303e-08 0.00021 9.47934901945303e-08 0 9.47934901945303e-08 0 9.48034901945303e-08 0.00021 9.48134901945303e-08 0 9.485006540823419e-08 0 9.486006540823419e-08 0.00021 9.487006540823419e-08 0 9.501002957462531e-08 0 9.502002957462531e-08 0.00021 9.503002957462531e-08 0 9.509991958278509e-08 0 9.510991958278509e-08 0.00021 9.511991958278509e-08 0 9.513832292739556e-08 0 9.514832292739556e-08 0.00021 9.515832292739556e-08 0 9.541927121144403e-08 0 9.542927121144403e-08 0.00021 9.543927121144403e-08 0 9.543927121144403e-08 0 9.544927121144403e-08 0.00021 9.545927121144403e-08 0 9.552493293552592e-08 0 9.553493293552591e-08 0.00021 9.554493293552591e-08 0 9.558083927322535e-08 0 9.559083927322535e-08 0.00021 9.560083927322535e-08 0 9.563093591172286e-08 0 9.564093591172286e-08 0.00021 9.565093591172286e-08 0 9.586131180013822e-08 0 9.587131180013821e-08 0.00021 9.588131180013821e-08 0 9.589508265079051e-08 0 9.59050826507905e-08 0.00021 9.59150826507905e-08 0 9.59826938081005e-08 0 9.59926938081005e-08 0.00021 9.60026938081005e-08 0 9.603340459137457e-08 0 9.604340459137457e-08 0.00021 9.605340459137457e-08 0 9.608178584401899e-08 0 9.609178584401899e-08 0.00021 9.610178584401899e-08 0 9.617909781874272e-08 0 9.618909781874272e-08 0.00021 9.619909781874272e-08 0 9.623617808853517e-08 0 9.624617808853516e-08 0.00021 9.625617808853516e-08 0 9.625617808853516e-08 0 9.626617808853516e-08 0.00021 9.627617808853516e-08 0 9.627617808853516e-08 0 9.628617808853516e-08 0.00021 9.629617808853515e-08 0 9.634322656827207e-08 0 9.635322656827206e-08 0.00021 9.636322656827206e-08 0 9.650883619621236e-08 0 9.651883619621236e-08 0.00021 9.652883619621235e-08 0 9.655992933893308e-08 0 9.656992933893308e-08 0.00021 9.657992933893308e-08 0 9.661649151192182e-08 0 9.662649151192182e-08 0.00021 9.663649151192182e-08 0 9.663649151192182e-08 0 9.664649151192182e-08 0.00021 9.665649151192181e-08 0 9.669875696447438e-08 0 9.670875696447438e-08 0.00021 9.671875696447438e-08 0 9.68439008338531e-08 0 9.68539008338531e-08 0.00021 9.68639008338531e-08 0 9.690568099380798e-08 0 9.691568099380798e-08 0.00021 9.692568099380798e-08 0 9.71040643145727e-08 0 9.71140643145727e-08 0.00021 9.71240643145727e-08 0 9.71240643145727e-08 0 9.713406431457269e-08 0.00021 9.714406431457269e-08 0 9.714406431457269e-08 0 9.715406431457269e-08 0.00021 9.716406431457269e-08 0 9.720460771871485e-08 0 9.721460771871485e-08 0.00021 9.722460771871484e-08 0 9.737696136873561e-08 0 9.738696136873561e-08 0.00021 9.739696136873561e-08 0 9.740183967272679e-08 0 9.741183967272679e-08 0.00021 9.742183967272678e-08 0 9.767473484763624e-08 0 9.768473484763624e-08 0.00021 9.769473484763624e-08 0 9.77245796084322e-08 0 9.77345796084322e-08 0.00021 9.77445796084322e-08 0 9.78196023827978e-08 0 9.78296023827978e-08 0.00021 9.78396023827978e-08 0 9.785188197345579e-08 0 9.786188197345579e-08 0.00021 9.787188197345579e-08 0 9.790698443244188e-08 0 9.791698443244188e-08 0.00021 9.792698443244188e-08 0 9.80889169121977e-08 0 9.80989169121977e-08 0.00021 9.81089169121977e-08 0 9.81939275475741e-08 0 9.82039275475741e-08 0.00021 9.821392754757409e-08 0 9.821392754757409e-08 0 9.822392754757409e-08 0.00021 9.823392754757409e-08 0 9.824641934056833e-08 0 9.825641934056832e-08 0.00021 9.826641934056832e-08 0 9.831088488734212e-08 0 9.832088488734212e-08 0.00021 9.833088488734212e-08 0 9.834863109732017e-08 0 9.835863109732017e-08 0.00021 9.836863109732017e-08 0 9.85057550051322e-08 0 9.85157550051322e-08 0.00021 9.85257550051322e-08 0 9.854069283849499e-08 0 9.855069283849499e-08 0.00021 9.856069283849499e-08 0 9.857649769855761e-08 0 9.858649769855761e-08 0.00021 9.859649769855761e-08 0 9.859649769855761e-08 0 9.860649769855761e-08 0.00021 9.86164976985576e-08 0 9.868249427379713e-08 0 9.869249427379713e-08 0.00021 9.870249427379712e-08 0 9.873667108842752e-08 0 9.874667108842752e-08 0.00021 9.875667108842751e-08 0 9.876927877731519e-08 0 9.877927877731519e-08 0.00021 9.878927877731519e-08 0 9.88521619647121e-08 0 9.88621619647121e-08 0.00021 9.88721619647121e-08 0 9.896393176830597e-08 0 9.897393176830597e-08 0.00021 9.898393176830597e-08 0 9.901168098057805e-08 0 9.902168098057804e-08 0.00021 9.903168098057804e-08 0 9.903168098057804e-08 0 9.904168098057804e-08 0.00021 9.905168098057804e-08 0 9.90926511803731e-08 0 9.91026511803731e-08 0.00021 9.91126511803731e-08 0 9.91126511803731e-08 0 9.91226511803731e-08 0.00021 9.91326511803731e-08 0 9.91326511803731e-08 0 9.914265118037309e-08 0.00021 9.915265118037309e-08 0 9.915265118037309e-08 0 9.916265118037309e-08 0.00021 9.917265118037309e-08 0 9.917265118037309e-08 0 9.918265118037309e-08 0.00021 9.919265118037308e-08 0 9.919265118037308e-08 0 9.920265118037308e-08 0.00021 9.921265118037308e-08 0 9.925480895116743e-08 0 9.926480895116743e-08 0.00021 9.927480895116743e-08 0 9.92852986524333e-08 0 9.92952986524333e-08 0.00021 9.930529865243329e-08 0 9.930529865243329e-08 0 9.931529865243329e-08 0.00021 9.932529865243329e-08 0 9.955179334322099e-08 0 9.956179334322098e-08 0.00021 9.957179334322098e-08 0 9.959033596790687e-08 0 9.960033596790687e-08 0.00021 9.961033596790687e-08 0 9.961539927074449e-08 0 9.962539927074448e-08 0.00021 9.963539927074448e-08 0 9.964382297812552e-08 0 9.965382297812551e-08 0.00021 9.966382297812551e-08 0 9.976725065593207e-08 0 9.977725065593207e-08 0.00021 9.978725065593207e-08 0 9.980377406116921e-08 0 9.981377406116921e-08 0.00021 9.982377406116921e-08 0 1.0001250320198653e-07 0 1.0002250320198653e-07 0.00021 1.0003250320198652e-07 0 1.0025140188685262e-07 0 1.0026140188685261e-07 0.00021 1.0027140188685261e-07 0 1.005867340402476e-07 0 1.005967340402476e-07 0.00021 1.006067340402476e-07 0 1.0073164231214078e-07 0 1.0074164231214077e-07 0.00021 1.0075164231214077e-07 0 1.0088219404138438e-07 0 1.0089219404138438e-07 0.00021 1.0090219404138438e-07 0 1.0092027347027117e-07 0 1.0093027347027117e-07 0.00021 1.0094027347027117e-07 0 1.0098642342056662e-07 0 1.0099642342056661e-07 0.00021 1.0100642342056661e-07 0 1.0100642342056661e-07 0 1.0101642342056661e-07 0.00021 1.0102642342056661e-07 0 1.0113156570802397e-07 0 1.0114156570802397e-07 0.00021 1.0115156570802396e-07 0 1.0115156570802396e-07 0 1.0116156570802396e-07 0.00021 1.0117156570802396e-07 0 1.0123712219910984e-07 0 1.0124712219910984e-07 0.00021 1.0125712219910984e-07 0 1.0128840984101831e-07 0 1.0129840984101831e-07 0.00021 1.0130840984101831e-07 0 1.0130840984101831e-07 0 1.0131840984101831e-07 0.00021 1.013284098410183e-07 0 1.013284098410183e-07 0 1.013384098410183e-07 0.00021 1.013484098410183e-07 0 1.0145953413540265e-07 0 1.0146953413540265e-07 0.00021 1.0147953413540265e-07 0 1.0148350800881613e-07 0 1.0149350800881613e-07 0.00021 1.0150350800881613e-07 0 1.0156301585504707e-07 0 1.0157301585504706e-07 0.00021 1.0158301585504706e-07 0 1.0164479441814389e-07 0 1.0165479441814389e-07 0.00021 1.0166479441814389e-07 0 1.0167442759739404e-07 0 1.0168442759739403e-07 0.00021 1.0169442759739403e-07 0 1.0204053578693739e-07 0 1.0205053578693739e-07 0.00021 1.0206053578693739e-07 0 1.0207743070799906e-07 0 1.0208743070799906e-07 0.00021 1.0209743070799906e-07 0 1.0212777715867812e-07 0 1.0213777715867812e-07 0.00021 1.0214777715867812e-07 0 1.0216300167101849e-07 0 1.0217300167101848e-07 0.00021 1.0218300167101848e-07 0 1.0226076981568957e-07 0 1.0227076981568956e-07 0.00021 1.0228076981568956e-07 0 1.0245403143411336e-07 0 1.0246403143411336e-07 0.00021 1.0247403143411336e-07 0 1.0247403143411336e-07 0 1.0248403143411336e-07 0.00021 1.0249403143411336e-07 0 1.0249403143411336e-07 0 1.0250403143411335e-07 0.00021 1.0251403143411335e-07 0 1.0259617207392286e-07 0 1.0260617207392286e-07 0.00021 1.0261617207392285e-07 0 1.0261617207392285e-07 0 1.0262617207392285e-07 0.00021 1.0263617207392285e-07 0 1.0264587906908554e-07 0 1.0265587906908554e-07 0.00021 1.0266587906908554e-07 0 1.0275564808027169e-07 0 1.0276564808027169e-07 0.00021 1.0277564808027168e-07 0 1.0279101967860086e-07 0 1.0280101967860085e-07 0.00021 1.0281101967860085e-07 0 1.0287119526006393e-07 0 1.0288119526006393e-07 0.00021 1.0289119526006393e-07 0 1.0297137483720491e-07 0 1.0298137483720491e-07 0.00021 1.0299137483720491e-07 0 1.0313892166983601e-07 0 1.0314892166983601e-07 0.00021 1.03158921669836e-07 0 1.0323606663226717e-07 0 1.0324606663226717e-07 0.00021 1.0325606663226717e-07 0 1.0331673230284819e-07 0 1.0332673230284819e-07 0.00021 1.0333673230284819e-07 0 1.0334283125731766e-07 0 1.0335283125731766e-07 0.00021 1.0336283125731766e-07 0 1.0336283125731766e-07 0 1.0337283125731766e-07 0.00021 1.0338283125731765e-07 0 1.0338283125731765e-07 0 1.0339283125731765e-07 0.00021 1.0340283125731765e-07 0 1.0343941841038145e-07 0 1.0344941841038145e-07 0.00021 1.0345941841038145e-07 0 1.0348474083906774e-07 0 1.0349474083906774e-07 0.00021 1.0350474083906774e-07 0 1.0350474083906774e-07 0 1.0351474083906773e-07 0.00021 1.0352474083906773e-07 0 1.0359576881294546e-07 0 1.0360576881294546e-07 0.00021 1.0361576881294545e-07 0 1.0373997514240061e-07 0 1.0374997514240061e-07 0.00021 1.0375997514240061e-07 0 1.0388489415881976e-07 0 1.0389489415881975e-07 0.00021 1.0390489415881975e-07 0 1.0390489415881975e-07 0 1.0391489415881975e-07 0.00021 1.0392489415881975e-07 0 1.0409397608187074e-07 0 1.0410397608187073e-07 0.00021 1.0411397608187073e-07 0 1.0422670310929797e-07 0 1.0423670310929797e-07 0.00021 1.0424670310929797e-07 0 1.0427446768896547e-07 0 1.0428446768896546e-07 0.00021 1.0429446768896546e-07 0 1.0431240058936916e-07 0 1.0432240058936916e-07 0.00021 1.0433240058936916e-07 0 1.0437273218916343e-07 0 1.0438273218916343e-07 0.00021 1.0439273218916343e-07 0 1.0439273218916343e-07 0 1.0440273218916343e-07 0.00021 1.0441273218916343e-07 0 1.0441273218916343e-07 0 1.0442273218916342e-07 0.00021 1.0443273218916342e-07 0 1.0443273218916342e-07 0 1.0444273218916342e-07 0.00021 1.0445273218916342e-07 0 1.0445273218916342e-07 0 1.0446273218916342e-07 0.00021 1.0447273218916341e-07 0 1.0447273218916341e-07 0 1.0448273218916341e-07 0.00021 1.0449273218916341e-07 0 1.0449273218916341e-07 0 1.0450273218916341e-07 0.00021 1.045127321891634e-07 0 1.045127321891634e-07 0 1.045227321891634e-07 0.00021 1.045327321891634e-07 0 1.0456769236576833e-07 0 1.0457769236576833e-07 0.00021 1.0458769236576833e-07 0 1.0460510743304483e-07 0 1.0461510743304483e-07 0.00021 1.0462510743304483e-07 0 1.0462510743304483e-07 0 1.0463510743304483e-07 0.00021 1.0464510743304483e-07 0 1.0464510743304483e-07 0 1.0465510743304482e-07 0.00021 1.0466510743304482e-07 0 1.0467328366805728e-07 0 1.0468328366805727e-07 0.00021 1.0469328366805727e-07 0 1.0469328366805727e-07 0 1.0470328366805727e-07 0.00021 1.0471328366805727e-07 0 1.0478791449835454e-07 0 1.0479791449835454e-07 0.00021 1.0480791449835453e-07 0 1.0488317610630106e-07 0 1.0489317610630106e-07 0.00021 1.0490317610630106e-07 0 1.0494038182543e-07 0 1.0495038182543e-07 0.00021 1.0496038182543e-07 0 1.0497318232603658e-07 0 1.0498318232603658e-07 0.00021 1.0499318232603658e-07 0 1.0510314244178209e-07 0 1.0511314244178209e-07 0.00021 1.0512314244178208e-07 0 1.0514005911656884e-07 0 1.0515005911656883e-07 0.00021 1.0516005911656883e-07 0 1.0516922302149434e-07 0 1.0517922302149434e-07 0.00021 1.0518922302149434e-07 0 1.0520073917458394e-07 0 1.0521073917458394e-07 0.00021 1.0522073917458394e-07 0 1.0525696434765463e-07 0 1.0526696434765463e-07 0.00021 1.0527696434765463e-07 0 1.0527969330725387e-07 0 1.0528969330725387e-07 0.00021 1.0529969330725386e-07 0 1.0530108821127275e-07 0 1.0531108821127275e-07 0.00021 1.0532108821127275e-07 0 1.0565196705184602e-07 0 1.0566196705184602e-07 0.00021 1.0567196705184602e-07 0 1.0567196705184602e-07 0 1.0568196705184602e-07 0.00021 1.0569196705184602e-07 0 1.0569196705184602e-07 0 1.0570196705184602e-07 0.00021 1.0571196705184601e-07 0 1.0571196705184601e-07 0 1.0572196705184601e-07 0.00021 1.0573196705184601e-07 0 1.0577495093228453e-07 0 1.0578495093228453e-07 0.00021 1.0579495093228453e-07 0 1.0582365967325726e-07 0 1.0583365967325726e-07 0.00021 1.0584365967325725e-07 0 1.0584365967325725e-07 0 1.0585365967325725e-07 0.00021 1.0586365967325725e-07 0 1.0595144765201849e-07 0 1.0596144765201849e-07 0.00021 1.0597144765201848e-07 0 1.0597144765201848e-07 0 1.0598144765201848e-07 0.00021 1.0599144765201848e-07 0 1.0599144765201848e-07 0 1.0600144765201848e-07 0.00021 1.0601144765201848e-07 0 1.0603085988773907e-07 0 1.0604085988773907e-07 0.00021 1.0605085988773907e-07 0 1.0605085988773907e-07 0 1.0606085988773907e-07 0.00021 1.0607085988773906e-07 0 1.0607358734850619e-07 0 1.0608358734850618e-07 0.00021 1.0609358734850618e-07 0 1.0629921911326508e-07 0 1.0630921911326508e-07 0.00021 1.0631921911326507e-07 0 1.0660098149180661e-07 0 1.0661098149180661e-07 0.00021 1.0662098149180661e-07 0 1.066219683428967e-07 0 1.066319683428967e-07 0.00021 1.066419683428967e-07 0 1.0674427663832277e-07 0 1.0675427663832277e-07 0.00021 1.0676427663832277e-07 0 1.0681673412868568e-07 0 1.0682673412868567e-07 0.00021 1.0683673412868567e-07 0 1.0693172129054452e-07 0 1.0694172129054452e-07 0.00021 1.0695172129054451e-07 0 1.0698530154992266e-07 0 1.0699530154992266e-07 0.00021 1.0700530154992266e-07 0 1.070106066772024e-07 0 1.070206066772024e-07 0.00021 1.0703060667720239e-07 0 1.0714802207042157e-07 0 1.0715802207042156e-07 0.00021 1.0716802207042156e-07 0 1.0745074216515671e-07 0 1.0746074216515671e-07 0.00021 1.0747074216515671e-07 0 1.075352005927231e-07 0 1.075452005927231e-07 0.00021 1.075552005927231e-07 0 1.0768306359028195e-07 0 1.0769306359028195e-07 0.00021 1.0770306359028195e-07 0 1.0770306359028195e-07 0 1.0771306359028194e-07 0.00021 1.0772306359028194e-07 0 1.0775116394126067e-07 0 1.0776116394126067e-07 0.00021 1.0777116394126067e-07 0 1.0778572987878662e-07 0 1.0779572987878662e-07 0.00021 1.0780572987878661e-07 0 1.0793624494058386e-07 0 1.0794624494058386e-07 0.00021 1.0795624494058386e-07 0 1.0795624494058386e-07 0 1.0796624494058386e-07 0.00021 1.0797624494058386e-07 0 1.0800176702543704e-07 0 1.0801176702543704e-07 0.00021 1.0802176702543704e-07 0 1.0804315755995421e-07 0 1.0805315755995421e-07 0.00021 1.080631575599542e-07 0 1.080828368041025e-07 0 1.080928368041025e-07 0.00021 1.081028368041025e-07 0 1.082086734380466e-07 0 1.082186734380466e-07 0.00021 1.082286734380466e-07 0 1.082286734380466e-07 0 1.082386734380466e-07 0.00021 1.0824867343804659e-07 0 1.0842568054762557e-07 0 1.0843568054762556e-07 0.00021 1.0844568054762556e-07 0 1.0844568054762556e-07 0 1.0845568054762556e-07 0.00021 1.0846568054762556e-07 0 1.085104440354e-07 0 1.085204440354e-07 0.00021 1.085304440354e-07 0 1.0864310408420873e-07 0 1.0865310408420873e-07 0.00021 1.0866310408420873e-07 0 1.087190534519559e-07 0 1.087290534519559e-07 0.00021 1.087390534519559e-07 0 1.0918952862080839e-07 0 1.0919952862080839e-07 0.00021 1.0920952862080839e-07 0 1.0934648666416864e-07 0 1.0935648666416864e-07 0.00021 1.0936648666416864e-07 0 1.0944067520998614e-07 0 1.0945067520998614e-07 0.00021 1.0946067520998614e-07 0 1.0947746703360807e-07 0 1.0948746703360806e-07 0.00021 1.0949746703360806e-07 0 1.0953084168850907e-07 0 1.0954084168850907e-07 0.00021 1.0955084168850907e-07 0 1.0964438788121908e-07 0 1.0965438788121908e-07 0.00021 1.0966438788121907e-07 0 1.0967231348814186e-07 0 1.0968231348814186e-07 0.00021 1.0969231348814186e-07 0 1.097122163573198e-07 0 1.097222163573198e-07 0.00021 1.097322163573198e-07 0 1.098652761305814e-07 0 1.098752761305814e-07 0.00021 1.098852761305814e-07 0 1.0999095302579895e-07 0 1.1000095302579895e-07 0.00021 1.1001095302579895e-07 0 1.1019780970024074e-07 0 1.1020780970024073e-07 0.00021 1.1021780970024073e-07 0 1.1042327116673105e-07 0 1.1043327116673105e-07 0.00021 1.1044327116673105e-07 0 1.1049594654498575e-07 0 1.1050594654498575e-07 0.00021 1.1051594654498575e-07 0 1.1064632453098676e-07 0 1.1065632453098676e-07 0.00021 1.1066632453098676e-07 0 1.1108599648365416e-07 0 1.1109599648365416e-07 0.00021 1.1110599648365416e-07 0 1.1111500796853383e-07 0 1.1112500796853382e-07 0.00021 1.1113500796853382e-07 0 1.1114691767847617e-07 0 1.1115691767847617e-07 0.00021 1.1116691767847617e-07 0 1.111805715314501e-07 0 1.111905715314501e-07 0.00021 1.112005715314501e-07 0 1.112651706830988e-07 0 1.112751706830988e-07 0.00021 1.112851706830988e-07 0 1.1133802975098927e-07 0 1.1134802975098927e-07 0.00021 1.1135802975098927e-07 0 1.1138097834293598e-07 0 1.1139097834293597e-07 0.00021 1.1140097834293597e-07 0 1.1140097834293597e-07 0 1.1141097834293597e-07 0.00021 1.1142097834293597e-07 0 1.1178598678722421e-07 0 1.1179598678722421e-07 0.00021 1.118059867872242e-07 0 1.1181131803642084e-07 0 1.1182131803642084e-07 0.00021 1.1183131803642083e-07 0 1.1186235239770369e-07 0 1.1187235239770369e-07 0.00021 1.1188235239770369e-07 0 1.1199519497963952e-07 0 1.1200519497963952e-07 0.00021 1.1201519497963952e-07 0 1.1225689478352311e-07 0 1.1226689478352311e-07 0.00021 1.1227689478352311e-07 0 1.1231142716546596e-07 0 1.1232142716546596e-07 0.00021 1.1233142716546596e-07 0 1.1236098239089852e-07 0 1.1237098239089851e-07 0.00021 1.1238098239089851e-07 0 1.1238098239089851e-07 0 1.1239098239089851e-07 0.00021 1.1240098239089851e-07 0 1.1245730651347148e-07 0 1.1246730651347147e-07 0.00021 1.1247730651347147e-07 0 1.1251019182524879e-07 0 1.1252019182524879e-07 0.00021 1.1253019182524879e-07 0 1.1253720060635078e-07 0 1.1254720060635078e-07 0.00021 1.1255720060635078e-07 0 1.1267805545884599e-07 0 1.1268805545884599e-07 0.00021 1.1269805545884599e-07 0 1.1277590949173307e-07 0 1.1278590949173307e-07 0.00021 1.1279590949173307e-07 0 1.1286810520009029e-07 0 1.1287810520009029e-07 0.00021 1.1288810520009029e-07 0 1.1291368170435356e-07 0 1.1292368170435356e-07 0.00021 1.1293368170435356e-07 0 1.1300384209141049e-07 0 1.1301384209141049e-07 0.00021 1.1302384209141049e-07 0 1.1356965702190564e-07 0 1.1357965702190564e-07 0.00021 1.1358965702190564e-07 0 1.1358965702190564e-07 0 1.1359965702190563e-07 0.00021 1.1360965702190563e-07 0 1.1377039480963965e-07 0 1.1378039480963965e-07 0.00021 1.1379039480963965e-07 0 1.1381308955057643e-07 0 1.1382308955057642e-07 0.00021 1.1383308955057642e-07 0 1.138619105468593e-07 0 1.138719105468593e-07 0.00021 1.138819105468593e-07 0 1.138819105468593e-07 0 1.138919105468593e-07 0.00021 1.139019105468593e-07 0 1.1402321307197503e-07 0 1.1403321307197503e-07 0.00021 1.1404321307197503e-07 0 1.1404321307197503e-07 0 1.1405321307197502e-07 0.00021 1.1406321307197502e-07 0 1.1406321307197502e-07 0 1.1407321307197502e-07 0.00021 1.1408321307197502e-07 0 1.1413817248982629e-07 0 1.1414817248982629e-07 0.00021 1.1415817248982629e-07 0 1.1415817248982629e-07 0 1.1416817248982628e-07 0.00021 1.1417817248982628e-07 0 1.1428302098090104e-07 0 1.1429302098090103e-07 0.00021 1.1430302098090103e-07 0 1.143096191684646e-07 0 1.143196191684646e-07 0.00021 1.143296191684646e-07 0 1.1457649239323071e-07 0 1.1458649239323071e-07 0.00021 1.145964923932307e-07 0 1.145964923932307e-07 0 1.146064923932307e-07 0.00021 1.146164923932307e-07 0 1.146164923932307e-07 0 1.146264923932307e-07 0.00021 1.146364923932307e-07 0 1.1463984136693206e-07 0 1.1464984136693206e-07 0.00021 1.1465984136693205e-07 0 1.146776253079916e-07 0 1.146876253079916e-07 0.00021 1.146976253079916e-07 0 1.1471523190945133e-07 0 1.1472523190945133e-07 0.00021 1.1473523190945133e-07 0 1.1473523190945133e-07 0 1.1474523190945132e-07 0.00021 1.1475523190945132e-07 0 1.1477980135947343e-07 0 1.1478980135947343e-07 0.00021 1.1479980135947343e-07 0 1.1481652808367584e-07 0 1.1482652808367584e-07 0.00021 1.1483652808367584e-07 0 1.1489491121950494e-07 0 1.1490491121950494e-07 0.00021 1.1491491121950494e-07 0 1.1519353045894277e-07 0 1.1520353045894277e-07 0.00021 1.1521353045894277e-07 0 1.1521353045894277e-07 0 1.1522353045894277e-07 0.00021 1.1523353045894277e-07 0 1.152470459511199e-07 0 1.1525704595111989e-07 0.00021 1.1526704595111989e-07 0 1.1526704595111989e-07 0 1.1527704595111989e-07 0.00021 1.1528704595111989e-07 0 1.1549212813709817e-07 0 1.1550212813709817e-07 0.00021 1.1551212813709817e-07 0 1.1551212813709817e-07 0 1.1552212813709817e-07 0.00021 1.1553212813709817e-07 0 1.1553212813709817e-07 0 1.1554212813709816e-07 0.00021 1.1555212813709816e-07 0 1.1561006988827048e-07 0 1.1562006988827048e-07 0.00021 1.1563006988827048e-07 0 1.1563006988827048e-07 0 1.1564006988827048e-07 0.00021 1.1565006988827047e-07 0 1.1565006988827047e-07 0 1.1566006988827047e-07 0.00021 1.1567006988827047e-07 0 1.1573996046928016e-07 0 1.1574996046928016e-07 0.00021 1.1575996046928015e-07 0 1.1575996046928015e-07 0 1.1576996046928015e-07 0.00021 1.1577996046928015e-07 0 1.1577996046928015e-07 0 1.1578996046928015e-07 0.00021 1.1579996046928015e-07 0 1.1584315158047978e-07 0 1.1585315158047978e-07 0.00021 1.1586315158047978e-07 0 1.1593746104005236e-07 0 1.1594746104005235e-07 0.00021 1.1595746104005235e-07 0 1.1600519669347521e-07 0 1.1601519669347521e-07 0.00021 1.1602519669347521e-07 0 1.1606730333529973e-07 0 1.1607730333529973e-07 0.00021 1.1608730333529973e-07 0 1.1612360252632551e-07 0 1.161336025263255e-07 0.00021 1.161436025263255e-07 0 1.1614754951545455e-07 0 1.1615754951545455e-07 0.00021 1.1616754951545454e-07 0 1.1617182809504473e-07 0 1.1618182809504473e-07 0.00021 1.1619182809504473e-07 0 1.1622700986918428e-07 0 1.1623700986918428e-07 0.00021 1.1624700986918428e-07 0 1.1630971672392891e-07 0 1.1631971672392891e-07 0.00021 1.1632971672392891e-07 0 1.165098926126524e-07 0 1.165198926126524e-07 0.00021 1.165298926126524e-07 0 1.165304460720212e-07 0 1.165404460720212e-07 0.00021 1.165504460720212e-07 0 1.1671194693945833e-07 0 1.1672194693945833e-07 0.00021 1.1673194693945833e-07 0 1.1684370430080417e-07 0 1.1685370430080417e-07 0.00021 1.1686370430080417e-07 0 1.1689759183567519e-07 0 1.1690759183567519e-07 0.00021 1.1691759183567519e-07 0 1.1705233197436462e-07 0 1.1706233197436462e-07 0.00021 1.1707233197436462e-07 0 1.1707233197436462e-07 0 1.1708233197436462e-07 0.00021 1.1709233197436461e-07 0 1.1709233197436461e-07 0 1.1710233197436461e-07 0.00021 1.1711233197436461e-07 0 1.1711233197436461e-07 0 1.1712233197436461e-07 0.00021 1.1713233197436461e-07 0 1.1713233197436461e-07 0 1.171423319743646e-07 0.00021 1.171523319743646e-07 0 1.17176168838286e-07 0 1.17186168838286e-07 0.00021 1.17196168838286e-07 0 1.1751957294438817e-07 0 1.1752957294438816e-07 0.00021 1.1753957294438816e-07 0 1.1759865723613642e-07 0 1.1760865723613642e-07 0.00021 1.1761865723613642e-07 0 1.176947901438958e-07 0 1.177047901438958e-07 0.00021 1.177147901438958e-07 0 1.1771821080574624e-07 0 1.1772821080574623e-07 0.00021 1.1773821080574623e-07 0 1.1795924881314528e-07 0 1.1796924881314528e-07 0.00021 1.1797924881314528e-07 0 1.1797972912154678e-07 0 1.1798972912154678e-07 0.00021 1.1799972912154677e-07 0 1.1838251115790716e-07 0 1.1839251115790716e-07 0.00021 1.1840251115790716e-07 0 1.1841656382571556e-07 0 1.1842656382571556e-07 0.00021 1.1843656382571556e-07 0 1.1844801462657028e-07 0 1.1845801462657028e-07 0.00021 1.1846801462657028e-07 0 1.1846801462657028e-07 0 1.1847801462657028e-07 0.00021 1.1848801462657028e-07 0 1.1848801462657028e-07 0 1.1849801462657027e-07 0.00021 1.1850801462657027e-07 0 1.1850801462657027e-07 0 1.1851801462657027e-07 0.00021 1.1852801462657027e-07 0 1.1852801462657027e-07 0 1.1853801462657027e-07 0.00021 1.1854801462657026e-07 0 1.1854801462657026e-07 0 1.1855801462657026e-07 0.00021 1.1856801462657026e-07 0 1.1856801462657026e-07 0 1.1857801462657026e-07 0.00021 1.1858801462657026e-07 0 1.1875339101382562e-07 0 1.1876339101382562e-07 0.00021 1.1877339101382562e-07 0 1.1877339101382562e-07 0 1.1878339101382562e-07 0.00021 1.1879339101382562e-07 0 1.1879339101382562e-07 0 1.1880339101382561e-07 0.00021 1.1881339101382561e-07 0 1.1882242969019859e-07 0 1.1883242969019859e-07 0.00021 1.1884242969019858e-07 0 1.1885024859759175e-07 0 1.1886024859759174e-07 0.00021 1.1887024859759174e-07 0 1.189172378229339e-07 0 1.189272378229339e-07 0.00021 1.189372378229339e-07 0 1.1893765782438504e-07 0 1.1894765782438503e-07 0.00021 1.1895765782438503e-07 0 1.1907329873481304e-07 0 1.1908329873481304e-07 0.00021 1.1909329873481303e-07 0 1.1917738274003666e-07 0 1.1918738274003666e-07 0.00021 1.1919738274003666e-07 0 1.1920122478743795e-07 0 1.1921122478743795e-07 0.00021 1.1922122478743796e-07 0 1.1934962918149356e-07 0 1.1935962918149357e-07 0.00021 1.1936962918149358e-07 0 1.1938140035087408e-07 0 1.193914003508741e-07 0.00021 1.194014003508741e-07 0 1.1948613664152037e-07 0 1.1949613664152038e-07 0.00021 1.195061366415204e-07 0 1.1954459389944296e-07 0 1.1955459389944297e-07 0.00021 1.1956459389944298e-07 0 1.1956459389944296e-07 0 1.1957459389944297e-07 0.00021 1.1958459389944298e-07 0 1.1959245070024218e-07 0 1.196024507002422e-07 0.00021 1.196124507002422e-07 0 1.196535849295619e-07 0 1.1966358492956191e-07 0.00021 1.1967358492956192e-07 0 1.1967979687878064e-07 0 1.1968979687878065e-07 0.00021 1.1969979687878066e-07 0 1.1969979687878064e-07 0 1.1970979687878065e-07 0.00021 1.1971979687878066e-07 0 1.19897576909748e-07 0 1.1990757690974802e-07 0.00021 1.1991757690974803e-07 0 1.199517564643264e-07 0 1.199617564643264e-07 0.00021 1.1997175646432641e-07 0 1.2022009996938205e-07 0 1.2023009996938207e-07 0.00021 1.2024009996938208e-07 0 1.2026121163448236e-07 0 1.2027121163448237e-07 0.00021 1.2028121163448238e-07 0 1.2028657960025313e-07 0 1.2029657960025314e-07 0.00021 1.2030657960025316e-07 0 1.2039616375323995e-07 0 1.2040616375323997e-07 0.00021 1.2041616375323998e-07 0 1.2044130855216976e-07 0 1.2045130855216977e-07 0.00021 1.2046130855216978e-07 0 1.2051687124475152e-07 0 1.2052687124475153e-07 0.00021 1.2053687124475154e-07 0 1.205454317053073e-07 0 1.205554317053073e-07 0.00021 1.205654317053073e-07 0 1.206046982657453e-07 0 1.206146982657453e-07 0.00021 1.206246982657453e-07 0 1.2062469826574528e-07 0 1.206346982657453e-07 0.00021 1.206446982657453e-07 0 1.2080651728977005e-07 0 1.2081651728977006e-07 0.00021 1.2082651728977007e-07 0 1.208508254911107e-07 0 1.2086082549111072e-07 0.00021 1.2087082549111073e-07 0 1.2087331526691636e-07 0 1.2088331526691638e-07 0.00021 1.208933152669164e-07 0 1.2112231435457156e-07 0 1.2113231435457157e-07 0.00021 1.2114231435457158e-07 0 1.2114231435457155e-07 0 1.2115231435457156e-07 0.00021 1.2116231435457158e-07 0 1.211734429360814e-07 0 1.211834429360814e-07 0.00021 1.2119344293608142e-07 0 1.211934429360814e-07 0 1.212034429360814e-07 0.00021 1.2121344293608142e-07 0 1.212134429360814e-07 0 1.212234429360814e-07 0.00021 1.2123344293608141e-07 0 1.2149319585883842e-07 0 1.2150319585883843e-07 0.00021 1.2151319585883845e-07 0 1.2151319585883842e-07 0 1.2152319585883843e-07 0.00021 1.2153319585883844e-07 0 1.2157923767555313e-07 0 1.2158923767555314e-07 0.00021 1.2159923767555315e-07 0 1.217347622678442e-07 0 1.217447622678442e-07 0.00021 1.217547622678442e-07 0 1.219924607472835e-07 0 1.220024607472835e-07 0.00021 1.220124607472835e-07 0 1.2213183782318417e-07 0 1.2214183782318418e-07 0.00021 1.221518378231842e-07 0 1.2218020809155308e-07 0 1.221902080915531e-07 0.00021 1.222002080915531e-07 0 1.2237706973136535e-07 0 1.2238706973136537e-07 0.00021 1.2239706973136538e-07 0 1.2239706973136535e-07 0 1.2240706973136536e-07 0.00021 1.2241706973136537e-07 0 1.2242177986359856e-07 0 1.2243177986359857e-07 0.00021 1.2244177986359858e-07 0 1.2244177986359855e-07 0 1.2245177986359857e-07 0.00021 1.2246177986359858e-07 0 1.225487472457282e-07 0 1.2255874724572822e-07 0.00021 1.2256874724572823e-07 0 1.226463901548698e-07 0 1.226563901548698e-07 0.00021 1.2266639015486982e-07 0 1.227594554296498e-07 0 1.227694554296498e-07 0.00021 1.227794554296498e-07 0 1.2277945542964979e-07 0 1.227894554296498e-07 0.00021 1.227994554296498e-07 0 1.2279945542964978e-07 0 1.228094554296498e-07 0.00021 1.228194554296498e-07 0 1.228658284292289e-07 0 1.2287582842922892e-07 0.00021 1.2288582842922893e-07 0 1.2295831227159813e-07 0 1.2296831227159814e-07 0.00021 1.2297831227159815e-07 0 1.23031447038003e-07 0 1.23041447038003e-07 0.00021 1.2305144703800302e-07 0 1.2311303890524656e-07 0 1.2312303890524657e-07 0.00021 1.2313303890524658e-07 0 1.2322965464429113e-07 0 1.2323965464429114e-07 0.00021 1.2324965464429115e-07 0 1.2324965464429112e-07 0 1.2325965464429113e-07 0.00021 1.2326965464429114e-07 0 1.2346188675387122e-07 0 1.2347188675387123e-07 0.00021 1.2348188675387124e-07 0 1.2362223128064198e-07 0 1.23632231280642e-07 0.00021 1.23642231280642e-07 0 1.2366819653123925e-07 0 1.2367819653123927e-07 0.00021 1.2368819653123928e-07 0 1.2373305558162492e-07 0 1.2374305558162493e-07 0.00021 1.2375305558162494e-07 0 1.2384601534873123e-07 0 1.2385601534873124e-07 0.00021 1.2386601534873125e-07 0 1.2390998077895808e-07 0 1.239199807789581e-07 0.00021 1.239299807789581e-07 0 1.2401171891433635e-07 0 1.2402171891433637e-07 0.00021 1.2403171891433638e-07 0 1.2403171891433635e-07 0 1.2404171891433636e-07 0.00021 1.2405171891433637e-07 0 1.2405171891433635e-07 0 1.2406171891433636e-07 0.00021 1.2407171891433637e-07 0 1.2407171891433634e-07 0 1.2408171891433635e-07 0.00021 1.2409171891433637e-07 0 1.2409171891433634e-07 0 1.2410171891433635e-07 0.00021 1.2411171891433636e-07 0 1.2414929222862283e-07 0 1.2415929222862284e-07 0.00021 1.2416929222862285e-07 0 1.2418389162244253e-07 0 1.2419389162244254e-07 0.00021 1.2420389162244255e-07 0 1.2422486080874532e-07 0 1.2423486080874533e-07 0.00021 1.2424486080874534e-07 0 1.243249554391136e-07 0 1.243349554391136e-07 0.00021 1.2434495543911362e-07 0 1.244542781901281e-07 0 1.244642781901281e-07 0.00021 1.2447427819012812e-07 0 1.245530597993106e-07 0 1.245630597993106e-07 0.00021 1.2457305979931062e-07 0 1.245730597993106e-07 0 1.245830597993106e-07 0.00021 1.2459305979931062e-07 0 1.245930597993106e-07 0 1.246030597993106e-07 0.00021 1.2461305979931062e-07 0 1.2464195551161423e-07 0 1.2465195551161425e-07 0.00021 1.2466195551161426e-07 0 1.2499853612121828e-07 0 1.250085361212183e-07 0.00021 1.250185361212183e-07 0 1.250777848462739e-07 0 1.250877848462739e-07 0.00021 1.250977848462739e-07 0 1.2516320792429713e-07 0 1.2517320792429714e-07 0.00021 1.2518320792429715e-07 0 1.2525584793596018e-07 0 1.252658479359602e-07 0.00021 1.252758479359602e-07 0 1.2537081534466973e-07 0 1.2538081534466974e-07 0.00021 1.2539081534466975e-07 0 1.25451693591455e-07 0 1.25461693591455e-07 0.00021 1.2547169359145502e-07 0 1.2547673811326827e-07 0 1.2548673811326828e-07 0.00021 1.254967381132683e-07 0 1.2554311665984412e-07 0 1.2555311665984413e-07 0.00021 1.2556311665984414e-07 0 1.257155038644814e-07 0 1.2572550386448142e-07 0.00021 1.2573550386448143e-07 0 1.2575944191657697e-07 0 1.2576944191657698e-07 0.00021 1.25779441916577e-07 0 1.2584124806748449e-07 0 1.258512480674845e-07 0.00021 1.258612480674845e-07 0 1.260778964377919e-07 0 1.2608789643779192e-07 0.00021 1.2609789643779193e-07 0 1.2611971467124385e-07 0 1.2612971467124386e-07 0.00021 1.2613971467124387e-07 0 1.2618697624094713e-07 0 1.2619697624094715e-07 0.00021 1.2620697624094716e-07 0 1.2642718443629516e-07 0 1.2643718443629517e-07 0.00021 1.2644718443629518e-07 0 1.2651820943467157e-07 0 1.2652820943467158e-07 0.00021 1.265382094346716e-07 0 1.2662210588308054e-07 0 1.2663210588308055e-07 0.00021 1.2664210588308057e-07 0 1.2664210588308054e-07 0 1.2665210588308055e-07 0.00021 1.2666210588308056e-07 0 1.266921529749388e-07 0 1.267021529749388e-07 0.00021 1.267121529749388e-07 0 1.268487114214421e-07 0 1.268587114214421e-07 0.00021 1.2686871142144212e-07 0 1.2699467081106541e-07 0 1.2700467081106543e-07 0.00021 1.2701467081106544e-07 0 1.2711482094564327e-07 0 1.2712482094564328e-07 0.00021 1.271348209456433e-07 0 1.2715121531334339e-07 0 1.271612153133434e-07 0.00021 1.271712153133434e-07 0 1.2722548150224578e-07 0 1.272354815022458e-07 0.00021 1.272454815022458e-07 0 1.273184753492377e-07 0 1.273284753492377e-07 0.00021 1.2733847534923772e-07 0 1.273384753492377e-07 0 1.273484753492377e-07 0.00021 1.2735847534923772e-07 0 1.273584753492377e-07 0 1.273684753492377e-07 0.00021 1.273784753492377e-07 0 1.2737847534923769e-07 0 1.273884753492377e-07 0.00021 1.273984753492377e-07 0 1.274887217312725e-07 0 1.2749872173127252e-07 0.00021 1.2750872173127253e-07 0 1.275087217312725e-07 0 1.2751872173127251e-07 0.00021 1.2752872173127252e-07 0 1.275287217312725e-07 0 1.275387217312725e-07 0.00021 1.2754872173127252e-07 0 1.275487217312725e-07 0 1.275587217312725e-07 0.00021 1.2756872173127252e-07 0 1.276049198226715e-07 0 1.276149198226715e-07 0.00021 1.2762491982267152e-07 0 1.2765214478901802e-07 0 1.2766214478901803e-07 0.00021 1.2767214478901805e-07 0 1.2774960309649326e-07 0 1.2775960309649327e-07 0.00021 1.2776960309649328e-07 0 1.2776960309649325e-07 0 1.2777960309649326e-07 0.00021 1.2778960309649328e-07 0 1.2783973193962865e-07 0 1.2784973193962866e-07 0.00021 1.2785973193962867e-07 0 1.2785973193962864e-07 0 1.2786973193962865e-07 0.00021 1.2787973193962866e-07 0 1.2787973193962864e-07 0 1.2788973193962865e-07 0.00021 1.2789973193962866e-07 0 1.2795457356333006e-07 0 1.2796457356333007e-07 0.00021 1.2797457356333008e-07 0 1.2810943703162402e-07 0 1.2811943703162404e-07 0.00021 1.2812943703162405e-07 0 1.2812943703162402e-07 0 1.2813943703162403e-07 0.00021 1.2814943703162404e-07 0 1.2821818319153704e-07 0 1.2822818319153705e-07 0.00021 1.2823818319153706e-07 0 1.2830523645582453e-07 0 1.2831523645582454e-07 0.00021 1.2832523645582455e-07 0 1.2832523645582452e-07 0 1.2833523645582453e-07 0.00021 1.2834523645582454e-07 0 1.2834954200770246e-07 0 1.2835954200770247e-07 0.00021 1.2836954200770248e-07 0 1.2836954200770245e-07 0 1.2837954200770246e-07 0.00021 1.2838954200770247e-07 0 1.2839867800548169e-07 0 1.284086780054817e-07 0.00021 1.284186780054817e-07 0 1.2844385407826903e-07 0 1.2845385407826904e-07 0.00021 1.2846385407826905e-07 0 1.2848192495443102e-07 0 1.2849192495443103e-07 0.00021 1.2850192495443104e-07 0 1.285977379316485e-07 0 1.286077379316485e-07 0.00021 1.2861773793164851e-07 0 1.286177379316485e-07 0 1.286277379316485e-07 0.00021 1.286377379316485e-07 0 1.2863773793164848e-07 0 1.286477379316485e-07 0.00021 1.286577379316485e-07 0 1.2881296478901485e-07 0 1.2882296478901486e-07 0.00021 1.2883296478901487e-07 0 1.2883296478901484e-07 0 1.2884296478901486e-07 0.00021 1.2885296478901487e-07 0 1.2886636789102833e-07 0 1.2887636789102834e-07 0.00021 1.2888636789102836e-07 0 1.2900298318041116e-07 0 1.2901298318041117e-07 0.00021 1.2902298318041118e-07 0 1.2926562752698344e-07 0 1.2927562752698345e-07 0.00021 1.2928562752698346e-07 0 1.2931735635849342e-07 0 1.2932735635849343e-07 0.00021 1.2933735635849344e-07 0 1.2941612874370968e-07 0 1.294261287437097e-07 0.00021 1.294361287437097e-07 0 1.2953538528848888e-07 0 1.295453852884889e-07 0.00021 1.295553852884889e-07 0 1.29620201281982e-07 0 1.2963020128198202e-07 0.00021 1.2964020128198204e-07 0 1.2967216176479468e-07 0 1.296821617647947e-07 0.00021 1.296921617647947e-07 0 1.2983400462773788e-07 0 1.2984400462773789e-07 0.00021 1.298540046277379e-07 0 1.2985400462773787e-07 0 1.2986400462773788e-07 0.00021 1.298740046277379e-07 0 1.2994349906437074e-07 0 1.2995349906437075e-07 0.00021 1.2996349906437077e-07 0 1.2996349906437074e-07 0 1.2997349906437075e-07 0.00021 1.2998349906437076e-07 0 1.3010172514909192e-07 0 1.3011172514909194e-07 0.00021 1.3012172514909195e-07 0 1.3018682137151073e-07 0 1.3019682137151074e-07 0.00021 1.3020682137151075e-07 0 1.3023120174342442e-07 0 1.3024120174342443e-07 0.00021 1.3025120174342444e-07 0 1.3039108287539262e-07 0 1.3040108287539263e-07 0.00021 1.3041108287539264e-07 0 1.3047383316674602e-07 0 1.3048383316674603e-07 0.00021 1.3049383316674604e-07 0 1.30493833166746e-07 0 1.3050383316674602e-07 0.00021 1.3051383316674604e-07 0 1.3062081738380327e-07 0 1.3063081738380328e-07 0.00021 1.306408173838033e-07 0 1.3065152010222836e-07 0 1.3066152010222837e-07 0.00021 1.3067152010222838e-07 0 1.3067152010222835e-07 0 1.3068152010222836e-07 0.00021 1.3069152010222838e-07 0 1.30765454848917e-07 0 1.3077545484891702e-07 0.00021 1.3078545484891704e-07 0 1.3087200084295322e-07 0 1.3088200084295323e-07 0.00021 1.3089200084295324e-07 0 1.311633554268255e-07 0 1.311733554268255e-07 0.00021 1.3118335542682552e-07 0 1.313453552321127e-07 0 1.3135535523211272e-07 0.00021 1.3136535523211273e-07 0 1.314197651090757e-07 0 1.3142976510907572e-07 0.00021 1.3143976510907573e-07 0 1.314658297772622e-07 0 1.314758297772622e-07 0.00021 1.3148582977726221e-07 0 1.3169499061593852e-07 0 1.3170499061593853e-07 0.00021 1.3171499061593854e-07 0 1.317149906159385e-07 0 1.3172499061593852e-07 0.00021 1.3173499061593853e-07 0 1.317349906159385e-07 0 1.3174499061593852e-07 0.00021 1.3175499061593853e-07 0 1.317549906159385e-07 0 1.3176499061593852e-07 0.00021 1.3177499061593853e-07 0 1.317749906159385e-07 0 1.317849906159385e-07 0.00021 1.3179499061593852e-07 0 1.318326473117752e-07 0 1.3184264731177521e-07 0.00021 1.3185264731177522e-07 0 1.3200325063184351e-07 0 1.3201325063184352e-07 0.00021 1.3202325063184354e-07 0 1.3205125592869716e-07 0 1.3206125592869717e-07 0.00021 1.3207125592869718e-07 0 1.3212235135443445e-07 0 1.3213235135443446e-07 0.00021 1.3214235135443447e-07 0 1.3214235135443445e-07 0 1.3215235135443446e-07 0.00021 1.3216235135443447e-07 0 1.3226135434890143e-07 0 1.3227135434890144e-07 0.00021 1.3228135434890145e-07 0 1.3228135434890143e-07 0 1.3229135434890144e-07 0.00021 1.3230135434890145e-07 0 1.3230601975854657e-07 0 1.3231601975854659e-07 0.00021 1.323260197585466e-07 0 1.3234686857966685e-07 0 1.3235686857966686e-07 0.00021 1.3236686857966687e-07 0 1.324470435352149e-07 0 1.3245704353521492e-07 0.00021 1.3246704353521493e-07 0 1.3247417081363714e-07 0 1.3248417081363716e-07 0.00021 1.3249417081363717e-07 0 1.3298250738441537e-07 0 1.3299250738441538e-07 0.00021 1.330025073844154e-07 0 1.330525569056079e-07 0 1.330625569056079e-07 0.00021 1.3307255690560792e-07 0 1.3307385920790933e-07 0 1.3308385920790934e-07 0.00021 1.3309385920790935e-07 0 1.335110896104805e-07 0 1.3352108961048052e-07 0.00021 1.3353108961048053e-07 0 1.3357110644153235e-07 0 1.3358110644153236e-07 0.00021 1.3359110644153237e-07 0 1.3365777341798375e-07 0 1.3366777341798376e-07 0.00021 1.3367777341798377e-07 0 1.3374851193090008e-07 0 1.337585119309001e-07 0.00021 1.337685119309001e-07 0 1.3393236380652373e-07 0 1.3394236380652374e-07 0.00021 1.3395236380652376e-07 0 1.3403843207895806e-07 0 1.3404843207895807e-07 0.00021 1.3405843207895808e-07 0 1.3407284573433683e-07 0 1.3408284573433685e-07 0.00021 1.3409284573433686e-07 0 1.3412142607649173e-07 0 1.3413142607649174e-07 0.00021 1.3414142607649175e-07 0 1.3414142607649173e-07 0 1.3415142607649174e-07 0.00021 1.3416142607649175e-07 0 1.342067092979193e-07 0 1.3421670929791932e-07 0.00021 1.3422670929791933e-07 0 1.344847662744514e-07 0 1.3449476627445142e-07 0.00021 1.3450476627445143e-07 0 1.347281801768569e-07 0 1.3473818017685692e-07 0.00021 1.3474818017685693e-07 0 1.3480289208670234e-07 0 1.3481289208670235e-07 0.00021 1.3482289208670237e-07 0 1.3482289208670234e-07 0 1.3483289208670235e-07 0.00021 1.3484289208670236e-07 0 1.3486433551832345e-07 0 1.3487433551832346e-07 0.00021 1.3488433551832347e-07 0 1.348967170187597e-07 0 1.349067170187597e-07 0.00021 1.349167170187597e-07 0 1.3497844361408843e-07 0 1.3498844361408844e-07 0.00021 1.3499844361408845e-07 0 1.3522620015509275e-07 0 1.3523620015509276e-07 0.00021 1.3524620015509277e-07 0 1.35249559180865e-07 0 1.35259559180865e-07 0.00021 1.3526955918086502e-07 0 1.3534284515615652e-07 0 1.3535284515615653e-07 0.00021 1.3536284515615655e-07 0 1.3550097325131626e-07 0 1.3551097325131627e-07 0.00021 1.3552097325131628e-07 0 1.355703937404237e-07 0 1.355803937404237e-07 0.00021 1.3559039374042372e-07 0 1.355903937404237e-07 0 1.356003937404237e-07 0.00021 1.3561039374042372e-07 0 1.3578179480749812e-07 0 1.3579179480749813e-07 0.00021 1.3580179480749814e-07 0 1.3587374088275696e-07 0 1.3588374088275697e-07 0.00021 1.3589374088275698e-07 0 1.359682621682396e-07 0 1.3597826216823962e-07 0.00021 1.3598826216823963e-07 0 1.3601049818494905e-07 0 1.3602049818494906e-07 0.00021 1.3603049818494908e-07 0 1.3604250782695364e-07 0 1.3605250782695365e-07 0.00021 1.3606250782695366e-07 0 1.3609915283353622e-07 0 1.3610915283353623e-07 0.00021 1.3611915283353624e-07 0 1.3627553422499564e-07 0 1.3628553422499565e-07 0.00021 1.3629553422499566e-07 0 1.365766971458587e-07 0 1.3658669714585872e-07 0.00021 1.3659669714585873e-07 0 1.365966971458587e-07 0 1.3660669714585872e-07 0.00021 1.3661669714585873e-07 0 1.3695277988902232e-07 0 1.3696277988902233e-07 0.00021 1.3697277988902234e-07 0 1.369745354653207e-07 0 1.369845354653207e-07 0.00021 1.3699453546532072e-07 0 1.3700978017060088e-07 0 1.370197801706009e-07 0.00021 1.370297801706009e-07 0 1.3715132900756772e-07 0 1.3716132900756773e-07 0.00021 1.3717132900756774e-07 0 1.3717132900756772e-07 0 1.3718132900756773e-07 0.00021 1.3719132900756774e-07 0 1.3727885404991922e-07 0 1.3728885404991923e-07 0.00021 1.3729885404991924e-07 0 1.3729885404991922e-07 0 1.3730885404991923e-07 0.00021 1.3731885404991924e-07 0 1.373633641480615e-07 0 1.373733641480615e-07 0.00021 1.3738336414806152e-07 0 1.375465985281759e-07 0 1.375565985281759e-07 0.00021 1.3756659852817592e-07 0 1.3757022909662583e-07 0 1.3758022909662584e-07 0.00021 1.3759022909662585e-07 0 1.3766631625848557e-07 0 1.3767631625848558e-07 0.00021 1.376863162584856e-07 0 1.3771781410209397e-07 0 1.3772781410209398e-07 0.00021 1.37737814102094e-07 0 1.3774121664385365e-07 0 1.3775121664385366e-07 0.00021 1.3776121664385367e-07 0 1.3776121664385365e-07 0 1.3777121664385366e-07 0.00021 1.3778121664385367e-07 0 1.3793294520933774e-07 0 1.3794294520933775e-07 0.00021 1.3795294520933776e-07 0 1.3799099500037726e-07 0 1.3800099500037727e-07 0.00021 1.3801099500037729e-07 0 1.3803924539906933e-07 0 1.3804924539906934e-07 0.00021 1.3805924539906935e-07 0 1.3814844478646188e-07 0 1.381584447864619e-07 0.00021 1.381684447864619e-07 0 1.3825243544090649e-07 0 1.382624354409065e-07 0.00021 1.382724354409065e-07 0 1.3827640202924978e-07 0 1.382864020292498e-07 0.00021 1.382964020292498e-07 0 1.3831822370205523e-07 0 1.3832822370205525e-07 0.00021 1.3833822370205526e-07 0 1.3836569950927928e-07 0 1.383756995092793e-07 0.00021 1.383856995092793e-07 0 1.3856420518536106e-07 0 1.3857420518536107e-07 0.00021 1.3858420518536108e-07 0 1.3861564437371004e-07 0 1.3862564437371006e-07 0.00021 1.3863564437371007e-07 0 1.3913106397269208e-07 0 1.391410639726921e-07 0.00021 1.391510639726921e-07 0 1.3919606723497144e-07 0 1.3920606723497145e-07 0.00021 1.3921606723497146e-07 0 1.3941719773168274e-07 0 1.3942719773168275e-07 0.00021 1.3943719773168276e-07 0 1.3943719773168274e-07 0 1.3944719773168275e-07 0.00021 1.3945719773168276e-07 0 1.3945719773168273e-07 0 1.3946719773168274e-07 0.00021 1.3947719773168276e-07 0 1.3947719773168273e-07 0 1.3948719773168274e-07 0.00021 1.3949719773168275e-07 0 1.395564443146303e-07 0 1.395664443146303e-07 0.00021 1.395764443146303e-07 0 1.3963753337749677e-07 0 1.3964753337749678e-07 0.00021 1.396575333774968e-07 0 1.3972679470154057e-07 0 1.3973679470154058e-07 0.00021 1.397467947015406e-07 0 1.397623552619324e-07 0 1.397723552619324e-07 0.00021 1.397823552619324e-07 0 1.398104821116464e-07 0 1.398204821116464e-07 0.00021 1.398304821116464e-07 0 1.4003775209063525e-07 0 1.4004775209063526e-07 0.00021 1.4005775209063527e-07 0 1.4009915129063702e-07 0 1.4010915129063703e-07 0.00021 1.4011915129063705e-07 0 1.4030702837209e-07 0 1.4031702837209e-07 0.00021 1.4032702837209e-07 0 1.4062076740909087e-07 0 1.4063076740909088e-07 0.00021 1.406407674090909e-07 0 1.4074378464035759e-07 0 1.407537846403576e-07 0.00021 1.407637846403576e-07 0 1.4076378464035758e-07 0 1.407737846403576e-07 0.00021 1.407837846403576e-07 0 1.4080574806572736e-07 0 1.4081574806572737e-07 0.00021 1.4082574806572738e-07 0 1.408826946157449e-07 0 1.408926946157449e-07 0.00021 1.409026946157449e-07 0 1.4090269461574489e-07 0 1.409126946157449e-07 0.00021 1.409226946157449e-07 0 1.409371348372204e-07 0 1.4094713483722042e-07 0.00021 1.4095713483722043e-07 0 1.409571348372204e-07 0 1.4096713483722042e-07 0.00021 1.4097713483722043e-07 0 1.409771348372204e-07 0 1.4098713483722041e-07 0.00021 1.4099713483722043e-07 0 1.4107140482107222e-07 0 1.4108140482107224e-07 0.00021 1.4109140482107225e-07 0 1.4117451808791005e-07 0 1.4118451808791006e-07 0.00021 1.4119451808791007e-07 0 1.4119451808791004e-07 0 1.4120451808791005e-07 0.00021 1.4121451808791006e-07 0 1.4124591637826366e-07 0 1.4125591637826368e-07 0.00021 1.412659163782637e-07 0 1.413217592423961e-07 0 1.4133175924239612e-07 0.00021 1.4134175924239613e-07 0 1.414043394768669e-07 0 1.414143394768669e-07 0.00021 1.4142433947686692e-07 0 1.4182612247401897e-07 0 1.4183612247401898e-07 0.00021 1.41846122474019e-07 0 1.4193094046012928e-07 0 1.419409404601293e-07 0.00021 1.419509404601293e-07 0 1.419782693965127e-07 0 1.419882693965127e-07 0.00021 1.4199826939651271e-07 0 1.419982693965127e-07 0 1.420082693965127e-07 0.00021 1.420182693965127e-07 0 1.420235085504462e-07 0 1.4203350855044622e-07 0.00021 1.4204350855044623e-07 0 1.4205850509374756e-07 0 1.4206850509374757e-07 0.00021 1.4207850509374758e-07 0 1.421092548335113e-07 0 1.421192548335113e-07 0.00021 1.4212925483351132e-07 0 1.4220041262712363e-07 0 1.4221041262712365e-07 0.00021 1.4222041262712366e-07 0 1.4222041262712363e-07 0 1.4223041262712364e-07 0.00021 1.4224041262712365e-07 0 1.4224041262712363e-07 0 1.4225041262712364e-07 0.00021 1.4226041262712365e-07 0 1.4227399115058506e-07 0 1.4228399115058507e-07 0.00021 1.4229399115058508e-07 0 1.423216419629299e-07 0 1.423316419629299e-07 0.00021 1.423416419629299e-07 0 1.423670520236178e-07 0 1.423770520236178e-07 0.00021 1.423870520236178e-07 0 1.4240132655019742e-07 0 1.4241132655019743e-07 0.00021 1.4242132655019744e-07 0 1.424283810703361e-07 0 1.424383810703361e-07 0.00021 1.4244838107033612e-07 0 1.424483810703361e-07 0 1.424583810703361e-07 0.00021 1.4246838107033612e-07 0 1.4259369475285198e-07 0 1.42603694752852e-07 0.00021 1.42613694752852e-07 0 1.4262556614413836e-07 0 1.4263556614413837e-07 0.00021 1.4264556614413839e-07 0 1.4264556614413836e-07 0 1.4265556614413837e-07 0.00021 1.4266556614413838e-07 0 1.4266556614413835e-07 0 1.4267556614413837e-07 0.00021 1.4268556614413838e-07 0 1.4268556614413835e-07 0 1.4269556614413836e-07 0.00021 1.4270556614413837e-07 0 1.4271145962765055e-07 0 1.4272145962765056e-07 0.00021 1.4273145962765057e-07 0 1.4273145962765055e-07 0 1.4274145962765056e-07 0.00021 1.4275145962765057e-07 0 1.4275145962765054e-07 0 1.4276145962765055e-07 0.00021 1.4277145962765057e-07 0 1.4286330878154632e-07 0 1.4287330878154633e-07 0.00021 1.4288330878154634e-07 0 1.4288330878154632e-07 0 1.4289330878154633e-07 0.00021 1.4290330878154634e-07 0 1.4290330878154631e-07 0 1.4291330878154632e-07 0.00021 1.4292330878154634e-07 0 1.4299514336537008e-07 0 1.430051433653701e-07 0.00021 1.430151433653701e-07 0 1.4301514336537007e-07 0 1.4302514336537008e-07 0.00021 1.430351433653701e-07 0 1.4312069986297426e-07 0 1.4313069986297427e-07 0.00021 1.4314069986297428e-07 0 1.4314069986297426e-07 0 1.4315069986297427e-07 0.00021 1.4316069986297428e-07 0 1.431630966787878e-07 0 1.431730966787878e-07 0.00021 1.4318309667878782e-07 0 1.4345415610517962e-07 0 1.4346415610517963e-07 0.00021 1.4347415610517964e-07 0 1.4347415610517962e-07 0 1.4348415610517963e-07 0.00021 1.4349415610517964e-07 0 1.435059612722767e-07 0 1.4351596127227672e-07 0.00021 1.4352596127227673e-07 0 1.435259612722767e-07 0 1.4353596127227672e-07 0.00021 1.4354596127227673e-07 0 1.4363409200806523e-07 0 1.4364409200806524e-07 0.00021 1.4365409200806525e-07 0 1.436839115503686e-07 0 1.4369391155036862e-07 0.00021 1.4370391155036863e-07 0 1.437039115503686e-07 0 1.437139115503686e-07 0.00021 1.4372391155036862e-07 0 1.43915743028469e-07 0 1.4392574302846902e-07 0.00021 1.4393574302846904e-07 0 1.441368439253497e-07 0 1.441468439253497e-07 0.00021 1.4415684392534972e-07 0 1.4417485730488272e-07 0 1.4418485730488273e-07 0.00021 1.4419485730488275e-07 0 1.4430348701557412e-07 0 1.4431348701557413e-07 0.00021 1.4432348701557414e-07 0 1.443407254424837e-07 0 1.4435072544248371e-07 0.00021 1.4436072544248372e-07 0 1.4439392411787057e-07 0 1.4440392411787058e-07 0.00021 1.444139241178706e-07 0 1.4441392411787056e-07 0 1.4442392411787058e-07 0.00021 1.444339241178706e-07 0 1.44469785369784e-07 0 1.44479785369784e-07 0.00021 1.4448978536978402e-07 0 1.4467355286562448e-07 0 1.446835528656245e-07 0.00021 1.446935528656245e-07 0 1.447020174958899e-07 0 1.4471201749588992e-07 0.00021 1.4472201749588993e-07 0 1.4477044488779976e-07 0 1.4478044488779977e-07 0.00021 1.4479044488779978e-07 0 1.4479044488779975e-07 0 1.4480044488779977e-07 0.00021 1.4481044488779978e-07 0 1.4481044488779975e-07 0 1.4482044488779976e-07 0.00021 1.4483044488779977e-07 0 1.4483044488779975e-07 0 1.4484044488779976e-07 0.00021 1.4485044488779977e-07 0 1.4485044488779974e-07 0 1.4486044488779975e-07 0.00021 1.4487044488779977e-07 0 1.4487044488779974e-07 0 1.4488044488779975e-07 0.00021 1.4489044488779976e-07 0 1.449013055313615e-07 0 1.4491130553136152e-07 0.00021 1.4492130553136153e-07 0 1.4503692507711266e-07 0 1.4504692507711267e-07 0.00021 1.4505692507711268e-07 0 1.4505692507711265e-07 0 1.4506692507711267e-07 0.00021 1.4507692507711268e-07 0 1.4508297628190063e-07 0 1.4509297628190064e-07 0.00021 1.4510297628190066e-07 0 1.4510297628190063e-07 0 1.4511297628190064e-07 0.00021 1.4512297628190065e-07 0 1.4518874317199992e-07 0 1.4519874317199994e-07 0.00021 1.4520874317199995e-07 0 1.4570651725422968e-07 0 1.457165172542297e-07 0.00021 1.457265172542297e-07 0 1.4572651725422967e-07 0 1.4573651725422968e-07 0.00021 1.457465172542297e-07 0 1.4577501278749303e-07 0 1.4578501278749304e-07 0.00021 1.4579501278749305e-07 0 1.4587360424411375e-07 0 1.4588360424411376e-07 0.00021 1.4589360424411377e-07 0 1.460742043784359e-07 0 1.4608420437843592e-07 0.00021 1.4609420437843593e-07 0 1.460942043784359e-07 0 1.4610420437843592e-07 0.00021 1.4611420437843593e-07 0 1.4614373664844743e-07 0 1.4615373664844744e-07 0.00021 1.4616373664844746e-07 0 1.4630969106792615e-07 0 1.4631969106792616e-07 0.00021 1.4632969106792617e-07 0 1.4632969106792614e-07 0 1.4633969106792616e-07 0.00021 1.4634969106792617e-07 0 1.4634969106792614e-07 0 1.4635969106792615e-07 0.00021 1.4636969106792616e-07 0 1.4640243074379187e-07 0 1.4641243074379189e-07 0.00021 1.464224307437919e-07 0 1.4648766159210014e-07 0 1.4649766159210015e-07 0.00021 1.4650766159210016e-07 0 1.4653592060475795e-07 0 1.4654592060475796e-07 0.00021 1.4655592060475797e-07 0 1.465888935638998e-07 0 1.465988935638998e-07 0.00021 1.4660889356389982e-07 0 1.4698549572076472e-07 0 1.4699549572076474e-07 0.00021 1.4700549572076475e-07 0 1.470902401976164e-07 0 1.4710024019761642e-07 0.00021 1.4711024019761643e-07 0 1.4714927872099198e-07 0 1.4715927872099199e-07 0.00021 1.47169278720992e-07 0 1.4719488366135352e-07 0 1.4720488366135353e-07 0.00021 1.4721488366135354e-07 0 1.4726564752159178e-07 0 1.472756475215918e-07 0.00021 1.472856475215918e-07 0 1.4730471697937293e-07 0 1.4731471697937295e-07 0.00021 1.4732471697937296e-07 0 1.4732471697937293e-07 0 1.4733471697937294e-07 0.00021 1.4734471697937295e-07 0 1.47349754625971e-07 0 1.47359754625971e-07 0.00021 1.4736975462597102e-07 0 1.4737355252970372e-07 0 1.4738355252970373e-07 0.00021 1.4739355252970375e-07 0 1.474722710441384e-07 0 1.474822710441384e-07 0.00021 1.4749227104413842e-07 0 1.4752137092869913e-07 0 1.4753137092869914e-07 0.00021 1.4754137092869916e-07 0 1.4769373845160102e-07 0 1.4770373845160103e-07 0.00021 1.4771373845160104e-07 0 1.4785930987174893e-07 0 1.4786930987174894e-07 0.00021 1.4787930987174895e-07 0 1.479835719327651e-07 0 1.4799357193276512e-07 0.00021 1.4800357193276513e-07 0 1.4800853475720313e-07 0 1.4801853475720314e-07 0.00021 1.4802853475720316e-07 0 1.4802853475720313e-07 0 1.4803853475720314e-07 0.00021 1.4804853475720315e-07 0 1.4836551440522496e-07 0 1.4837551440522497e-07 0.00021 1.4838551440522498e-07 0 1.4844681136509196e-07 0 1.4845681136509197e-07 0.00021 1.4846681136509198e-07 0 1.4852723169028236e-07 0 1.4853723169028237e-07 0.00021 1.4854723169028238e-07 0 1.4857907744190967e-07 0 1.4858907744190968e-07 0.00021 1.485990774419097e-07 0 1.4861793195811619e-07 0 1.486279319581162e-07 0.00021 1.486379319581162e-07 0 1.4865462414733846e-07 0 1.4866462414733847e-07 0.00021 1.4867462414733848e-07 0 1.4875916532876965e-07 0 1.4876916532876966e-07 0.00021 1.4877916532876967e-07 0 1.4877916532876965e-07 0 1.4878916532876966e-07 0.00021 1.4879916532876967e-07 0 1.4881889487204339e-07 0 1.488288948720434e-07 0.00021 1.488388948720434e-07 0 1.48880335561093e-07 0 1.4889033556109302e-07 0.00021 1.4890033556109303e-07 0 1.4890423113794314e-07 0 1.4891423113794315e-07 0.00021 1.4892423113794316e-07 0 1.4892423113794314e-07 0 1.4893423113794315e-07 0.00021 1.4894423113794316e-07 0 1.4894423113794313e-07 0 1.4895423113794314e-07 0.00021 1.4896423113794315e-07 0 1.4910173590295115e-07 0 1.4911173590295116e-07 0.00021 1.4912173590295117e-07 0 1.4912173590295115e-07 0 1.4913173590295116e-07 0.00021 1.4914173590295117e-07 0 1.4921665682592716e-07 0 1.4922665682592718e-07 0.00021 1.492366568259272e-07 0 1.492425887942816e-07 0 1.4925258879428162e-07 0.00021 1.4926258879428163e-07 0 1.4926971962593564e-07 0 1.4927971962593565e-07 0.00021 1.4928971962593566e-07 0 1.4929258508308614e-07 0 1.4930258508308615e-07 0.00021 1.4931258508308616e-07 0 1.4935241951441956e-07 0 1.4936241951441957e-07 0.00021 1.4937241951441958e-07 0 1.4949522584684292e-07 0 1.4950522584684293e-07 0.00021 1.4951522584684294e-07 0 1.4951522584684292e-07 0 1.4952522584684293e-07 0.00021 1.4953522584684294e-07 0 1.495352258468429e-07 0 1.4954522584684292e-07 0.00021 1.4955522584684293e-07 0 1.495552258468429e-07 0 1.4956522584684292e-07 0.00021 1.4957522584684293e-07 0 1.4961611979070334e-07 0 1.4962611979070335e-07 0.00021 1.4963611979070336e-07 0 1.4965987231380113e-07 0 1.4966987231380114e-07 0.00021 1.4967987231380116e-07 0 1.496928016273681e-07 0 1.497028016273681e-07 0.00021 1.497128016273681e-07 0 1.4971280162736809e-07 0 1.497228016273681e-07 0.00021 1.497328016273681e-07 0 1.4973280162736808e-07 0 1.497428016273681e-07 0.00021 1.497528016273681e-07 0 1.4975280162736808e-07 0 1.497628016273681e-07 0.00021 1.497728016273681e-07 0 1.4977280162736807e-07 0 1.4978280162736809e-07 0.00021 1.497928016273681e-07 0 1.498382197029492e-07 0 1.498482197029492e-07 0.00021 1.4985821970294922e-07 0 1.498717301281073e-07 0 1.4988173012810732e-07 0.00021 1.4989173012810733e-07 0 1.499332650280805e-07 0 1.499432650280805e-07 0.00021 1.4995326502808052e-07 0 1.5000185347315702e-07 0 1.5001185347315703e-07 0.00021 1.5002185347315704e-07 0 1.50129140953472e-07 0 1.50139140953472e-07 0.00021 1.5014914095347202e-07 0 1.5039045247652794e-07 0 1.5040045247652795e-07 0.00021 1.5041045247652796e-07 0 1.5041122654974708e-07 0 1.504212265497471e-07 0.00021 1.504312265497471e-07 0 1.5044030154401914e-07 0 1.5045030154401915e-07 0.00021 1.5046030154401916e-07 0 1.507045887303612e-07 0 1.5071458873036122e-07 0.00021 1.5072458873036124e-07 0 1.5073525605176346e-07 0 1.5074525605176347e-07 0.00021 1.5075525605176348e-07 0 1.507567251719146e-07 0 1.507667251719146e-07 0.00021 1.507767251719146e-07 0 1.5077672517191458e-07 0 1.507867251719146e-07 0.00021 1.507967251719146e-07 0 1.5079672517191458e-07 0 1.508067251719146e-07 0.00021 1.508167251719146e-07 0 1.5083422819356364e-07 0 1.5084422819356366e-07 0.00021 1.5085422819356367e-07 0 1.5089560181209396e-07 0 1.5090560181209397e-07 0.00021 1.5091560181209398e-07 0 1.5091865218138333e-07 0 1.5092865218138334e-07 0.00021 1.5093865218138335e-07 0 1.509990403943742e-07 0 1.510090403943742e-07 0.00021 1.5101904039437422e-07 0 1.510248253415373e-07 0 1.5103482534153732e-07 0.00021 1.5104482534153733e-07 0 1.511641936424811e-07 0 1.5117419364248112e-07 0.00021 1.5118419364248113e-07 0 1.511841936424811e-07 0 1.5119419364248112e-07 0.00021 1.5120419364248113e-07 0 1.512041936424811e-07 0 1.512141936424811e-07 0.00021 1.5122419364248112e-07 0 1.512241936424811e-07 0 1.512341936424811e-07 0.00021 1.5124419364248112e-07 0 1.5132224883612177e-07 0 1.5133224883612178e-07 0.00021 1.513422488361218e-07 0 1.5169817784411303e-07 0 1.5170817784411304e-07 0.00021 1.5171817784411306e-07 0 1.5172476057120484e-07 0 1.5173476057120485e-07 0.00021 1.5174476057120486e-07 0 1.5193651147055348e-07 0 1.519465114705535e-07 0.00021 1.519565114705535e-07 0 1.520402067101693e-07 0 1.520502067101693e-07 0.00021 1.5206020671016932e-07 0 1.521450368165449e-07 0 1.5215503681654492e-07 0.00021 1.5216503681654493e-07 0 1.522193182874834e-07 0 1.522293182874834e-07 0.00021 1.522393182874834e-07 0 1.5223931828748339e-07 0 1.522493182874834e-07 0.00021 1.522593182874834e-07 0 1.522755697172488e-07 0 1.522855697172488e-07 0.00021 1.522955697172488e-07 0 1.5231511194836702e-07 0 1.5232511194836703e-07 0.00021 1.5233511194836705e-07 0 1.5243535972825998e-07 0 1.5244535972826e-07 0.00021 1.5245535972826e-07 0 1.5245535972825998e-07 0 1.5246535972826e-07 0.00021 1.5247535972826e-07 0 1.5247588023761038e-07 0 1.524858802376104e-07 0.00021 1.524958802376104e-07 0 1.5264463128622123e-07 0 1.5265463128622124e-07 0.00021 1.5266463128622126e-07 0 1.52677054164637e-07 0 1.52687054164637e-07 0.00021 1.5269705416463702e-07 0 1.52697054164637e-07 0 1.52707054164637e-07 0.00021 1.5271705416463701e-07 0 1.52717054164637e-07 0 1.52727054164637e-07 0.00021 1.52737054164637e-07 0 1.5273705416463698e-07 0 1.52747054164637e-07 0.00021 1.52757054164637e-07 0 1.5297898462512006e-07 0 1.5298898462512007e-07 0.00021 1.5299898462512008e-07 0 1.5306803994979315e-07 0 1.5307803994979316e-07 0.00021 1.5308803994979317e-07 0 1.5317518496034327e-07 0 1.5318518496034328e-07 0.00021 1.531951849603433e-07 0 1.532492765580381e-07 0 1.5325927655803812e-07 0.00021 1.5326927655803813e-07 0 1.532692765580381e-07 0 1.5327927655803812e-07 0.00021 1.5328927655803813e-07 0 1.5332433755271505e-07 0 1.5333433755271506e-07 0.00021 1.5334433755271508e-07 0 1.5335213646299978e-07 0 1.533621364629998e-07 0.00021 1.533721364629998e-07 0 1.5339481538456023e-07 0 1.5340481538456024e-07 0.00021 1.5341481538456026e-07 0 1.534292444881627e-07 0 1.534392444881627e-07 0.00021 1.5344924448816271e-07 0 1.534572656369319e-07 0 1.5346726563693192e-07 0.00021 1.5347726563693193e-07 0 1.534901708261094e-07 0 1.535001708261094e-07 0.00021 1.5351017082610942e-07 0 1.535101708261094e-07 0 1.535201708261094e-07 0.00021 1.5353017082610941e-07 0 1.5357830109559726e-07 0 1.5358830109559727e-07 0.00021 1.5359830109559728e-07 0 1.5363076242087393e-07 0 1.5364076242087395e-07 0.00021 1.5365076242087396e-07 0 1.5365706293974716e-07 0 1.5366706293974717e-07 0.00021 1.5367706293974718e-07 0 1.5367706293974716e-07 0 1.5368706293974717e-07 0.00021 1.5369706293974718e-07 0 1.5369706293974715e-07 0 1.5370706293974716e-07 0.00021 1.5371706293974717e-07 0 1.537912862777733e-07 0 1.538012862777733e-07 0.00021 1.5381128627777332e-07 0 1.538112862777733e-07 0 1.538212862777733e-07 0.00021 1.538312862777733e-07 0 1.5383128627777329e-07 0 1.538412862777733e-07 0.00021 1.538512862777733e-07 0 1.5385128627777328e-07 0 1.538612862777733e-07 0.00021 1.538712862777733e-07 0 1.53893388058862e-07 0 1.5390338805886202e-07 0.00021 1.5391338805886203e-07 0 1.5391766406819892e-07 0 1.5392766406819894e-07 0.00021 1.5393766406819895e-07 0 1.5395479799009902e-07 0 1.5396479799009903e-07 0.00021 1.5397479799009904e-07 0 1.541076804971269e-07 0 1.541176804971269e-07 0.00021 1.541276804971269e-07 0 1.542233285517309e-07 0 1.542333285517309e-07 0.00021 1.542433285517309e-07 0 1.5427125277620676e-07 0 1.5428125277620677e-07 0.00021 1.5429125277620678e-07 0 1.5429125277620675e-07 0 1.5430125277620677e-07 0.00021 1.5431125277620678e-07 0 1.5431562252629063e-07 0 1.5432562252629064e-07 0.00021 1.5433562252629065e-07 0 1.5433562252629063e-07 0 1.5434562252629064e-07 0.00021 1.5435562252629065e-07 0 1.543906983513869e-07 0 1.544006983513869e-07 0.00021 1.5441069835138691e-07 0 1.5455508278556848e-07 0 1.545650827855685e-07 0.00021 1.545750827855685e-07 0 1.547565467950014e-07 0 1.547665467950014e-07 0.00021 1.547765467950014e-07 0 1.5484563718811243e-07 0 1.5485563718811244e-07 0.00021 1.5486563718811245e-07 0 1.5499305602589722e-07 0 1.5500305602589723e-07 0.00021 1.5501305602589724e-07 0 1.5510730235005775e-07 0 1.5511730235005776e-07 0.00021 1.5512730235005777e-07 0 1.551906011212479e-07 0 1.5520060112124792e-07 0.00021 1.5521060112124793e-07 0 1.5523174667535533e-07 0 1.5524174667535534e-07 0.00021 1.5525174667535535e-07 0 1.5525174667535533e-07 0 1.5526174667535534e-07 0.00021 1.5527174667535535e-07 0 1.553317689946473e-07 0 1.553417689946473e-07 0.00021 1.5535176899464732e-07 0 1.5567331730053124e-07 0 1.5568331730053125e-07 0.00021 1.5569331730053126e-07 0 1.5569331730053124e-07 0 1.5570331730053125e-07 0.00021 1.5571331730053126e-07 0 1.5574821834414776e-07 0 1.5575821834414777e-07 0.00021 1.5576821834414778e-07 0 1.5577702149117188e-07 0 1.557870214911719e-07 0.00021 1.557970214911719e-07 0 1.558043113316412e-07 0 1.558143113316412e-07 0.00021 1.5582431133164121e-07 0 1.558243113316412e-07 0 1.558343113316412e-07 0.00021 1.558443113316412e-07 0 1.5599257029397222e-07 0 1.5600257029397223e-07 0.00021 1.5601257029397224e-07 0 1.5604298395396636e-07 0 1.5605298395396638e-07 0.00021 1.560629839539664e-07 0 1.5607388858642133e-07 0 1.5608388858642134e-07 0.00021 1.5609388858642136e-07 0 1.561872121927936e-07 0 1.561972121927936e-07 0.00021 1.562072121927936e-07 0 1.5622293274151734e-07 0 1.5623293274151735e-07 0.00021 1.5624293274151736e-07 0 1.5659408172261777e-07 0 1.5660408172261778e-07 0.00021 1.566140817226178e-07 0 1.5663087507921462e-07 0 1.5664087507921463e-07 0.00021 1.5665087507921464e-07 0 1.5665087507921461e-07 0 1.5666087507921463e-07 0.00021 1.5667087507921464e-07 0 1.5673416891314575e-07 0 1.5674416891314577e-07 0.00021 1.5675416891314578e-07 0 1.5676595504129432e-07 0 1.5677595504129433e-07 0.00021 1.5678595504129435e-07 0 1.5683941261841275e-07 0 1.5684941261841276e-07 0.00021 1.5685941261841277e-07 0 1.5692555176786927e-07 0 1.5693555176786928e-07 0.00021 1.569455517678693e-07 0 1.569595709466531e-07 0 1.569695709466531e-07 0.00021 1.5697957094665312e-07 0 1.569795709466531e-07 0 1.569895709466531e-07 0.00021 1.5699957094665312e-07 0 1.569995709466531e-07 0 1.570095709466531e-07 0.00021 1.5701957094665312e-07 0 1.570909177113066e-07 0 1.571009177113066e-07 0.00021 1.571109177113066e-07 0 1.5712362045984918e-07 0 1.571336204598492e-07 0.00021 1.571436204598492e-07 0 1.5715994066344793e-07 0 1.5716994066344794e-07 0.00021 1.5717994066344796e-07 0 1.5739272929773587e-07 0 1.5740272929773589e-07 0.00021 1.574127292977359e-07 0 1.575774338608368e-07 0 1.575874338608368e-07 0.00021 1.5759743386083682e-07 0 1.575974338608368e-07 0 1.576074338608368e-07 0.00021 1.5761743386083682e-07 0 1.576174338608368e-07 0 1.576274338608368e-07 0.00021 1.576374338608368e-07 0 1.5765296439896683e-07 0 1.5766296439896684e-07 0.00021 1.5767296439896685e-07 0 1.5767296439896683e-07 0 1.5768296439896684e-07 0.00021 1.5769296439896685e-07 0 1.5788012146629354e-07 0 1.5789012146629355e-07 0.00021 1.5790012146629356e-07 0 1.579106303518463e-07 0 1.579206303518463e-07 0.00021 1.579306303518463e-07 0 1.5798033221929599e-07 0 1.57990332219296e-07 0.00021 1.58000332219296e-07 0 1.5800033221929598e-07 0 1.58010332219296e-07 0.00021 1.58020332219296e-07 0 1.581875655197944e-07 0 1.581975655197944e-07 0.00021 1.5820756551979441e-07 0 1.582268903040796e-07 0 1.582368903040796e-07 0.00021 1.582468903040796e-07 0 1.583846884367384e-07 0 1.583946884367384e-07 0.00021 1.5840468843673842e-07 0 1.5844335658595456e-07 0 1.5845335658595457e-07 0.00021 1.5846335658595458e-07 0 1.5851301903031237e-07 0 1.5852301903031238e-07 0.00021 1.585330190303124e-07 0 1.5862514385281786e-07 0 1.5863514385281787e-07 0.00021 1.5864514385281788e-07 0 1.5864514385281786e-07 0 1.5865514385281787e-07 0.00021 1.5866514385281788e-07 0 1.5866514385281785e-07 0 1.5867514385281786e-07 0.00021 1.5868514385281788e-07 0 1.5868514385281785e-07 0 1.5869514385281786e-07 0.00021 1.5870514385281787e-07 0 1.587659790922799e-07 0 1.5877597909227992e-07 0.00021 1.5878597909227993e-07 0 1.5885329860234506e-07 0 1.5886329860234507e-07 0.00021 1.5887329860234508e-07 0 1.5887929823547614e-07 0 1.5888929823547615e-07 0.00021 1.5889929823547616e-07 0 1.5892681281464229e-07 0 1.589368128146423e-07 0.00021 1.589468128146423e-07 0 1.590254697966219e-07 0 1.5903546979662192e-07 0.00021 1.5904546979662193e-07 0 1.5914719147139503e-07 0 1.5915719147139504e-07 0.00021 1.5916719147139505e-07 0 1.5918915433196795e-07 0 1.5919915433196796e-07 0.00021 1.5920915433196797e-07 0 1.5933875304923077e-07 0 1.5934875304923078e-07 0.00021 1.593587530492308e-07 0 1.5935875304923077e-07 0 1.5936875304923078e-07 0.00021 1.593787530492308e-07 0 1.594672351193684e-07 0 1.594772351193684e-07 0.00021 1.5948723511936842e-07 0 1.5953375669321295e-07 0 1.5954375669321296e-07 0.00021 1.5955375669321297e-07 0 1.595541893746343e-07 0 1.5956418937463432e-07 0.00021 1.5957418937463433e-07 0 1.595909694114248e-07 0 1.596009694114248e-07 0.00021 1.5961096941142482e-07 0 1.5963928576437793e-07 0 1.5964928576437794e-07 0.00021 1.5965928576437795e-07 0 1.596604140115115e-07 0 1.5967041401151151e-07 0.00021 1.5968041401151153e-07 0 1.597297278657535e-07 0 1.597397278657535e-07 0.00021 1.5974972786575351e-07 0 1.597497278657535e-07 0 1.597597278657535e-07 0.00021 1.597697278657535e-07 0 1.5981717469397767e-07 0 1.5982717469397768e-07 0.00021 1.598371746939777e-07 0 1.5998333778648408e-07 0 1.599933377864841e-07 0.00021 1.600033377864841e-07 0 1.6024623434481715e-07 0 1.6025623434481716e-07 0.00021 1.6026623434481718e-07 0 1.6026623434481715e-07 0 1.6027623434481716e-07 0.00021 1.6028623434481717e-07 0 1.6044416146892854e-07 0 1.6045416146892855e-07 0.00021 1.6046416146892856e-07 0 1.6046416146892853e-07 0 1.6047416146892854e-07 0.00021 1.6048416146892855e-07 0 1.6052838444124205e-07 0 1.6053838444124206e-07 0.00021 1.6054838444124207e-07 0 1.6059060811767447e-07 0 1.6060060811767448e-07 0.00021 1.606106081176745e-07 0 1.6065789587146455e-07 0 1.6066789587146456e-07 0.00021 1.6067789587146457e-07 0 1.6067789587146455e-07 0 1.6068789587146456e-07 0.00021 1.6069789587146457e-07 0 1.6078409713427934e-07 0 1.6079409713427935e-07 0.00021 1.6080409713427936e-07 0 1.6080832831497983e-07 0 1.6081832831497985e-07 0.00021 1.6082832831497986e-07 0 1.6099322065980142e-07 0 1.6100322065980143e-07 0.00021 1.6101322065980144e-07 0 1.6106094504549658e-07 0 1.610709450454966e-07 0.00021 1.610809450454966e-07 0 1.611570569474369e-07 0 1.6116705694743692e-07 0.00021 1.6117705694743693e-07 0 1.611770569474369e-07 0 1.6118705694743691e-07 0.00021 1.6119705694743693e-07 0 1.611970569474369e-07 0 1.612070569474369e-07 0.00021 1.6121705694743692e-07 0 1.612170569474369e-07 0 1.612270569474369e-07 0.00021 1.6123705694743692e-07 0 1.612370569474369e-07 0 1.612470569474369e-07 0.00021 1.6125705694743691e-07 0 1.6133280306973845e-07 0 1.6134280306973846e-07 0.00021 1.6135280306973847e-07 0 1.6141565896520452e-07 0 1.6142565896520453e-07 0.00021 1.6143565896520455e-07 0 1.6162518957491095e-07 0 1.6163518957491096e-07 0.00021 1.6164518957491097e-07 0 1.617034097996752e-07 0 1.6171340979967522e-07 0.00021 1.6172340979967523e-07 0 1.6187119899496462e-07 0 1.6188119899496463e-07 0.00021 1.6189119899496464e-07 0 1.6192376371811438e-07 0 1.619337637181144e-07 0.00021 1.619437637181144e-07 0 1.6198043763206906e-07 0 1.6199043763206907e-07 0.00021 1.6200043763206908e-07 0 1.6200043763206905e-07 0 1.6201043763206906e-07 0.00021 1.6202043763206908e-07 0 1.6215933089460017e-07 0 1.6216933089460018e-07 0.00021 1.621793308946002e-07 0 1.6227456969544908e-07 0 1.622845696954491e-07 0.00021 1.622945696954491e-07 0 1.6242916497241504e-07 0 1.6243916497241505e-07 0.00021 1.6244916497241507e-07 0 1.6244916497241504e-07 0 1.6245916497241505e-07 0.00021 1.6246916497241506e-07 0 1.6247821133131078e-07 0 1.6248821133131079e-07 0.00021 1.624982113313108e-07 0 1.6249821133131077e-07 0 1.6250821133131078e-07 0.00021 1.625182113313108e-07 0 1.625578767890201e-07 0 1.6256787678902011e-07 0.00021 1.6257787678902013e-07 0 1.6259808030569235e-07 0 1.6260808030569236e-07 0.00021 1.6261808030569237e-07 0 1.6265979756153528e-07 0 1.626697975615353e-07 0.00021 1.626797975615353e-07 0 1.6269960539313292e-07 0 1.6270960539313293e-07 0.00021 1.6271960539313294e-07 0 1.6278725756790078e-07 0 1.627972575679008e-07 0.00021 1.628072575679008e-07 0 1.6285563435199654e-07 0 1.6286563435199655e-07 0.00021 1.6287563435199656e-07 0 1.6287563435199654e-07 0 1.6288563435199655e-07 0.00021 1.6289563435199656e-07 0 1.6289563435199653e-07 0 1.6290563435199654e-07 0.00021 1.6291563435199656e-07 0 1.6291563435199653e-07 0 1.6292563435199654e-07 0.00021 1.6293563435199655e-07 0 1.6293563435199653e-07 0 1.6294563435199654e-07 0.00021 1.6295563435199655e-07 0 1.6295563435199652e-07 0 1.6296563435199653e-07 0.00021 1.6297563435199654e-07 0 1.6301115286702504e-07 0 1.6302115286702505e-07 0.00021 1.6303115286702506e-07 0 1.6303115286702504e-07 0 1.6304115286702505e-07 0.00021 1.6305115286702506e-07 0 1.6317400418003173e-07 0 1.6318400418003175e-07 0.00021 1.6319400418003176e-07 0 1.6319400418003173e-07 0 1.6320400418003174e-07 0.00021 1.6321400418003175e-07 0 1.6321400418003173e-07 0 1.6322400418003174e-07 0.00021 1.6323400418003175e-07 0 1.6323400418003172e-07 0 1.6324400418003173e-07 0.00021 1.6325400418003175e-07 0 1.632703652368376e-07 0 1.632803652368376e-07 0.00021 1.6329036523683761e-07 0 1.632903652368376e-07 0 1.633003652368376e-07 0.00021 1.633103652368376e-07 0 1.6331036523683758e-07 0 1.633203652368376e-07 0.00021 1.633303652368376e-07 0 1.6337523032451138e-07 0 1.633852303245114e-07 0.00021 1.633952303245114e-07 0 1.6342579382701302e-07 0 1.6343579382701303e-07 0.00021 1.6344579382701304e-07 0 1.6355983022027964e-07 0 1.6356983022027965e-07 0.00021 1.6357983022027966e-07 0 1.6358807756043145e-07 0 1.6359807756043146e-07 0.00021 1.6360807756043147e-07 0 1.6363471935252093e-07 0 1.6364471935252095e-07 0.00021 1.6365471935252096e-07 0 1.6376657531215274e-07 0 1.6377657531215276e-07 0.00021 1.6378657531215277e-07 0 1.638535184155582e-07 0 1.6386351841555822e-07 0.00021 1.6387351841555823e-07 0 1.6425965082662463e-07 0 1.6426965082662464e-07 0.00021 1.6427965082662465e-07 0 1.643484116208083e-07 0 1.6435841162080832e-07 0.00021 1.6436841162080833e-07 0 1.643684116208083e-07 0 1.6437841162080831e-07 0.00021 1.6438841162080833e-07 0 1.645938106530358e-07 0 1.646038106530358e-07 0.00021 1.6461381065303582e-07 0 1.6463245524238853e-07 0 1.6464245524238855e-07 0.00021 1.6465245524238856e-07 0 1.6469701490756436e-07 0 1.6470701490756438e-07 0.00021 1.6471701490756439e-07 0 1.6472891703510725e-07 0 1.6473891703510726e-07 0.00021 1.6474891703510727e-07 0 1.649225878739482e-07 0 1.649325878739482e-07 0.00021 1.6494258787394822e-07 0 1.64946225569554e-07 0 1.6495622556955401e-07 0.00021 1.6496622556955402e-07 0 1.650129334179194e-07 0 1.6502293341791942e-07 0.00021 1.6503293341791943e-07 0 1.650329334179194e-07 0 1.650429334179194e-07 0.00021 1.6505293341791942e-07 0 1.651606534859571e-07 0 1.6517065348595712e-07 0.00021 1.6518065348595714e-07 0 1.652436271429737e-07 0 1.652536271429737e-07 0.00021 1.6526362714297372e-07 0 1.652636271429737e-07 0 1.652736271429737e-07 0.00021 1.6528362714297372e-07 0 1.6534290082894631e-07 0 1.6535290082894633e-07 0.00021 1.6536290082894634e-07 0 1.6566882239152585e-07 0 1.6567882239152587e-07 0.00021 1.6568882239152588e-07 0 1.6570691595952588e-07 0 1.657169159595259e-07 0.00021 1.657269159595259e-07 0 1.6572691595952588e-07 0 1.657369159595259e-07 0.00021 1.657469159595259e-07 0 1.6591477128744815e-07 0 1.6592477128744816e-07 0.00021 1.6593477128744817e-07 0 1.6593758930056234e-07 0 1.6594758930056235e-07 0.00021 1.6595758930056236e-07 0 1.6595758930056234e-07 0 1.6596758930056235e-07 0.00021 1.6597758930056236e-07 0 1.6597758930056233e-07 0 1.6598758930056234e-07 0.00021 1.6599758930056236e-07 0 1.6599758930056233e-07 0 1.6600758930056234e-07 0.00021 1.6601758930056235e-07 0 1.6610789600656624e-07 0 1.6611789600656625e-07 0.00021 1.6612789600656626e-07 0 1.6631230188209862e-07 0 1.6632230188209863e-07 0.00021 1.6633230188209865e-07 0 1.6645390866100532e-07 0 1.6646390866100533e-07 0.00021 1.6647390866100534e-07 0 1.665274830388148e-07 0 1.6653748303881482e-07 0.00021 1.6654748303881483e-07 0 1.6664534444145724e-07 0 1.6665534444145725e-07 0.00021 1.6666534444145726e-07 0 1.6674024274631938e-07 0 1.667502427463194e-07 0.00021 1.667602427463194e-07 0 1.668141427525973e-07 0 1.6682414275259732e-07 0.00021 1.6683414275259733e-07 0 1.668848031575003e-07 0 1.668948031575003e-07 0.00021 1.6690480315750032e-07 0 1.6705723995065047e-07 0 1.6706723995065048e-07 0.00021 1.670772399506505e-07 0 1.6707723995065046e-07 0 1.6708723995065047e-07 0.00021 1.6709723995065049e-07 0 1.6709723995065046e-07 0 1.6710723995065047e-07 0.00021 1.6711723995065048e-07 0 1.674444079107887e-07 0 1.674544079107887e-07 0.00021 1.674644079107887e-07 0 1.6754666785031594e-07 0 1.6755666785031595e-07 0.00021 1.6756666785031596e-07 0 1.6756666785031593e-07 0 1.6757666785031594e-07 0.00021 1.6758666785031595e-07 0 1.6758666785031593e-07 0 1.6759666785031594e-07 0.00021 1.6760666785031595e-07 0 1.6760666785031592e-07 0 1.6761666785031594e-07 0.00021 1.6762666785031595e-07 0 1.6762666785031592e-07 0 1.6763666785031593e-07 0.00021 1.6764666785031594e-07 0 1.6764666785031592e-07 0 1.6765666785031593e-07 0.00021 1.6766666785031594e-07 0 1.6769251146323837e-07 0 1.6770251146323838e-07 0.00021 1.677125114632384e-07 0 1.680642826082861e-07 0 1.6807428260828611e-07 0.00021 1.6808428260828613e-07 0 1.6816360619551992e-07 0 1.6817360619551993e-07 0.00021 1.6818360619551995e-07 0 1.682133775094117e-07 0 1.682233775094117e-07 0.00021 1.6823337750941172e-07 0 1.6836403105105758e-07 0 1.683740310510576e-07 0.00021 1.683840310510576e-07 0 1.6839034689728963e-07 0 1.6840034689728965e-07 0.00021 1.6841034689728966e-07 0 1.6842099944049188e-07 0 1.684309994404919e-07 0.00021 1.684409994404919e-07 0 1.6846965336199566e-07 0 1.6847965336199567e-07 0.00021 1.6848965336199568e-07 0 1.6850991558446102e-07 0 1.6851991558446103e-07 0.00021 1.6852991558446104e-07 0 1.6860049432537953e-07 0 1.6861049432537955e-07 0.00021 1.6862049432537956e-07 0 1.6862049432537953e-07 0 1.6863049432537954e-07 0.00021 1.6864049432537955e-07 0 1.6864049432537953e-07 0 1.6865049432537954e-07 0.00021 1.6866049432537955e-07 0 1.6866049432537952e-07 0 1.6867049432537953e-07 0.00021 1.6868049432537955e-07 0 1.686805045536235e-07 0 1.686905045536235e-07 0.00021 1.687005045536235e-07 0 1.6874518810412945e-07 0 1.6875518810412946e-07 0.00021 1.6876518810412948e-07 0 1.687705502171435e-07 0 1.687805502171435e-07 0.00021 1.6879055021714351e-07 0 1.6879339103464543e-07 0 1.6880339103464544e-07 0.00021 1.6881339103464545e-07 0 1.6906970987533284e-07 0 1.6907970987533285e-07 0.00021 1.6908970987533286e-07 0 1.6908970987533284e-07 0 1.6909970987533285e-07 0.00021 1.6910970987533286e-07 0 1.6910970987533283e-07 0 1.6911970987533285e-07 0.00021 1.6912970987533286e-07 0 1.6915752517336282e-07 0 1.6916752517336284e-07 0.00021 1.6917752517336285e-07 0 1.6919879880665006e-07 0 1.6920879880665007e-07 0.00021 1.6921879880665008e-07 0 1.6932521071573404e-07 0 1.6933521071573405e-07 0.00021 1.6934521071573406e-07 0 1.6945203491799315e-07 0 1.6946203491799316e-07 0.00021 1.6947203491799317e-07 0 1.6966227415563681e-07 0 1.6967227415563683e-07 0.00021 1.6968227415563684e-07 0 1.7012137540626353e-07 0 1.7013137540626354e-07 0.00021 1.7014137540626355e-07 0 1.7014137540626352e-07 0 1.7015137540626353e-07 0.00021 1.7016137540626355e-07 0 1.7026054046464553e-07 0 1.7027054046464554e-07 0.00021 1.7028054046464555e-07 0 1.7040514912331334e-07 0 1.7041514912331335e-07 0.00021 1.7042514912331336e-07 0 1.7048573016589853e-07 0 1.7049573016589854e-07 0.00021 1.7050573016589855e-07 0 1.7050832560144643e-07 0 1.7051832560144644e-07 0.00021 1.7052832560144646e-07 0 1.70695939801331e-07 0 1.70705939801331e-07 0.00021 1.7071593980133102e-07 0 1.7075147574630005e-07 0 1.7076147574630006e-07 0.00021 1.7077147574630007e-07 0 1.7111403602080745e-07 0 1.7112403602080746e-07 0.00021 1.7113403602080747e-07 0 1.7115126465929566e-07 0 1.7116126465929568e-07 0.00021 1.711712646592957e-07 0 1.7133790173437747e-07 0 1.7134790173437748e-07 0.00021 1.713579017343775e-07 0 1.7135930923895562e-07 0 1.7136930923895563e-07 0.00021 1.7137930923895564e-07 0 1.713850036545944e-07 0 1.713950036545944e-07 0.00021 1.7140500365459442e-07 0 1.717167579398626e-07 0 1.717267579398626e-07 0.00021 1.717367579398626e-07 0 1.717397537426789e-07 0 1.717497537426789e-07 0.00021 1.717597537426789e-07 0 1.7175975374267889e-07 0 1.717697537426789e-07 0.00021 1.717797537426789e-07 0 1.7178709203499952e-07 0 1.7179709203499954e-07 0.00021 1.7180709203499955e-07 0 1.7187597218091565e-07 0 1.7188597218091566e-07 0.00021 1.7189597218091567e-07 0 1.719003027315092e-07 0 1.719103027315092e-07 0.00021 1.7192030273150922e-07 0 1.7196241369686015e-07 0 1.7197241369686016e-07 0.00021 1.7198241369686017e-07 0 1.7200541638705137e-07 0 1.7201541638705138e-07 0.00021 1.720254163870514e-07 0 1.7204391919194164e-07 0 1.7205391919194165e-07 0.00021 1.7206391919194166e-07 0 1.7209015930185162e-07 0 1.7210015930185163e-07 0.00021 1.7211015930185164e-07 0 1.7236959065915153e-07 0 1.7237959065915154e-07 0.00021 1.7238959065915156e-07 0 1.724251756086447e-07 0 1.724351756086447e-07 0.00021 1.7244517560864472e-07 0 1.724451756086447e-07 0 1.724551756086447e-07 0.00021 1.724651756086447e-07 0 1.7254543644443055e-07 0 1.7255543644443056e-07 0.00021 1.7256543644443057e-07 0 1.727295628493248e-07 0 1.727395628493248e-07 0.00021 1.7274956284932481e-07 0 1.7280378970296637e-07 0 1.7281378970296638e-07 0.00021 1.728237897029664e-07 0 1.7282378970296637e-07 0 1.7283378970296638e-07 0.00021 1.728437897029664e-07 0 1.730619648812081e-07 0 1.730719648812081e-07 0.00021 1.7308196488120812e-07 0 1.731622014600594e-07 0 1.731722014600594e-07 0.00021 1.7318220146005942e-07 0 1.731822014600594e-07 0 1.731922014600594e-07 0.00021 1.732022014600594e-07 0 1.7325426091124658e-07 0 1.732642609112466e-07 0.00021 1.732742609112466e-07 0 1.7327426091124658e-07 0 1.732842609112466e-07 0.00021 1.732942609112466e-07 0 1.73422844049883e-07 0 1.7343284404988302e-07 0.00021 1.7344284404988303e-07 0 1.734708033994635e-07 0 1.734808033994635e-07 0.00021 1.7349080339946352e-07 0 1.734908033994635e-07 0 1.735008033994635e-07 0.00021 1.7351080339946352e-07 0 1.7351968927545333e-07 0 1.7352968927545334e-07 0.00021 1.7353968927545336e-07 0 1.736359040687615e-07 0 1.7364590406876151e-07 0.00021 1.7365590406876153e-07 0 1.7369427491568214e-07 0 1.7370427491568215e-07 0.00021 1.7371427491568217e-07 0 1.7381578192276002e-07 0 1.7382578192276003e-07 0.00021 1.7383578192276004e-07 0 1.738548849541298e-07 0 1.738648849541298e-07 0.00021 1.7387488495412982e-07 0 1.73924881189544e-07 0 1.7393488118954402e-07 0.00021 1.7394488118954404e-07 0 1.7404285505701598e-07 0 1.74052855057016e-07 0.00021 1.74062855057016e-07 0 1.7406285505701598e-07 0 1.74072855057016e-07 0.00021 1.74082855057016e-07 0 1.7417611510518336e-07 0 1.7418611510518338e-07 0.00021 1.741961151051834e-07 0 1.742380380030338e-07 0 1.742480380030338e-07 0.00021 1.742580380030338e-07 0 1.7457379618052478e-07 0 1.745837961805248e-07 0.00021 1.745937961805248e-07 0 1.7462981914849276e-07 0 1.7463981914849278e-07 0.00021 1.746498191484928e-07 0 1.7464981914849276e-07 0 1.7465981914849277e-07 0.00021 1.7466981914849278e-07 0 1.7478179852342882e-07 0 1.7479179852342883e-07 0.00021 1.7480179852342884e-07 0 1.7485597341448006e-07 0 1.7486597341448007e-07 0.00021 1.7487597341448008e-07 0 1.7493579749083064e-07 0 1.7494579749083065e-07 0.00021 1.7495579749083066e-07 0 1.7496317366069864e-07 0 1.7497317366069865e-07 0.00021 1.7498317366069866e-07 0 1.7506698887582097e-07 0 1.7507698887582099e-07 0.00021 1.75086988875821e-07 0 1.7511172546389392e-07 0 1.7512172546389393e-07 0.00021 1.7513172546389394e-07 0 1.7513172546389392e-07 0 1.7514172546389393e-07 0.00021 1.7515172546389394e-07 0 1.751517254638939e-07 0 1.7516172546389392e-07 0.00021 1.7517172546389394e-07 0 1.75173697940496e-07 0 1.7518369794049602e-07 0.00021 1.7519369794049603e-07 0 1.752158854726715e-07 0 1.752258854726715e-07 0.00021 1.7523588547267152e-07 0 1.7535978038081024e-07 0 1.7536978038081025e-07 0.00021 1.7537978038081026e-07 0 1.7556321006308647e-07 0 1.7557321006308649e-07 0.00021 1.755832100630865e-07 0 1.7558557334110473e-07 0 1.7559557334110474e-07 0.00021 1.7560557334110475e-07 0 1.7562660200657848e-07 0 1.756366020065785e-07 0.00021 1.756466020065785e-07 0 1.7595049282179345e-07 0 1.7596049282179346e-07 0.00021 1.7597049282179347e-07 0 1.7599411552294597e-07 0 1.7600411552294598e-07 0.00021 1.76014115522946e-07 0 1.7603171332288614e-07 0 1.7604171332288615e-07 0.00021 1.7605171332288617e-07 0 1.7610472048249775e-07 0 1.7611472048249776e-07 0.00021 1.7612472048249777e-07 0 1.7612604450081755e-07 0 1.7613604450081756e-07 0.00021 1.7614604450081757e-07 0 1.7614604450081754e-07 0 1.7615604450081755e-07 0.00021 1.7616604450081757e-07 0 1.7622644259292864e-07 0 1.7623644259292865e-07 0.00021 1.7624644259292867e-07 0 1.7626007629557638e-07 0 1.762700762955764e-07 0.00021 1.762800762955764e-07 0 1.7628007629557638e-07 0 1.762900762955764e-07 0.00021 1.763000762955764e-07 0 1.7644547860526156e-07 0 1.7645547860526157e-07 0.00021 1.7646547860526158e-07 0 1.7646547860526155e-07 0 1.7647547860526156e-07 0.00021 1.7648547860526158e-07 0 1.765010216225624e-07 0 1.7651102162256242e-07 0.00021 1.7652102162256243e-07 0 1.7657080101966055e-07 0 1.7658080101966057e-07 0.00021 1.7659080101966058e-07 0 1.766907735177697e-07 0 1.767007735177697e-07 0.00021 1.7671077351776972e-07 0 1.767107735177697e-07 0 1.767207735177697e-07 0.00021 1.7673077351776971e-07 0 1.7678201646353598e-07 0 1.76792016463536e-07 0.00021 1.76802016463536e-07 0 1.7682790641368348e-07 0 1.768379064136835e-07 0.00021 1.768479064136835e-07 0 1.7689536232587492e-07 0 1.7690536232587493e-07 0.00021 1.7691536232587495e-07 0 1.7692062507144682e-07 0 1.7693062507144683e-07 0.00021 1.7694062507144684e-07 0 1.7694906911168295e-07 0 1.7695906911168296e-07 0.00021 1.7696906911168298e-07 0 1.7699835331191458e-07 0 1.770083533119146e-07 0.00021 1.770183533119146e-07 0 1.772120034770245e-07 0 1.772220034770245e-07 0.00021 1.7723200347702452e-07 0 1.7729275514826744e-07 0 1.7730275514826745e-07 0.00021 1.7731275514826746e-07 0 1.7741000758751576e-07 0 1.7742000758751577e-07 0.00021 1.7743000758751578e-07 0 1.7743000758751576e-07 0 1.7744000758751577e-07 0.00021 1.7745000758751578e-07 0 1.7762556860607537e-07 0 1.7763556860607538e-07 0.00021 1.776455686060754e-07 0 1.7764556860607536e-07 0 1.7765556860607537e-07 0.00021 1.7766556860607539e-07 0 1.776839289282523e-07 0 1.7769392892825232e-07 0.00021 1.7770392892825233e-07 0 1.7799781298640124e-07 0 1.7800781298640125e-07 0.00021 1.7801781298640127e-07 0 1.780263062541633e-07 0 1.7803630625416332e-07 0.00021 1.7804630625416333e-07 0 1.7810878820365432e-07 0 1.7811878820365434e-07 0.00021 1.7812878820365435e-07 0 1.7812878820365432e-07 0 1.7813878820365433e-07 0.00021 1.7814878820365434e-07 0 1.7822765629325305e-07 0 1.7823765629325306e-07 0.00021 1.7824765629325307e-07 0 1.7825497019272864e-07 0 1.7826497019272865e-07 0.00021 1.7827497019272866e-07 0 1.7827919454964237e-07 0 1.7828919454964238e-07 0.00021 1.782991945496424e-07 0 1.783190826802148e-07 0 1.783290826802148e-07 0.00021 1.783390826802148e-07 0 1.7835546051124266e-07 0 1.7836546051124267e-07 0.00021 1.7837546051124268e-07 0 1.7837546051124265e-07 0 1.7838546051124266e-07 0.00021 1.7839546051124267e-07 0 1.78424281553786e-07 0 1.7843428155378602e-07 0.00021 1.7844428155378603e-07 0 1.7849320490459247e-07 0 1.7850320490459248e-07 0.00021 1.785132049045925e-07 0 1.7859087863092704e-07 0 1.7860087863092706e-07 0.00021 1.7861087863092707e-07 0 1.7867280917303583e-07 0 1.7868280917303584e-07 0.00021 1.7869280917303585e-07 0 1.788549417279991e-07 0 1.7886494172799912e-07 0.00021 1.7887494172799913e-07 0 1.78879183788559e-07 0 1.7888918378855902e-07 0.00021 1.7889918378855903e-07 0 1.7897678716483668e-07 0 1.789867871648367e-07 0.00021 1.789967871648367e-07 0 1.7902503675912234e-07 0 1.7903503675912235e-07 0.00021 1.7904503675912236e-07 0 1.7911089769858803e-07 0 1.7912089769858804e-07 0.00021 1.7913089769858806e-07 0 1.7913089769858803e-07 0 1.7914089769858804e-07 0.00021 1.7915089769858805e-07 0 1.7917859442920666e-07 0 1.7918859442920667e-07 0.00021 1.7919859442920668e-07 0 1.7927731366349112e-07 0 1.7928731366349113e-07 0.00021 1.7929731366349114e-07 0 1.7940595994808596e-07 0 1.7941595994808597e-07 0.00021 1.7942595994808598e-07 0 1.7948469514989913e-07 0 1.7949469514989914e-07 0.00021 1.7950469514989915e-07 0 1.7950880309464116e-07 0 1.7951880309464117e-07 0.00021 1.7952880309464118e-07 0 1.7952880309464115e-07 0 1.7953880309464117e-07 0.00021 1.7954880309464118e-07 0 1.7969044506902796e-07 0 1.7970044506902797e-07 0.00021 1.7971044506902798e-07 0 1.7973101098152454e-07 0 1.7974101098152455e-07 0.00021 1.7975101098152456e-07 0 1.7976956133390928e-07 0 1.797795613339093e-07 0.00021 1.797895613339093e-07 0 1.7986155840962485e-07 0 1.7987155840962486e-07 0.00021 1.7988155840962488e-07 0 1.7988155840962485e-07 0 1.7989155840962486e-07 0.00021 1.7990155840962487e-07 0 1.7993847198185748e-07 0 1.799484719818575e-07 0.00021 1.799584719818575e-07 0 1.8028531844610093e-07 0 1.8029531844610094e-07 0.00021 1.8030531844610095e-07 0 1.8031757733764246e-07 0 1.8032757733764247e-07 0.00021 1.8033757733764248e-07 0 1.803451870428138e-07 0 1.803551870428138e-07 0.00021 1.8036518704281381e-07 0 1.8044549663419183e-07 0 1.8045549663419184e-07 0.00021 1.8046549663419185e-07 0 1.8046678537896795e-07 0 1.8047678537896796e-07 0.00021 1.8048678537896797e-07 0 1.8050827099654736e-07 0 1.8051827099654737e-07 0.00021 1.8052827099654738e-07 0 1.8052827099654735e-07 0 1.8053827099654736e-07 0.00021 1.8054827099654737e-07 0 1.8054827099654735e-07 0 1.8055827099654736e-07 0.00021 1.8056827099654737e-07 0 1.807057613637374e-07 0 1.807157613637374e-07 0.00021 1.8072576136373742e-07 0 1.807257613637374e-07 0 1.807357613637374e-07 0.00021 1.8074576136373742e-07 0 1.807506732584606e-07 0 1.807606732584606e-07 0.00021 1.8077067325846062e-07 0 1.8078472658711165e-07 0 1.8079472658711166e-07 0.00021 1.8080472658711167e-07 0 1.8081820017524758e-07 0 1.808282001752476e-07 0.00021 1.808382001752476e-07 0 1.8090456015357442e-07 0 1.8091456015357443e-07 0.00021 1.8092456015357444e-07 0 1.809245601535744e-07 0 1.8093456015357442e-07 0.00021 1.8094456015357443e-07 0 1.8107233452095053e-07 0 1.8108233452095054e-07 0.00021 1.8109233452095055e-07 0 1.8125178864634137e-07 0 1.8126178864634138e-07 0.00021 1.812717886463414e-07 0 1.8134205553731138e-07 0 1.813520555373114e-07 0.00021 1.813620555373114e-07 0 1.8137717256792687e-07 0 1.8138717256792688e-07 0.00021 1.813971725679269e-07 0 1.8141307639524497e-07 0 1.8142307639524498e-07 0.00021 1.81433076395245e-07 0 1.8144947216680828e-07 0 1.814594721668083e-07 0.00021 1.814694721668083e-07 0 1.8161520430567452e-07 0 1.8162520430567454e-07 0.00021 1.8163520430567455e-07 0 1.816424395704067e-07 0 1.816524395704067e-07 0.00021 1.816624395704067e-07 0 1.817886795135603e-07 0 1.817986795135603e-07 0.00021 1.8180867951356032e-07 0 1.818166374094478e-07 0 1.8182663740944782e-07 0.00021 1.8183663740944783e-07 0 1.8183930940337472e-07 0 1.8184930940337473e-07 0.00021 1.8185930940337474e-07 0 1.8185959939598538e-07 0 1.818695993959854e-07 0.00021 1.818795993959854e-07 0 1.819938840043401e-07 0 1.8200388400434011e-07 0.00021 1.8201388400434012e-07 0 1.820138840043401e-07 0 1.820238840043401e-07 0.00021 1.8203388400434012e-07 0 1.820338840043401e-07 0 1.820438840043401e-07 0.00021 1.8205388400434012e-07 0 1.8208180663685388e-07 0 1.820918066368539e-07 0.00021 1.821018066368539e-07 0 1.821168702137833e-07 0 1.821268702137833e-07 0.00021 1.8213687021378332e-07 0 1.821721066946755e-07 0 1.8218210669467551e-07 0.00021 1.8219210669467552e-07 0 1.8227462368792378e-07 0 1.822846236879238e-07 0.00021 1.822946236879238e-07 0 1.8233559277280544e-07 0 1.8234559277280545e-07 0.00021 1.8235559277280546e-07 0 1.8255428117371864e-07 0 1.8256428117371866e-07 0.00021 1.8257428117371867e-07 0 1.8266249169432755e-07 0 1.8267249169432756e-07 0.00021 1.8268249169432757e-07 0 1.8268249169432755e-07 0 1.8269249169432756e-07 0.00021 1.8270249169432757e-07 0 1.8293182297982704e-07 0 1.8294182297982705e-07 0.00021 1.8295182297982707e-07 0 1.8295182297982704e-07 0 1.8296182297982705e-07 0.00021 1.8297182297982706e-07 0 1.832194702508971e-07 0 1.832294702508971e-07 0.00021 1.8323947025089712e-07 0 1.8324376790784165e-07 0 1.8325376790784166e-07 0.00021 1.8326376790784168e-07 0 1.8326376790784165e-07 0 1.8327376790784166e-07 0.00021 1.8328376790784167e-07 0 1.834460638696521e-07 0 1.834560638696521e-07 0.00021 1.8346606386965212e-07 0 1.8350619221352455e-07 0 1.8351619221352456e-07 0.00021 1.8352619221352457e-07 0 1.8369015274333043e-07 0 1.8370015274333044e-07 0.00021 1.8371015274333046e-07 0 1.8372339444919818e-07 0 1.837333944491982e-07 0.00021 1.837433944491982e-07 0 1.839614765501907e-07 0 1.839714765501907e-07 0.00021 1.8398147655019072e-07 0 1.8406301130167138e-07 0 1.840730113016714e-07 0.00021 1.840830113016714e-07 0 1.841661514059105e-07 0 1.841761514059105e-07 0.00021 1.8418615140591052e-07 0 1.843340629325291e-07 0 1.843440629325291e-07 0.00021 1.8435406293252912e-07 0 1.843540629325291e-07 0 1.843640629325291e-07 0.00021 1.843740629325291e-07 0 1.8437406293252909e-07 0 1.843840629325291e-07 0.00021 1.843940629325291e-07 0 1.8439406293252908e-07 0 1.844040629325291e-07 0.00021 1.844140629325291e-07 0 1.844920629747155e-07 0 1.8450206297471552e-07 0.00021 1.8451206297471553e-07 0 1.8467544331190138e-07 0 1.846854433119014e-07 0.00021 1.846954433119014e-07 0 1.8469544331190137e-07 0 1.8470544331190138e-07 0.00021 1.847154433119014e-07 0 1.8478917674821234e-07 0 1.8479917674821236e-07 0.00021 1.8480917674821237e-07 0 1.8482747609389214e-07 0 1.8483747609389216e-07 0.00021 1.8484747609389217e-07 0 1.8497139705572853e-07 0 1.8498139705572854e-07 0.00021 1.8499139705572855e-07 0 1.8500448940326228e-07 0 1.850144894032623e-07 0.00021 1.850244894032623e-07 0 1.852003358889577e-07 0 1.8521033588895772e-07 0.00021 1.8522033588895773e-07 0 1.8528326472801395e-07 0 1.8529326472801396e-07 0.00021 1.8530326472801397e-07 0 1.8555655784477188e-07 0 1.855665578447719e-07 0.00021 1.855765578447719e-07 0 1.8561021959494245e-07 0 1.8562021959494246e-07 0.00021 1.8563021959494247e-07 0 1.8577775974803466e-07 0 1.8578775974803467e-07 0.00021 1.8579775974803468e-07 0 1.8592534704616386e-07 0 1.8593534704616387e-07 0.00021 1.8594534704616388e-07 0 1.8594534704616385e-07 0 1.8595534704616387e-07 0.00021 1.8596534704616388e-07 0 1.8598662958340041e-07 0 1.8599662958340043e-07 0.00021 1.8600662958340044e-07 0 1.860963644248119e-07 0 1.8610636442481191e-07 0.00021 1.8611636442481193e-07 0 1.8618661989125333e-07 0 1.8619661989125334e-07 0.00021 1.8620661989125335e-07 0 1.8625873126542085e-07 0 1.8626873126542086e-07 0.00021 1.8627873126542087e-07 0 1.862817983757491e-07 0 1.862917983757491e-07 0.00021 1.8630179837574911e-07 0 1.863017983757491e-07 0 1.863117983757491e-07 0.00021 1.863217983757491e-07 0 1.8637489322871063e-07 0 1.8638489322871064e-07 0.00021 1.8639489322871065e-07 0 1.864101532106161e-07 0 1.8642015321061612e-07 0.00021 1.8643015321061613e-07 0 1.864301532106161e-07 0 1.864401532106161e-07 0.00021 1.8645015321061612e-07 0 1.867335068021257e-07 0 1.867435068021257e-07 0.00021 1.867535068021257e-07 0 1.8683527729566454e-07 0 1.8684527729566456e-07 0.00021 1.8685527729566457e-07 0 1.8685527729566454e-07 0 1.8686527729566455e-07 0.00021 1.8687527729566456e-07 0 1.8702350998374437e-07 0 1.8703350998374438e-07 0.00021 1.870435099837444e-07 0 1.8704350998374437e-07 0 1.8705350998374438e-07 0.00021 1.870635099837444e-07 0 1.8706680329628465e-07 0 1.8707680329628466e-07 0.00021 1.8708680329628467e-07 0 1.8710835700879544e-07 0 1.8711835700879545e-07 0.00021 1.8712835700879546e-07 0 1.87304924767975e-07 0 1.8731492476797502e-07 0.00021 1.8732492476797503e-07 0 1.87324924767975e-07 0 1.87334924767975e-07 0.00021 1.8734492476797502e-07 0 1.873461713858552e-07 0 1.873561713858552e-07 0.00021 1.8736617138585521e-07 0 1.8745718284346943e-07 0 1.8746718284346945e-07 0.00021 1.8747718284346946e-07 0 1.8750310121049664e-07 0 1.8751310121049665e-07 0.00021 1.8752310121049666e-07 0 1.8766080763066017e-07 0 1.8767080763066018e-07 0.00021 1.876808076306602e-07 0 1.8768080763066017e-07 0 1.8769080763066018e-07 0.00021 1.877008076306602e-07 0 1.8775386189117213e-07 0 1.8776386189117214e-07 0.00021 1.8777386189117215e-07 0 1.878559586879497e-07 0 1.878659586879497e-07 0.00021 1.8787595868794972e-07 0 1.8787753689407472e-07 0 1.8788753689407473e-07 0.00021 1.8789753689407474e-07 0 1.878975368940747e-07 0 1.8790753689407472e-07 0.00021 1.8791753689407474e-07 0 1.879175368940747e-07 0 1.8792753689407472e-07 0.00021 1.8793753689407473e-07 0 1.879375368940747e-07 0 1.8794753689407472e-07 0.00021 1.8795753689407473e-07 0 1.879575368940747e-07 0 1.879675368940747e-07 0.00021 1.8797753689407472e-07 0 1.881064650722053e-07 0 1.881164650722053e-07 0.00021 1.8812646507220532e-07 0 1.882436726542963e-07 0 1.882536726542963e-07 0.00021 1.8826367265429632e-07 0 1.882636726542963e-07 0 1.882736726542963e-07 0.00021 1.882836726542963e-07 0 1.8835744262160065e-07 0 1.8836744262160066e-07 0.00021 1.8837744262160067e-07 0 1.88399313334513e-07 0 1.88409313334513e-07 0.00021 1.8841931333451302e-07 0 1.8853201429407547e-07 0 1.8854201429407549e-07 0.00021 1.885520142940755e-07 0 1.8860531896127326e-07 0 1.8861531896127327e-07 0.00021 1.8862531896127329e-07 0 1.8869843547662245e-07 0 1.8870843547662246e-07 0.00021 1.8871843547662247e-07 0 1.8872698874706345e-07 0 1.8873698874706346e-07 0.00021 1.8874698874706347e-07 0 1.8879081304851346e-07 0 1.8880081304851348e-07 0.00021 1.888108130485135e-07 0 1.8881081304851346e-07 0 1.8882081304851347e-07 0.00021 1.8883081304851348e-07 0 1.891136411953319e-07 0 1.891236411953319e-07 0.00021 1.891336411953319e-07 0 1.891975672957833e-07 0 1.8920756729578332e-07 0.00021 1.8921756729578333e-07 0 1.893688761564805e-07 0 1.8937887615648051e-07 0.00021 1.8938887615648053e-07 0 1.8977967122329538e-07 0 1.8978967122329539e-07 0.00021 1.897996712232954e-07 0 1.8980431977269648e-07 0 1.898143197726965e-07 0.00021 1.898243197726965e-07 0 1.8982910112136187e-07 0 1.8983910112136188e-07 0.00021 1.898491011213619e-07 0 1.899612053414894e-07 0 1.899712053414894e-07 0.00021 1.8998120534148942e-07 0 1.9004720808204707e-07 0 1.9005720808204708e-07 0.00021 1.900672080820471e-07 0 1.9013688387044963e-07 0 1.9014688387044964e-07 0.00021 1.9015688387044965e-07 0 1.9027066278518174e-07 0 1.9028066278518175e-07 0.00021 1.9029066278518177e-07 0 1.9029066278518174e-07 0 1.9030066278518175e-07 0.00021 1.9031066278518176e-07 0 1.9036878998361982e-07 0 1.9037878998361983e-07 0.00021 1.9038878998361984e-07 0 1.9048973683430914e-07 0 1.9049973683430915e-07 0.00021 1.9050973683430916e-07 0 1.9050973683430913e-07 0 1.9051973683430915e-07 0.00021 1.9052973683430916e-07 0 1.906093810924367e-07 0 1.906193810924367e-07 0.00021 1.9062938109243672e-07 0 1.9063775877745246e-07 0 1.9064775877745247e-07 0.00021 1.9065775877745248e-07 0 1.9067122760656946e-07 0 1.9068122760656947e-07 0.00021 1.9069122760656948e-07 0 1.908911763565379e-07 0 1.909011763565379e-07 0.00021 1.909111763565379e-07 0 1.9097716972076496e-07 0 1.9098716972076497e-07 0.00021 1.9099716972076498e-07 0 1.9101009869409045e-07 0 1.9102009869409047e-07 0.00021 1.9103009869409048e-07 0 1.9116073169355222e-07 0 1.9117073169355223e-07 0.00021 1.9118073169355224e-07 0 1.9124602225948321e-07 0 1.9125602225948323e-07 0.00021 1.9126602225948324e-07 0 1.9134739919922828e-07 0 1.913573991992283e-07 0.00021 1.913673991992283e-07 0 1.9146321137894536e-07 0 1.9147321137894537e-07 0.00021 1.9148321137894538e-07 0 1.9151272036479675e-07 0 1.9152272036479677e-07 0.00021 1.9153272036479678e-07 0 1.9168545891082118e-07 0 1.916954589108212e-07 0.00021 1.917054589108212e-07 0 1.9170545891082117e-07 0 1.9171545891082119e-07 0.00021 1.917254589108212e-07 0 1.9173619416461525e-07 0 1.9174619416461526e-07 0.00021 1.9175619416461527e-07 0 1.9186284795724316e-07 0 1.9187284795724317e-07 0.00021 1.9188284795724318e-07 0 1.9188284795724316e-07 0 1.9189284795724317e-07 0.00021 1.9190284795724318e-07 0 1.919574563540368e-07 0 1.9196745635403682e-07 0.00021 1.9197745635403683e-07 0 1.9223161115792415e-07 0 1.9224161115792416e-07 0.00021 1.9225161115792417e-07 0 1.923634734478416e-07 0 1.923734734478416e-07 0.00021 1.9238347344784162e-07 0 1.9247552883149023e-07 0 1.9248552883149024e-07 0.00021 1.9249552883149025e-07 0 1.9272795620285293e-07 0 1.9273795620285294e-07 0.00021 1.9274795620285295e-07 0 1.9276948779178333e-07 0 1.9277948779178335e-07 0.00021 1.9278948779178336e-07 0 1.9285821254866087e-07 0 1.9286821254866088e-07 0.00021 1.928782125486609e-07 0 1.930674411330947e-07 0 1.9307744113309472e-07 0.00021 1.9308744113309474e-07 0 1.930874411330947e-07 0 1.9309744113309472e-07 0.00021 1.9310744113309473e-07 0 1.932269335887019e-07 0 1.9323693358870192e-07 0.00021 1.9324693358870193e-07 0 1.932469335887019e-07 0 1.9325693358870192e-07 0.00021 1.9326693358870193e-07 0 1.9340117306197842e-07 0 1.9341117306197844e-07 0.00021 1.9342117306197845e-07 0 1.934334042736089e-07 0 1.934434042736089e-07 0.00021 1.9345340427360892e-07 0 1.934534042736089e-07 0 1.934634042736089e-07 0.00021 1.934734042736089e-07 0 1.9347340427360888e-07 0 1.934834042736089e-07 0.00021 1.934934042736089e-07 0 1.936464964433865e-07 0 1.936564964433865e-07 0.00021 1.9366649644338652e-07 0 1.936664964433865e-07 0 1.936764964433865e-07 0.00021 1.9368649644338652e-07 0 1.936864964433865e-07 0 1.936964964433865e-07 0.00021 1.9370649644338652e-07 0 1.937064964433865e-07 0 1.937164964433865e-07 0.00021 1.937264964433865e-07 0 1.9373843054205374e-07 0 1.9374843054205375e-07 0.00021 1.9375843054205376e-07 0 1.9375843054205374e-07 0 1.9376843054205375e-07 0.00021 1.9377843054205376e-07 0 1.9379447859005978e-07 0 1.938044785900598e-07 0.00021 1.938144785900598e-07 0 1.9399240335997435e-07 0 1.9400240335997436e-07 0.00021 1.9401240335997437e-07 0 1.9434396308205235e-07 0 1.9435396308205237e-07 0.00021 1.9436396308205238e-07 0 1.9436396308205235e-07 0 1.9437396308205236e-07 0.00021 1.9438396308205237e-07 0 1.9438396308205235e-07 0 1.9439396308205236e-07 0.00021 1.9440396308205237e-07 0 1.9440396308205234e-07 0 1.9441396308205235e-07 0.00021 1.9442396308205237e-07 0 1.9442396308205234e-07 0 1.9443396308205235e-07 0.00021 1.9444396308205236e-07 0 1.9444396308205234e-07 0 1.9445396308205235e-07 0.00021 1.9446396308205236e-07 0 1.9447400443779685e-07 0 1.9448400443779686e-07 0.00021 1.9449400443779688e-07 0 1.9469135839299487e-07 0 1.9470135839299488e-07 0.00021 1.947113583929949e-07 0 1.9485226731702195e-07 0 1.9486226731702196e-07 0.00021 1.9487226731702197e-07 0 1.9496890700675745e-07 0 1.9497890700675747e-07 0.00021 1.9498890700675748e-07 0 1.9500830763729488e-07 0 1.950183076372949e-07 0.00021 1.950283076372949e-07 0 1.9502830763729488e-07 0 1.950383076372949e-07 0.00021 1.950483076372949e-07 0 1.9512387734346863e-07 0 1.9513387734346864e-07 0.00021 1.9514387734346865e-07 0 1.9520504333859714e-07 0 1.9521504333859715e-07 0.00021 1.9522504333859716e-07 0 1.9522504333859713e-07 0 1.9523504333859714e-07 0.00021 1.9524504333859716e-07 0 1.952850095483347e-07 0 1.952950095483347e-07 0.00021 1.953050095483347e-07 0 1.9530500954833469e-07 0 1.953150095483347e-07 0.00021 1.953250095483347e-07 0 1.9538729601789623e-07 0 1.9539729601789625e-07 0.00021 1.9540729601789626e-07 0 1.9543685045284924e-07 0 1.9544685045284925e-07 0.00021 1.9545685045284926e-07 0 1.9546594093473938e-07 0 1.954759409347394e-07 0.00021 1.954859409347394e-07 0 1.955812097576155e-07 0 1.955912097576155e-07 0.00021 1.9560120975761551e-07 0 1.956012097576155e-07 0 1.956112097576155e-07 0.00021 1.956212097576155e-07 0 1.9587184389525785e-07 0 1.9588184389525786e-07 0.00021 1.9589184389525787e-07 0 1.9598191423695233e-07 0 1.9599191423695234e-07 0.00021 1.9600191423695235e-07 0 1.9603205805152765e-07 0 1.9604205805152766e-07 0.00021 1.9605205805152767e-07 0 1.9605205805152765e-07 0 1.9606205805152766e-07 0.00021 1.9607205805152767e-07 0 1.9607205805152764e-07 0 1.9608205805152765e-07 0.00021 1.9609205805152767e-07 0 1.9630463704428473e-07 0 1.9631463704428474e-07 0.00021 1.9632463704428475e-07 0 1.9632463704428472e-07 0 1.9633463704428473e-07 0.00021 1.9634463704428474e-07 0 1.9634463704428472e-07 0 1.9635463704428473e-07 0.00021 1.9636463704428474e-07 0 1.9636463704428471e-07 0 1.9637463704428473e-07 0.00021 1.9638463704428474e-07 0 1.963846370442847e-07 0 1.9639463704428472e-07 0.00021 1.9640463704428473e-07 0 1.965633561786929e-07 0 1.9657335617869292e-07 0.00021 1.9658335617869293e-07 0 1.9671486989004989e-07 0 1.967248698900499e-07 0.00021 1.967348698900499e-07 0 1.9685757898577602e-07 0 1.9686757898577603e-07 0.00021 1.9687757898577605e-07 0 1.9697047594000368e-07 0 1.969804759400037e-07 0.00021 1.969904759400037e-07 0 1.9699047594000368e-07 0 1.970004759400037e-07 0.00021 1.970104759400037e-07 0 1.9703076432136904e-07 0 1.9704076432136905e-07 0.00021 1.9705076432136906e-07 0 1.9712211178333757e-07 0 1.9713211178333758e-07 0.00021 1.971421117833376e-07 0 1.9714211178333756e-07 0 1.9715211178333757e-07 0.00021 1.9716211178333759e-07 0 1.9737835015614034e-07 0 1.9738835015614035e-07 0.00021 1.9739835015614036e-07 0 1.9752961688271554e-07 0 1.9753961688271555e-07 0.00021 1.9754961688271556e-07 0 1.9775996284852395e-07 0 1.9776996284852396e-07 0.00021 1.9777996284852397e-07 0 1.9786863456226328e-07 0 1.978786345622633e-07 0.00021 1.978886345622633e-07 0 1.979569118865194e-07 0 1.979669118865194e-07 0.00021 1.9797691188651942e-07 0 1.980964151740855e-07 0 1.981064151740855e-07 0.00021 1.9811641517408552e-07 0 1.981164151740855e-07 0 1.981264151740855e-07 0.00021 1.981364151740855e-07 0 1.9813641517408549e-07 0 1.981464151740855e-07 0.00021 1.981564151740855e-07 0 1.9817822356429227e-07 0 1.9818822356429228e-07 0.00021 1.981982235642923e-07 0 1.9824950671054743e-07 0 1.9825950671054744e-07 0.00021 1.9826950671054745e-07 0 1.9826950671054743e-07 0 1.9827950671054744e-07 0.00021 1.9828950671054745e-07 0 1.9831852358273443e-07 0 1.9832852358273444e-07 0.00021 1.9833852358273445e-07 0 1.9838090883425468e-07 0 1.983909088342547e-07 0.00021 1.984009088342547e-07 0 1.986400253803779e-07 0 1.986500253803779e-07 0.00021 1.9866002538037792e-07 0 1.986600253803779e-07 0 1.986700253803779e-07 0.00021 1.9868002538037792e-07 0 1.986800253803779e-07 0 1.986900253803779e-07 0.00021 1.9870002538037792e-07 0 1.9879174566846503e-07 0 1.9880174566846505e-07 0.00021 1.9881174566846506e-07 0 1.9888276466815048e-07 0 1.988927646681505e-07 0.00021 1.989027646681505e-07 0 1.989500876175488e-07 0 1.989600876175488e-07 0.00021 1.989700876175488e-07 0 1.990375716231248e-07 0 1.9904757162312482e-07 0.00021 1.9905757162312483e-07 0 1.990575716231248e-07 0 1.9906757162312482e-07 0.00021 1.9907757162312483e-07 0 1.9909218798107695e-07 0 1.9910218798107697e-07 0.00021 1.9911218798107698e-07 0 1.9911218798107695e-07 0 1.9912218798107696e-07 0.00021 1.9913218798107697e-07 0 1.9913218798107695e-07 0 1.9914218798107696e-07 0.00021 1.9915218798107697e-07 0 1.994353812357879e-07 0 1.994453812357879e-07 0.00021 1.9945538123578791e-07 0 1.994553812357879e-07 0 1.994653812357879e-07 0.00021 1.994753812357879e-07 0 1.9947538123578788e-07 0 1.994853812357879e-07 0.00021 1.994953812357879e-07 0 1.9955294729057072e-07 0 1.9956294729057073e-07 0.00021 1.9957294729057074e-07 0 1.9982011130570378e-07 0 1.998301113057038e-07 0.00021 1.998401113057038e-07 0 1.9988682806691775e-07 0 1.9989682806691776e-07 0.00021 1.9990682806691778e-07 0 1.9991968351806012e-07 0 1.9992968351806013e-07 0.00021 1.9993968351806014e-07 0 1.999396835180601e-07 0 1.9994968351806012e-07 0.00021 1.9995968351806013e-07 0 1.999596835180601e-07 0 1.9996968351806012e-07 0.00021 1.9997968351806013e-07 0 2.0010446405702723e-07 0 2.0011446405702724e-07 0.00021 2.0012446405702725e-07 0 2.0015564664494205e-07 0 2.0016564664494206e-07 0.00021 2.0017564664494207e-07 0 2.0034805207323152e-07 0 2.0035805207323153e-07 0.00021 2.0036805207323155e-07 0 2.0036805207323152e-07 0 2.0037805207323153e-07 0.00021 2.0038805207323154e-07 0 2.0038805207323151e-07 0 2.0039805207323153e-07 0.00021 2.0040805207323154e-07 0 2.004080520732315e-07 0 2.0041805207323152e-07 0.00021 2.0042805207323153e-07 0 2.0059418437970391e-07 0 2.0060418437970393e-07 0.00021 2.0061418437970394e-07 0 2.007103577798646e-07 0 2.0072035777986462e-07 0.00021 2.0073035777986463e-07 0 2.007582021033328e-07 0 2.007682021033328e-07 0.00021 2.0077820210333282e-07 0 2.007782021033328e-07 0 2.007882021033328e-07 0.00021 2.0079820210333282e-07 0 2.01258747087075e-07 0 2.0126874708707502e-07 0.00021 2.0127874708707503e-07 0 2.01278747087075e-07 0 2.0128874708707502e-07 0.00021 2.0129874708707503e-07 0 2.01298747087075e-07 0 2.0130874708707502e-07 0.00021 2.0131874708707503e-07 0 2.0140722215272243e-07 0 2.0141722215272244e-07 0.00021 2.0142722215272245e-07 0 2.0142722215272243e-07 0 2.0143722215272244e-07 0.00021 2.0144722215272245e-07 0 2.0158599872826112e-07 0 2.0159599872826113e-07 0.00021 2.0160599872826115e-07 0 2.0160599872826112e-07 0 2.0161599872826113e-07 0.00021 2.0162599872826114e-07 0 2.0171582881921148e-07 0 2.017258288192115e-07 0.00021 2.017358288192115e-07 0 2.0174264872875102e-07 0 2.0175264872875103e-07 0.00021 2.0176264872875104e-07 0 2.018825474991876e-07 0 2.018925474991876e-07 0.00021 2.0190254749918762e-07 0 2.0192476877992807e-07 0 2.0193476877992808e-07 0.00021 2.019447687799281e-07 0 2.020923784382116e-07 0 2.021023784382116e-07 0.00021 2.0211237843821162e-07 0 2.0213629072167884e-07 0 2.0214629072167886e-07 0.00021 2.0215629072167887e-07 0 2.0215629072167884e-07 0 2.0216629072167885e-07 0.00021 2.0217629072167886e-07 0 2.0219288281624456e-07 0 2.0220288281624457e-07 0.00021 2.0221288281624458e-07 0 2.022178941388194e-07 0 2.0222789413881942e-07 0.00021 2.0223789413881944e-07 0 2.0224100986648156e-07 0 2.0225100986648157e-07 0.00021 2.0226100986648158e-07 0 2.0239276462567107e-07 0 2.0240276462567108e-07 0.00021 2.024127646256711e-07 0 2.0246370232294694e-07 0 2.0247370232294695e-07 0.00021 2.0248370232294696e-07 0 2.0248370232294693e-07 0 2.0249370232294695e-07 0.00021 2.0250370232294696e-07 0 2.0255239604854045e-07 0 2.0256239604854046e-07 0.00021 2.0257239604854047e-07 0 2.025987171263662e-07 0 2.0260871712636622e-07 0.00021 2.0261871712636623e-07 0 2.0267487848896037e-07 0 2.0268487848896038e-07 0.00021 2.026948784889604e-07 0 2.0276293159508958e-07 0 2.027729315950896e-07 0.00021 2.027829315950896e-07 0 2.027974926752561e-07 0 2.028074926752561e-07 0.00021 2.0281749267525611e-07 0 2.0282282686536403e-07 0 2.0283282686536404e-07 0.00021 2.0284282686536405e-07 0 2.0284282686536403e-07 0 2.0285282686536404e-07 0.00021 2.0286282686536405e-07 0 2.0286282686536402e-07 0 2.0287282686536403e-07 0.00021 2.0288282686536405e-07 0 2.0288282686536402e-07 0 2.0289282686536403e-07 0.00021 2.0290282686536404e-07 0 2.029377056410191e-07 0 2.0294770564101912e-07 0.00021 2.0295770564101913e-07 0 2.0319737022430852e-07 0 2.0320737022430853e-07 0.00021 2.0321737022430854e-07 0 2.0321737022430852e-07 0 2.0322737022430853e-07 0.00021 2.0323737022430854e-07 0 2.032761514506684e-07 0 2.032861514506684e-07 0.00021 2.0329615145066842e-07 0 2.0334005681498457e-07 0 2.0335005681498458e-07 0.00021 2.033600568149846e-07 0 2.0344690152157194e-07 0 2.0345690152157195e-07 0.00021 2.0346690152157196e-07 0 2.0361507996196294e-07 0 2.0362507996196295e-07 0.00021 2.0363507996196296e-07 0 2.0365159223182273e-07 0 2.0366159223182274e-07 0.00021 2.0367159223182275e-07 0 2.0367159223182273e-07 0 2.0368159223182274e-07 0.00021 2.0369159223182275e-07 0 2.0369159223182272e-07 0 2.0370159223182274e-07 0.00021 2.0371159223182275e-07 0 2.0399886811349683e-07 0 2.0400886811349684e-07 0.00021 2.0401886811349685e-07 0 2.040932222570614e-07 0 2.0410322225706142e-07 0.00021 2.0411322225706143e-07 0 2.0420093066863063e-07 0 2.0421093066863064e-07 0.00021 2.0422093066863065e-07 0 2.0445505609568442e-07 0 2.0446505609568443e-07 0.00021 2.0447505609568444e-07 0 2.0448152810607822e-07 0 2.0449152810607823e-07 0.00021 2.0450152810607825e-07 0 2.045582448371224e-07 0 2.0456824483712242e-07 0.00021 2.0457824483712243e-07 0 2.045782448371224e-07 0 2.0458824483712241e-07 0.00021 2.0459824483712243e-07 0 2.0471267087874897e-07 0 2.0472267087874898e-07 0.00021 2.04732670878749e-07 0 2.0489091727110589e-07 0 2.049009172711059e-07 0.00021 2.049109172711059e-07 0 2.0494118943302096e-07 0 2.0495118943302097e-07 0.00021 2.0496118943302098e-07 0 2.051599980720417e-07 0 2.051699980720417e-07 0.00021 2.0517999807204172e-07 0 2.051799980720417e-07 0 2.051899980720417e-07 0.00021 2.0519999807204172e-07 0 2.0520188994415608e-07 0 2.052118899441561e-07 0.00021 2.052218899441561e-07 0 2.0527902558757723e-07 0 2.0528902558757724e-07 0.00021 2.0529902558757726e-07 0 2.0533161609612586e-07 0 2.0534161609612587e-07 0.00021 2.0535161609612589e-07 0 2.0535161609612586e-07 0 2.0536161609612587e-07 0.00021 2.0537161609612588e-07 0 2.0537305863910136e-07 0 2.0538305863910137e-07 0.00021 2.0539305863910138e-07 0 2.056175416946845e-07 0 2.056275416946845e-07 0.00021 2.0563754169468452e-07 0 2.0570748454792098e-07 0 2.05717484547921e-07 0.00021 2.05727484547921e-07 0 2.0583345292966288e-07 0 2.058434529296629e-07 0.00021 2.058534529296629e-07 0 2.0594695224399392e-07 0 2.0595695224399394e-07 0.00021 2.0596695224399395e-07 0 2.0599238628260384e-07 0 2.0600238628260385e-07 0.00021 2.0601238628260386e-07 0 2.061640520148033e-07 0 2.061740520148033e-07 0.00021 2.0618405201480332e-07 0 2.061840520148033e-07 0 2.061940520148033e-07 0.00021 2.0620405201480332e-07 0 2.0631697237792557e-07 0 2.0632697237792558e-07 0.00021 2.063369723779256e-07 0 2.0638492261966084e-07 0 2.0639492261966085e-07 0.00021 2.0640492261966086e-07 0 2.064166471195733e-07 0 2.064266471195733e-07 0.00021 2.064366471195733e-07 0 2.065835688913557e-07 0 2.0659356889135572e-07 0.00021 2.0660356889135573e-07 0 2.0667586457946752e-07 0 2.0668586457946753e-07 0.00021 2.0669586457946754e-07 0 2.0683128114879213e-07 0 2.0684128114879214e-07 0.00021 2.0685128114879215e-07 0 2.0706097235037074e-07 0 2.0707097235037075e-07 0.00021 2.0708097235037076e-07 0 2.0716414347184108e-07 0 2.071741434718411e-07 0.00021 2.071841434718411e-07 0 2.073209601745951e-07 0 2.0733096017459512e-07 0.00021 2.0734096017459513e-07 0 2.0739171685636152e-07 0 2.0740171685636153e-07 0.00021 2.0741171685636154e-07 0 2.0747559896259275e-07 0 2.0748559896259276e-07 0.00021 2.0749559896259277e-07 0 2.0755500846570405e-07 0 2.0756500846570406e-07 0.00021 2.0757500846570407e-07 0 2.0757609448828583e-07 0 2.0758609448828584e-07 0.00021 2.0759609448828585e-07 0 2.076545563795219e-07 0 2.076645563795219e-07 0.00021 2.0767455637952192e-07 0 2.0767730213655047e-07 0 2.0768730213655048e-07 0.00021 2.076973021365505e-07 0 2.0774145066105347e-07 0 2.0775145066105348e-07 0.00021 2.077614506610535e-07 0 2.078246550576781e-07 0 2.078346550576781e-07 0.00021 2.078446550576781e-07 0 2.0784557981042593e-07 0 2.0785557981042594e-07 0.00021 2.0786557981042595e-07 0 2.0797159656060306e-07 0 2.0798159656060307e-07 0.00021 2.0799159656060308e-07 0 2.0800675566793953e-07 0 2.0801675566793954e-07 0.00021 2.0802675566793956e-07 0 2.081886537805365e-07 0 2.081986537805365e-07 0.00021 2.0820865378053651e-07 0 2.082396195002008e-07 0 2.0824961950020082e-07 0.00021 2.0825961950020084e-07 0 2.0841240898702827e-07 0 2.0842240898702829e-07 0.00021 2.084324089870283e-07 0 2.0855987109072175e-07 0 2.0856987109072176e-07 0.00021 2.0857987109072177e-07 0 2.086489428703427e-07 0 2.086589428703427e-07 0.00021 2.0866894287034271e-07 0 2.0867019811466593e-07 0 2.0868019811466594e-07 0.00021 2.0869019811466595e-07 0 2.0875393535488062e-07 0 2.0876393535488063e-07 0.00021 2.0877393535488064e-07 0 2.0882304877456643e-07 0 2.0883304877456644e-07 0.00021 2.0884304877456645e-07 0 2.0885130773117946e-07 0 2.0886130773117947e-07 0.00021 2.0887130773117948e-07 0 2.0898482269043819e-07 0 2.089948226904382e-07 0.00021 2.090048226904382e-07 0 2.0900482269043818e-07 0 2.090148226904382e-07 0.00021 2.090248226904382e-07 0 2.0902482269043818e-07 0 2.090348226904382e-07 0.00021 2.090448226904382e-07 0 2.0906585192004392e-07 0 2.0907585192004393e-07 0.00021 2.0908585192004394e-07 0 2.0909841942914045e-07 0 2.0910841942914046e-07 0.00021 2.0911841942914047e-07 0 2.0915566195679326e-07 0 2.0916566195679327e-07 0.00021 2.0917566195679328e-07 0 2.0918387668426665e-07 0 2.0919387668426666e-07 0.00021 2.0920387668426667e-07 0 2.0923887308224994e-07 0 2.0924887308224996e-07 0.00021 2.0925887308224997e-07 0 2.0936444747534857e-07 0 2.0937444747534858e-07 0.00021 2.093844474753486e-07 0 2.0959622567538557e-07 0 2.0960622567538559e-07 0.00021 2.096162256753856e-07 0 2.0961622567538557e-07 0 2.0962622567538558e-07 0.00021 2.096362256753856e-07 0 2.0966767644425662e-07 0 2.0967767644425663e-07 0.00021 2.0968767644425664e-07 0 2.096876764442566e-07 0 2.0969767644425662e-07 0.00021 2.0970767644425663e-07 0 2.099148702514068e-07 0 2.0992487025140682e-07 0.00021 2.0993487025140683e-07 0 2.100689626870237e-07 0 2.1007896268702372e-07 0.00021 2.1008896268702373e-07 0 2.1019368391322156e-07 0 2.1020368391322157e-07 0.00021 2.1021368391322158e-07 0 2.1032582991221527e-07 0 2.1033582991221528e-07 0.00021 2.103458299122153e-07 0 2.1044771413905663e-07 0 2.1045771413905664e-07 0.00021 2.1046771413905666e-07 0 2.1046771413905663e-07 0 2.1047771413905664e-07 0.00021 2.1048771413905665e-07 0 2.1061720123901052e-07 0 2.1062720123901053e-07 0.00021 2.1063720123901054e-07 0 2.106681900457419e-07 0 2.106781900457419e-07 0.00021 2.106881900457419e-07 0 2.10722218801162e-07 0 2.1073221880116202e-07 0.00021 2.1074221880116203e-07 0 2.10742218801162e-07 0 2.1075221880116201e-07 0.00021 2.1076221880116203e-07 0 2.1076298322637687e-07 0 2.1077298322637688e-07 0.00021 2.107829832263769e-07 0 2.1079044731382722e-07 0 2.1080044731382723e-07 0.00021 2.1081044731382724e-07 0 2.1085633610094933e-07 0 2.1086633610094934e-07 0.00021 2.1087633610094935e-07 0 2.10923409923342e-07 0 2.1093340992334201e-07 0.00021 2.1094340992334203e-07 0 2.109716368690932e-07 0 2.109816368690932e-07 0.00021 2.1099163686909322e-07 0 2.1108235867842933e-07 0 2.1109235867842934e-07 0.00021 2.1110235867842935e-07 0 2.1110235867842933e-07 0 2.1111235867842934e-07 0.00021 2.1112235867842935e-07 0 2.111758326810521e-07 0 2.111858326810521e-07 0.00021 2.111958326810521e-07 0 2.112414596686027e-07 0 2.1125145966860272e-07 0.00021 2.1126145966860273e-07 0 2.112614596686027e-07 0 2.1127145966860271e-07 0.00021 2.1128145966860273e-07 0 2.112814596686027e-07 0 2.112914596686027e-07 0.00021 2.1130145966860272e-07 0 2.113014596686027e-07 0 2.113114596686027e-07 0.00021 2.1132145966860272e-07 0 2.113214596686027e-07 0 2.113314596686027e-07 0.00021 2.1134145966860271e-07 0 2.113414596686027e-07 0 2.113514596686027e-07 0.00021 2.113614596686027e-07 0 2.1136145966860268e-07 0 2.113714596686027e-07 0.00021 2.113814596686027e-07 0 2.1146621376520848e-07 0 2.114762137652085e-07 0.00021 2.114862137652085e-07 0 2.1148621376520848e-07 0 2.114962137652085e-07 0.00021 2.115062137652085e-07 0 2.1150621376520847e-07 0 2.1151621376520848e-07 0.00021 2.115262137652085e-07 0 2.1152621376520847e-07 0 2.1153621376520848e-07 0.00021 2.115462137652085e-07 0 2.1155550395642933e-07 0 2.1156550395642934e-07 0.00021 2.1157550395642936e-07 0 2.1157958959748204e-07 0 2.1158958959748205e-07 0.00021 2.1159958959748207e-07 0 2.1159958959748204e-07 0 2.1160958959748205e-07 0.00021 2.1161958959748206e-07 0 2.1161958959748204e-07 0 2.1162958959748205e-07 0.00021 2.1163958959748206e-07 0 2.117825506720309e-07 0 2.1179255067203092e-07 0.00021 2.1180255067203093e-07 0 2.1187570640200645e-07 0 2.1188570640200646e-07 0.00021 2.1189570640200647e-07 0 2.1198515005454057e-07 0 2.1199515005454059e-07 0.00021 2.120051500545406e-07 0 2.1200515005454057e-07 0 2.1201515005454058e-07 0.00021 2.120251500545406e-07 0 2.1202640165901452e-07 0 2.1203640165901453e-07 0.00021 2.1204640165901455e-07 0 2.1249545071203338e-07 0 2.125054507120334e-07 0.00021 2.125154507120334e-07 0 2.1253910938273096e-07 0 2.1254910938273097e-07 0.00021 2.1255910938273098e-07 0 2.1261253237289458e-07 0 2.126225323728946e-07 0.00021 2.126325323728946e-07 0 2.1266789418425028e-07 0 2.126778941842503e-07 0.00021 2.126878941842503e-07 0 2.1277050722368118e-07 0 2.127805072236812e-07 0.00021 2.127905072236812e-07 0 2.1279050722368118e-07 0 2.128005072236812e-07 0.00021 2.128105072236812e-07 0 2.1289552191687384e-07 0 2.1290552191687385e-07 0.00021 2.1291552191687387e-07 0 2.1292641890060033e-07 0 2.1293641890060035e-07 0.00021 2.1294641890060036e-07 0 2.130309092378544e-07 0 2.1304090923785442e-07 0.00021 2.1305090923785443e-07 0 2.1305378649506724e-07 0 2.1306378649506725e-07 0.00021 2.1307378649506726e-07 0 2.1310361675320347e-07 0 2.1311361675320348e-07 0.00021 2.131236167532035e-07 0 2.133660830013564e-07 0 2.1337608300135642e-07 0.00021 2.1338608300135643e-07 0 2.1346360142823518e-07 0 2.134736014282352e-07 0.00021 2.134836014282352e-07 0 2.135154275845854e-07 0 2.1352542758458542e-07 0.00021 2.1353542758458543e-07 0 2.135837819225877e-07 0 2.135937819225877e-07 0.00021 2.1360378192258771e-07 0 2.136037819225877e-07 0 2.136137819225877e-07 0.00021 2.136237819225877e-07 0 2.1383102451397934e-07 0 2.1384102451397935e-07 0.00021 2.1385102451397936e-07 0 2.13854415047759e-07 0 2.13864415047759e-07 0.00021 2.1387441504775902e-07 0 2.13874415047759e-07 0 2.13884415047759e-07 0.00021 2.1389441504775902e-07 0 2.138945785576366e-07 0 2.139045785576366e-07 0.00021 2.1391457855763662e-07 0 2.1416931911987119e-07 0 2.141793191198712e-07 0.00021 2.141893191198712e-07 0 2.1427954420075885e-07 0 2.1428954420075886e-07 0.00021 2.1429954420075887e-07 0 2.1430266792559196e-07 0 2.1431266792559198e-07 0.00021 2.1432266792559199e-07 0 2.1440169452526254e-07 0 2.1441169452526255e-07 0.00021 2.1442169452526256e-07 0 2.1445154430436965e-07 0 2.1446154430436966e-07 0.00021 2.1447154430436967e-07 0 2.1447154430436965e-07 0 2.1448154430436966e-07 0.00021 2.1449154430436967e-07 0 2.1473644311371046e-07 0 2.1474644311371047e-07 0.00021 2.1475644311371048e-07 0 2.148124411555618e-07 0 2.148224411555618e-07 0.00021 2.1483244115556182e-07 0 2.150828162351426e-07 0 2.1509281623514262e-07 0.00021 2.1510281623514263e-07 0 2.151028162351426e-07 0 2.1511281623514262e-07 0.00021 2.1512281623514263e-07 0 2.153712932203486e-07 0 2.153812932203486e-07 0.00021 2.153912932203486e-07 0 2.1539129322034858e-07 0 2.154012932203486e-07 0.00021 2.154112932203486e-07 0 2.1541129322034858e-07 0 2.154212932203486e-07 0.00021 2.154312932203486e-07 0 2.1556436973419042e-07 0 2.1557436973419043e-07 0.00021 2.1558436973419045e-07 0 2.1576674235137986e-07 0 2.1577674235137987e-07 0.00021 2.1578674235137988e-07 0 2.1592261053176038e-07 0 2.159326105317604e-07 0.00021 2.159426105317604e-07 0 2.1605525389219206e-07 0 2.1606525389219207e-07 0.00021 2.1607525389219208e-07 0 2.1611164430163945e-07 0 2.1612164430163946e-07 0.00021 2.1613164430163947e-07 0 2.162330930448113e-07 0 2.162430930448113e-07 0.00021 2.1625309304481132e-07 0 2.162530930448113e-07 0 2.162630930448113e-07 0.00021 2.162730930448113e-07 0 2.1627309304481129e-07 0 2.162830930448113e-07 0.00021 2.162930930448113e-07 0 2.1630551585271206e-07 0 2.1631551585271207e-07 0.00021 2.1632551585271208e-07 0 2.1635035315650348e-07 0 2.163603531565035e-07 0.00021 2.163703531565035e-07 0 2.1637035315650348e-07 0 2.163803531565035e-07 0.00021 2.163903531565035e-07 0 2.1646190986958778e-07 0 2.164719098695878e-07 0.00021 2.164819098695878e-07 0 2.165260881482521e-07 0 2.165360881482521e-07 0.00021 2.1654608814825211e-07 0 2.1665197894792008e-07 0 2.166619789479201e-07 0.00021 2.166719789479201e-07 0 2.1667197894792007e-07 0 2.1668197894792008e-07 0.00021 2.166919789479201e-07 0 2.1669197894792007e-07 0 2.1670197894792008e-07 0.00021 2.167119789479201e-07 0 2.168276644277816e-07 0 2.168376644277816e-07 0.00021 2.168476644277816e-07 0 2.1684766442778158e-07 0 2.168576644277816e-07 0.00021 2.168676644277816e-07 0 2.168850518702307e-07 0 2.168950518702307e-07 0.00021 2.1690505187023071e-07 0 2.170078405052265e-07 0 2.170178405052265e-07 0.00021 2.1702784050522652e-07 0 2.170573428919171e-07 0 2.170673428919171e-07 0.00021 2.1707734289191712e-07 0 2.171031127327883e-07 0 2.1711311273278832e-07 0.00021 2.1712311273278833e-07 0 2.1716696597750822e-07 0 2.1717696597750823e-07 0.00021 2.1718696597750824e-07 0 2.1721321655326772e-07 0 2.1722321655326774e-07 0.00021 2.1723321655326775e-07 0 2.1728578110835344e-07 0 2.1729578110835345e-07 0.00021 2.1730578110835346e-07 0 2.1735506766787093e-07 0 2.1736506766787094e-07 0.00021 2.1737506766787095e-07 0 2.174031677367984e-07 0 2.174131677367984e-07 0.00021 2.174231677367984e-07 0 2.1747834341417578e-07 0 2.1748834341417579e-07 0.00021 2.174983434141758e-07 0 2.1752902933303736e-07 0 2.1753902933303737e-07 0.00021 2.1754902933303738e-07 0 2.175630081230058e-07 0 2.1757300812300582e-07 0.00021 2.1758300812300583e-07 0 2.175830081230058e-07 0 2.1759300812300582e-07 0.00021 2.1760300812300583e-07 0 2.176030081230058e-07 0 2.1761300812300581e-07 0.00021 2.1762300812300583e-07 0 2.1763023811309556e-07 0 2.1764023811309557e-07 0.00021 2.1765023811309558e-07 0 2.1769989629469421e-07 0 2.1770989629469423e-07 0.00021 2.1771989629469424e-07 0 2.1774233592027664e-07 0 2.1775233592027665e-07 0.00021 2.1776233592027667e-07 0 2.177627541425136e-07 0 2.1777275414251362e-07 0.00021 2.1778275414251363e-07 0 2.1781997842111537e-07 0 2.1782997842111539e-07 0.00021 2.178399784211154e-07 0 2.182701041495272e-07 0 2.182801041495272e-07 0.00021 2.1829010414952721e-07 0 2.1829306223097434e-07 0 2.1830306223097435e-07 0.00021 2.1831306223097436e-07 0 2.1833565056820988e-07 0 2.183456505682099e-07 0.00021 2.183556505682099e-07 0 2.1838414996324686e-07 0 2.1839414996324687e-07 0.00021 2.1840414996324689e-07 0 2.1869325995533434e-07 0 2.1870325995533435e-07 0.00021 2.1871325995533436e-07 0 2.1871325995533434e-07 0 2.1872325995533435e-07 0.00021 2.1873325995533436e-07 0 2.1881860125854712e-07 0 2.1882860125854713e-07 0.00021 2.1883860125854715e-07 0 2.1900179228947566e-07 0 2.1901179228947567e-07 0.00021 2.1902179228947568e-07 0 2.1902179228947565e-07 0 2.1903179228947567e-07 0.00021 2.1904179228947568e-07 0 2.190612630168678e-07 0 2.190712630168678e-07 0.00021 2.1908126301686782e-07 0 2.1910123483872885e-07 0 2.1911123483872886e-07 0.00021 2.1912123483872887e-07 0 2.191423223105277e-07 0 2.191523223105277e-07 0.00021 2.1916232231052772e-07 0 2.1917075290082253e-07 0 2.1918075290082254e-07 0.00021 2.1919075290082255e-07 0 2.194307441485552e-07 0 2.1944074414855522e-07 0.00021 2.1945074414855523e-07 0 2.194638527536281e-07 0 2.194738527536281e-07 0.00021 2.194838527536281e-07 0 2.1954282529470277e-07 0 2.1955282529470278e-07 0.00021 2.195628252947028e-07 0 2.1969325564340644e-07 0 2.1970325564340646e-07 0.00021 2.1971325564340647e-07 0 2.1976387380949147e-07 0 2.1977387380949148e-07 0.00021 2.197838738094915e-07 0 2.197914297097428e-07 0 2.1980142970974282e-07 0.00021 2.1981142970974283e-07 0 2.198921173766928e-07 0 2.1990211737669282e-07 0.00021 2.1991211737669283e-07 0 2.200935131872598e-07 0 2.2010351318725982e-07 0.00021 2.2011351318725984e-07 0 2.2014967889068216e-07 0 2.2015967889068217e-07 0.00021 2.2016967889068218e-07 0 2.2024599060383509e-07 0 2.202559906038351e-07 0.00021 2.202659906038351e-07 0 2.2042680581918256e-07 0 2.2043680581918257e-07 0.00021 2.2044680581918258e-07 0 2.204806778596814e-07 0 2.204906778596814e-07 0.00021 2.2050067785968142e-07 0 2.205435579646581e-07 0 2.2055355796465812e-07 0.00021 2.2056355796465813e-07 0 2.2061735272402873e-07 0 2.2062735272402874e-07 0.00021 2.2063735272402875e-07 0 2.2066407453900013e-07 0 2.2067407453900014e-07 0.00021 2.2068407453900015e-07 0 2.207254953838076e-07 0 2.2073549538380762e-07 0.00021 2.2074549538380763e-07 0 2.2077029282761367e-07 0 2.2078029282761368e-07 0.00021 2.207902928276137e-07 0 2.2079029282761367e-07 0 2.2080029282761368e-07 0.00021 2.208102928276137e-07 0 2.2081029282761366e-07 0 2.2082029282761367e-07 0.00021 2.2083029282761368e-07 0 2.2083046532463336e-07 0 2.2084046532463337e-07 0.00021 2.2085046532463339e-07 0 2.2086447394203622e-07 0 2.2087447394203623e-07 0.00021 2.2088447394203625e-07 0 2.2088447394203622e-07 0 2.2089447394203623e-07 0.00021 2.2090447394203624e-07 0 2.2090447394203621e-07 0 2.2091447394203623e-07 0.00021 2.2092447394203624e-07 0 2.209472252846095e-07 0 2.209572252846095e-07 0.00021 2.2096722528460952e-07 0 2.209672252846095e-07 0 2.209772252846095e-07 0.00021 2.2098722528460952e-07 0 2.210612892609048e-07 0 2.210712892609048e-07 0.00021 2.2108128926090482e-07 0 2.210912545341075e-07 0 2.2110125453410751e-07 0.00021 2.2111125453410753e-07 0 2.211743273958986e-07 0 2.2118432739589862e-07 0.00021 2.2119432739589863e-07 0 2.212075936458113e-07 0 2.2121759364581132e-07 0.00021 2.2122759364581133e-07 0 2.2132949787602428e-07 0 2.213394978760243e-07 0.00021 2.213494978760243e-07 0 2.2134949787602427e-07 0 2.2135949787602428e-07 0.00021 2.213694978760243e-07 0 2.2140866073849767e-07 0 2.2141866073849768e-07 0.00021 2.214286607384977e-07 0 2.2142866073849767e-07 0 2.2143866073849768e-07 0.00021 2.214486607384977e-07 0 2.215298595589764e-07 0 2.2153985955897642e-07 0.00021 2.2154985955897643e-07 0 2.2159120737732946e-07 0 2.2160120737732947e-07 0.00021 2.2161120737732948e-07 0 2.2168012809198672e-07 0 2.2169012809198673e-07 0.00021 2.2170012809198674e-07 0 2.2170012809198671e-07 0 2.2171012809198673e-07 0.00021 2.2172012809198674e-07 0 2.217201280919867e-07 0 2.2173012809198672e-07 0.00021 2.2174012809198673e-07 0 2.2180374640048422e-07 0 2.2181374640048423e-07 0.00021 2.2182374640048424e-07 0 2.218342729396413e-07 0 2.218442729396413e-07 0.00021 2.218542729396413e-07 0 2.2185427293964129e-07 0 2.218642729396413e-07 0.00021 2.218742729396413e-07 0 2.219083249326493e-07 0 2.2191832493264932e-07 0.00021 2.2192832493264933e-07 0 2.219783967169128e-07 0 2.219883967169128e-07 0.00021 2.219983967169128e-07 0 2.2252042238258766e-07 0 2.2253042238258767e-07 0.00021 2.2254042238258768e-07 0 2.2259250474926437e-07 0 2.2260250474926438e-07 0.00021 2.226125047492644e-07 0 2.2264445824281154e-07 0 2.2265445824281155e-07 0.00021 2.2266445824281156e-07 0 2.2269171898422423e-07 0 2.2270171898422424e-07 0.00021 2.2271171898422425e-07 0 2.229128263053799e-07 0 2.229228263053799e-07 0.00021 2.2293282630537992e-07 0 2.2339903905872163e-07 0 2.2340903905872164e-07 0.00021 2.2341903905872165e-07 0 2.2344268788224959e-07 0 2.234526878822496e-07 0.00021 2.234626878822496e-07 0 2.234742303476891e-07 0 2.234842303476891e-07 0.00021 2.2349423034768912e-07 0 2.234942303476891e-07 0 2.235042303476891e-07 0.00021 2.2351423034768912e-07 0 2.2366008853498358e-07 0 2.236700885349836e-07 0.00021 2.236800885349836e-07 0 2.2385486444967465e-07 0 2.2386486444967466e-07 0.00021 2.2387486444967467e-07 0 2.2387486444967465e-07 0 2.2388486444967466e-07 0.00021 2.2389486444967467e-07 0 2.240704560423057e-07 0 2.2408045604230571e-07 0.00021 2.2409045604230573e-07 0 2.2413450072917816e-07 0 2.2414450072917817e-07 0.00021 2.2415450072917818e-07 0 2.2431234854030463e-07 0 2.2432234854030464e-07 0.00021 2.2433234854030465e-07 0 2.2433234854030463e-07 0 2.2434234854030464e-07 0.00021 2.2435234854030465e-07 0 2.2437898307292675e-07 0 2.2438898307292676e-07 0.00021 2.2439898307292677e-07 0 2.2460942854930535e-07 0 2.2461942854930536e-07 0.00021 2.2462942854930538e-07 0 2.2462942854930535e-07 0 2.2463942854930536e-07 0.00021 2.2464942854930537e-07 0 2.2464942854930535e-07 0 2.2465942854930536e-07 0.00021 2.2466942854930537e-07 0 2.2491674358455993e-07 0 2.2492674358455994e-07 0.00021 2.2493674358455995e-07 0 2.2495946950820185e-07 0 2.2496946950820186e-07 0.00021 2.2497946950820187e-07 0 2.250630543599454e-07 0 2.250730543599454e-07 0.00021 2.2508305435994542e-07 0 2.2523702985520654e-07 0 2.2524702985520656e-07 0.00021 2.2525702985520657e-07 0 2.252844896558069e-07 0 2.252944896558069e-07 0.00021 2.253044896558069e-07 0 2.2530448965580689e-07 0 2.253144896558069e-07 0.00021 2.253244896558069e-07 0 2.253254324236519e-07 0 2.2533543242365192e-07 0.00021 2.2534543242365194e-07 0 2.2545293899923536e-07 0 2.2546293899923537e-07 0.00021 2.2547293899923538e-07 0 2.2548783508906215e-07 0 2.2549783508906216e-07 0.00021 2.2550783508906217e-07 0 2.2552084796935713e-07 0 2.2553084796935714e-07 0.00021 2.2554084796935715e-07 0 2.2554084796935713e-07 0 2.2555084796935714e-07 0.00021 2.2556084796935715e-07 0 2.2556084796935712e-07 0 2.2557084796935713e-07 0.00021 2.2558084796935715e-07 0 2.2568270739698988e-07 0 2.256927073969899e-07 0.00021 2.257027073969899e-07 0 2.2570270739698988e-07 0 2.257127073969899e-07 0.00021 2.257227073969899e-07 0 2.2584900882001898e-07 0 2.25859008820019e-07 0.00021 2.25869008820019e-07 0 2.2588684360134323e-07 0 2.2589684360134325e-07 0.00021 2.2590684360134326e-07 0 2.2597415776316908e-07 0 2.259841577631691e-07 0.00021 2.259941577631691e-07 0 2.2609950881351922e-07 0 2.2610950881351923e-07 0.00021 2.2611950881351925e-07 0 2.2634359574861165e-07 0 2.2635359574861167e-07 0.00021 2.2636359574861168e-07 0 2.264924007091427e-07 0 2.265024007091427e-07 0.00021 2.265124007091427e-07 0 2.2659412831488912e-07 0 2.2660412831488913e-07 0.00021 2.2661412831488914e-07 0 2.2673167555388163e-07 0 2.2674167555388164e-07 0.00021 2.2675167555388165e-07 0 2.2682229450642144e-07 0 2.2683229450642145e-07 0.00021 2.2684229450642146e-07 0 2.2684229450642143e-07 0 2.2685229450642144e-07 0.00021 2.2686229450642146e-07 0 2.2703448309637482e-07 0 2.2704448309637484e-07 0.00021 2.2705448309637485e-07 0 2.2710766695483994e-07 0 2.2711766695483995e-07 0.00021 2.2712766695483997e-07 0 2.2712766695483994e-07 0 2.2713766695483995e-07 0.00021 2.2714766695483996e-07 0 2.2722026866696633e-07 0 2.2723026866696634e-07 0.00021 2.2724026866696635e-07 0 2.2732870946146512e-07 0 2.2733870946146514e-07 0.00021 2.2734870946146515e-07 0 2.2739529276479564e-07 0 2.2740529276479565e-07 0.00021 2.2741529276479566e-07 0 2.2741529276479563e-07 0 2.2742529276479564e-07 0.00021 2.2743529276479566e-07 0 2.2750594132414847e-07 0 2.2751594132414848e-07 0.00021 2.275259413241485e-07 0 2.2765706106351873e-07 0 2.2766706106351874e-07 0.00021 2.2767706106351875e-07 0 2.2767706106351873e-07 0 2.2768706106351874e-07 0.00021 2.2769706106351875e-07 0 2.277461869297879e-07 0 2.277561869297879e-07 0.00021 2.2776618692978792e-07 0 2.2781784942895193e-07 0 2.2782784942895194e-07 0.00021 2.2783784942895195e-07 0 2.2791077941048384e-07 0 2.2792077941048385e-07 0.00021 2.2793077941048386e-07 0 2.2794473884230843e-07 0 2.2795473884230844e-07 0.00021 2.2796473884230845e-07 0 2.2818497904456156e-07 0 2.2819497904456157e-07 0.00021 2.2820497904456158e-07 0 2.2824453702197437e-07 0 2.2825453702197438e-07 0.00021 2.282645370219744e-07 0 2.2831401817522952e-07 0 2.2832401817522953e-07 0.00021 2.2833401817522954e-07 0 2.2837044052143587e-07 0 2.2838044052143588e-07 0.00021 2.283904405214359e-07 0 2.2842378373315174e-07 0 2.2843378373315175e-07 0.00021 2.2844378373315176e-07 0 2.2844650513328867e-07 0 2.2845650513328868e-07 0.00021 2.284665051332887e-07 0 2.286206730478972e-07 0 2.286306730478972e-07 0.00021 2.2864067304789722e-07 0 2.2873578035840644e-07 0 2.2874578035840645e-07 0.00021 2.2875578035840646e-07 0 2.2881738032062744e-07 0 2.2882738032062745e-07 0.00021 2.2883738032062746e-07 0 2.288376911644475e-07 0 2.288476911644475e-07 0.00021 2.2885769116444752e-07 0 2.288576911644475e-07 0 2.288676911644475e-07 0.00021 2.288776911644475e-07 0 2.2890393607881713e-07 0 2.2891393607881714e-07 0.00021 2.2892393607881716e-07 0 2.291421706077747e-07 0 2.2915217060777472e-07 0.00021 2.2916217060777473e-07 0 2.2920801881335638e-07 0 2.292180188133564e-07 0.00021 2.292280188133564e-07 0 2.295195763163964e-07 0 2.2952957631639641e-07 0.00021 2.2953957631639643e-07 0 2.295869812548486e-07 0 2.295969812548486e-07 0.00021 2.296069812548486e-07 0 2.2962988040598087e-07 0 2.2963988040598088e-07 0.00021 2.296498804059809e-07 0 2.2964988040598086e-07 0 2.2965988040598087e-07 0.00021 2.2966988040598089e-07 0 2.2984659752265281e-07 0 2.2985659752265282e-07 0.00021 2.2986659752265284e-07 0 2.300095594059276e-07 0 2.300195594059276e-07 0.00021 2.3002955940592761e-07 0 2.3003024453335416e-07 0 2.3004024453335417e-07 0.00021 2.3005024453335418e-07 0 2.3014339281923146e-07 0 2.3015339281923148e-07 0.00021 2.3016339281923149e-07 0 2.3016339281923146e-07 0 2.3017339281923147e-07 0.00021 2.3018339281923148e-07 0 2.3018339281923146e-07 0 2.3019339281923147e-07 0.00021 2.3020339281923148e-07 0 2.3020339281923145e-07 0 2.3021339281923146e-07 0.00021 2.3022339281923148e-07 0 2.3040994731556943e-07 0 2.3041994731556944e-07 0.00021 2.3042994731556946e-07 0 2.3051965530315917e-07 0 2.3052965530315919e-07 0.00021 2.305396553031592e-07 0 2.3056492660251918e-07 0 2.3057492660251919e-07 0.00021 2.305849266025192e-07 0 2.3060210550951295e-07 0 2.3061210550951296e-07 0.00021 2.3062210550951297e-07 0 2.3063135543396445e-07 0 2.3064135543396446e-07 0.00021 2.3065135543396448e-07 0 2.3066162996914874e-07 0 2.3067162996914875e-07 0.00021 2.3068162996914877e-07 0 2.3068162996914874e-07 0 2.3069162996914875e-07 0.00021 2.3070162996914876e-07 0 2.3098069844762442e-07 0 2.3099069844762443e-07 0.00021 2.3100069844762444e-07 0 2.3116979805378663e-07 0 2.3117979805378664e-07 0.00021 2.3118979805378665e-07 0 2.3118979805378662e-07 0 2.3119979805378663e-07 0.00021 2.3120979805378664e-07 0 2.3132587307109225e-07 0 2.3133587307109226e-07 0.00021 2.3134587307109227e-07 0 2.313534701769481e-07 0 2.313634701769481e-07 0.00021 2.3137347017694812e-07 0 2.3141243230701843e-07 0 2.3142243230701845e-07 0.00021 2.3143243230701846e-07 0 2.3145820990032672e-07 0 2.3146820990032673e-07 0.00021 2.3147820990032675e-07 0 2.3154960619635103e-07 0 2.3155960619635104e-07 0.00021 2.3156960619635105e-07 0 2.3161571249549462e-07 0 2.3162571249549463e-07 0.00021 2.3163571249549464e-07 0 2.3165223446874077e-07 0 2.3166223446874078e-07 0.00021 2.316722344687408e-07 0 2.317417284483398e-07 0 2.3175172844833982e-07 0.00021 2.3176172844833983e-07 0 2.317617284483398e-07 0 2.3177172844833982e-07 0.00021 2.3178172844833983e-07 0 2.3181673111869795e-07 0 2.3182673111869796e-07 0.00021 2.3183673111869797e-07 0 2.31884250294958e-07 0 2.31894250294958e-07 0.00021 2.31904250294958e-07 0 2.3194454520753482e-07 0 2.3195454520753483e-07 0.00021 2.3196454520753484e-07 0 2.3196454520753481e-07 0 2.3197454520753483e-07 0.00021 2.3198454520753484e-07 0 2.3204737287518775e-07 0 2.3205737287518776e-07 0.00021 2.3206737287518778e-07 0 2.321664661102627e-07 0 2.3217646611026272e-07 0.00021 2.3218646611026273e-07 0 2.322102837860482e-07 0 2.322202837860482e-07 0.00021 2.3223028378604822e-07 0 2.322635900925013e-07 0 2.3227359009250132e-07 0.00021 2.3228359009250133e-07 0 2.322835900925013e-07 0 2.3229359009250132e-07 0.00021 2.3230359009250133e-07 0 2.323707197164735e-07 0 2.3238071971647352e-07 0.00021 2.3239071971647353e-07 0 2.3249474373281853e-07 0 2.3250474373281855e-07 0.00021 2.3251474373281856e-07 0 2.3275281115417664e-07 0 2.3276281115417665e-07 0.00021 2.3277281115417666e-07 0 2.3277281115417664e-07 0 2.3278281115417665e-07 0.00021 2.3279281115417666e-07 0 2.3279281115417663e-07 0 2.3280281115417665e-07 0.00021 2.3281281115417666e-07 0 2.328578983797516e-07 0 2.3286789837975162e-07 0.00021 2.3287789837975163e-07 0 2.3318680040111417e-07 0 2.3319680040111418e-07 0.00021 2.332068004011142e-07 0 2.3320680040111417e-07 0 2.3321680040111418e-07 0.00021 2.332268004011142e-07 0 2.3335340037037313e-07 0 2.3336340037037314e-07 0.00021 2.3337340037037315e-07 0 2.3337340037037313e-07 0 2.3338340037037314e-07 0.00021 2.3339340037037315e-07 0 2.3365025965481858e-07 0 2.336602596548186e-07 0.00021 2.336702596548186e-07 0 2.337701670296912e-07 0 2.3378016702969122e-07 0.00021 2.3379016702969123e-07 0 2.3384120315510153e-07 0 2.3385120315510154e-07 0.00021 2.3386120315510155e-07 0 2.3390212317082092e-07 0 2.3391212317082093e-07 0.00021 2.3392212317082094e-07 0 2.340228895794774e-07 0 2.340328895794774e-07 0.00021 2.3404288957947742e-07 0 2.3414743665355893e-07 0 2.3415743665355894e-07 0.00021 2.3416743665355895e-07 0 2.342467081673769e-07 0 2.3425670816737692e-07 0.00021 2.3426670816737693e-07 0 2.3427471245287737e-07 0 2.3428471245287739e-07 0.00021 2.342947124528774e-07 0 2.3429471245287737e-07 0 2.3430471245287738e-07 0.00021 2.343147124528774e-07 0 2.3440370794563918e-07 0 2.344137079456392e-07 0.00021 2.344237079456392e-07 0 2.3444004428382367e-07 0 2.3445004428382368e-07 0.00021 2.344600442838237e-07 0 2.3450596093629797e-07 0 2.3451596093629799e-07 0.00021 2.34525960936298e-07 0 2.3458557433572566e-07 0 2.3459557433572567e-07 0.00021 2.3460557433572568e-07 0 2.3466726406093219e-07 0 2.346772640609322e-07 0.00021 2.346872640609322e-07 0 2.3468726406093218e-07 0 2.346972640609322e-07 0.00021 2.347072640609322e-07 0 2.3470726406093218e-07 0 2.347172640609322e-07 0.00021 2.347272640609322e-07 0 2.3489741034844333e-07 0 2.3490741034844334e-07 0.00021 2.3491741034844335e-07 0 2.3491741034844332e-07 0 2.3492741034844334e-07 0.00021 2.3493741034844335e-07 0 2.3493741034844332e-07 0 2.3494741034844333e-07 0.00021 2.3495741034844334e-07 0 2.3509685255909426e-07 0 2.3510685255909427e-07 0.00021 2.3511685255909428e-07 0 2.351584305155584e-07 0 2.351684305155584e-07 0.00021 2.3517843051555842e-07 0 2.3517898897253512e-07 0 2.3518898897253513e-07 0.00021 2.3519898897253514e-07 0 2.3519898897253512e-07 0 2.3520898897253513e-07 0.00021 2.3521898897253514e-07 0 2.354718880500963e-07 0 2.3548188805009632e-07 0.00021 2.3549188805009633e-07 0 2.3555095001007916e-07 0 2.3556095001007917e-07 0.00021 2.3557095001007918e-07 0 2.356616949460372e-07 0 2.356716949460372e-07 0.00021 2.356816949460372e-07 0 2.3569718052677708e-07 0 2.357071805267771e-07 0.00021 2.357171805267771e-07 0 2.3593832922581131e-07 0 2.3594832922581133e-07 0.00021 2.3595832922581134e-07 0 2.359583292258113e-07 0 2.3596832922581132e-07 0.00021 2.3597832922581133e-07 0 2.359783292258113e-07 0 2.3598832922581132e-07 0.00021 2.3599832922581133e-07 0 2.3599845957869036e-07 0 2.3600845957869037e-07 0.00021 2.3601845957869038e-07 0 2.3602685414515625e-07 0 2.3603685414515626e-07 0.00021 2.3604685414515627e-07 0 2.3616822166264455e-07 0 2.3617822166264456e-07 0.00021 2.3618822166264457e-07 0 2.3619038995588953e-07 0 2.3620038995588954e-07 0.00021 2.3621038995588955e-07 0 2.3627998478228473e-07 0 2.3628998478228474e-07 0.00021 2.3629998478228476e-07 0 2.3629998478228473e-07 0 2.3630998478228474e-07 0.00021 2.3631998478228475e-07 0 2.3646730304054422e-07 0 2.3647730304054423e-07 0.00021 2.3648730304054424e-07 0 2.365011691955911e-07 0 2.365111691955911e-07 0.00021 2.365211691955911e-07 0 2.3652116919559109e-07 0 2.365311691955911e-07 0.00021 2.365411691955911e-07 0 2.3654770392939921e-07 0 2.3655770392939923e-07 0.00021 2.3656770392939924e-07 0 2.365803804772754e-07 0 2.365903804772754e-07 0.00021 2.3660038047727542e-07 0 2.366517612719445e-07 0 2.3666176127194452e-07 0.00021 2.3667176127194453e-07 0 2.366820066900398e-07 0 2.3669200669003982e-07 0.00021 2.3670200669003983e-07 0 2.3682787243551204e-07 0 2.3683787243551205e-07 0.00021 2.3684787243551206e-07 0 2.3686298806368193e-07 0 2.3687298806368194e-07 0.00021 2.3688298806368195e-07 0 2.3690469957333313e-07 0 2.3691469957333314e-07 0.00021 2.3692469957333316e-07 0 2.3696987304186757e-07 0 2.3697987304186758e-07 0.00021 2.369898730418676e-07 0 2.3701914096792344e-07 0 2.3702914096792345e-07 0.00021 2.3703914096792346e-07 0 2.3703914096792344e-07 0 2.3704914096792345e-07 0.00021 2.3705914096792346e-07 0 2.3705914096792343e-07 0 2.3706914096792344e-07 0.00021 2.3707914096792345e-07 0 2.3714156795766123e-07 0 2.3715156795766124e-07 0.00021 2.3716156795766125e-07 0 2.3728144792086981e-07 0 2.3729144792086983e-07 0.00021 2.3730144792086984e-07 0 2.3735422854574468e-07 0 2.373642285457447e-07 0.00021 2.373742285457447e-07 0 2.3746580597468692e-07 0 2.3747580597468694e-07 0.00021 2.3748580597468695e-07 0 2.3748915417838608e-07 0 2.374991541783861e-07 0.00021 2.375091541783861e-07 0 2.3752491567682878e-07 0 2.375349156768288e-07 0.00021 2.375449156768288e-07 0 2.3785016020252208e-07 0 2.378601602025221e-07 0.00021 2.378701602025221e-07 0 2.378775337570349e-07 0 2.3788753375703492e-07 0.00021 2.3789753375703493e-07 0 2.3790011420990633e-07 0 2.3791011420990634e-07 0.00021 2.3792011420990635e-07 0 2.3798806009659098e-07 0 2.37998060096591e-07 0.00021 2.38008060096591e-07 0 2.3822987457967984e-07 0 2.3823987457967985e-07 0.00021 2.3824987457967986e-07 0 2.3824987457967983e-07 0 2.3825987457967985e-07 0.00021 2.3826987457967986e-07 0 2.3828096624966235e-07 0 2.3829096624966236e-07 0.00021 2.3830096624966237e-07 0 2.38555261590593e-07 0 2.38565261590593e-07 0.00021 2.38575261590593e-07 0 2.38590666942042e-07 0 2.38600666942042e-07 0.00021 2.38610666942042e-07 0 2.38610666942042e-07 0 2.38620666942042e-07 0.00021 2.3863066694204203e-07 0 2.386610546505493e-07 0 2.386710546505493e-07 0.00021 2.3868105465054934e-07 0 2.387374221190937e-07 0 2.387474221190937e-07 0.00021 2.387574221190937e-07 0 2.3888319432008186e-07 0 2.388931943200819e-07 0.00021 2.389031943200819e-07 0 2.389031943200819e-07 0 2.389131943200819e-07 0.00021 2.389231943200819e-07 0 2.3894397619176833e-07 0 2.3895397619176834e-07 0.00021 2.3896397619176835e-07 0 2.389654770343578e-07 0 2.389754770343578e-07 0.00021 2.3898547703435783e-07 0 2.390363421145566e-07 0 2.3904634211455663e-07 0.00021 2.3905634211455664e-07 0 2.3905634211455664e-07 0 2.3906634211455665e-07 0.00021 2.3907634211455667e-07 0 2.391093120831853e-07 0 2.3911931208318534e-07 0.00021 2.3912931208318535e-07 0 2.3913712150602563e-07 0 2.3914712150602564e-07 0.00021 2.3915712150602565e-07 0 2.3926330752435905e-07 0 2.3927330752435906e-07 0.00021 2.3928330752435907e-07 0 2.393500742707789e-07 0 2.393600742707789e-07 0.00021 2.393700742707789e-07 0 2.395082556503554e-07 0 2.3951825565035543e-07 0.00021 2.3952825565035544e-07 0 2.39547265458297e-07 0 2.39557265458297e-07 0.00021 2.39567265458297e-07 0 2.396737984001064e-07 0 2.396837984001064e-07 0.00021 2.396937984001064e-07 0 2.3981841894155427e-07 0 2.398284189415543e-07 0.00021 2.398384189415543e-07 0 2.398384189415543e-07 0 2.398484189415543e-07 0.00021 2.398584189415543e-07 0 2.398584189415543e-07 0 2.3986841894155433e-07 0.00021 2.3987841894155434e-07 0 2.399518685641012e-07 0 2.399618685641012e-07 0.00021 2.3997186856410123e-07 0 2.3997200735474076e-07 0 2.3998200735474077e-07 0.00021 2.399920073547408e-07 0 2.4011555394469857e-07 0 2.401255539446986e-07 0.00021 2.401355539446986e-07 0 2.401355539446986e-07 0 2.401455539446986e-07 0.00021 2.401555539446986e-07 0 2.4020463284271505e-07 0 2.4021463284271506e-07 0.00021 2.402246328427151e-07 0 2.403817758389473e-07 0 2.403917758389473e-07 0.00021 2.404017758389473e-07 0 2.4050591848131016e-07 0 2.4051591848131017e-07 0.00021 2.405259184813102e-07 0 2.406051491267813e-07 0 2.406151491267813e-07 0.00021 2.4062514912678133e-07 0 2.4063628028903794e-07 0 2.4064628028903796e-07 0.00021 2.4065628028903797e-07 0 2.40692964511379e-07 0 2.40702964511379e-07 0.00021 2.4071296451137904e-07 0 2.408794739166672e-07 0 2.4088947391666724e-07 0.00021 2.4089947391666725e-07 0 2.409093694114364e-07 0 2.409193694114364e-07 0.00021 2.409293694114364e-07 0 2.40970464586382e-07 0 2.4098046458638203e-07 0.00021 2.4099046458638204e-07 0 2.410064327530568e-07 0 2.410164327530568e-07 0.00021 2.410264327530568e-07 0 2.411092745507782e-07 0 2.411192745507782e-07 0.00021 2.411292745507782e-07 0 2.41166016395313e-07 0 2.41176016395313e-07 0.00021 2.4118601639531303e-07 0 2.4118601639531303e-07 0 2.4119601639531305e-07 0.00021 2.4120601639531306e-07 0 2.4120601639531306e-07 0 2.4121601639531307e-07 0.00021 2.412260163953131e-07 0 2.412260163953131e-07 0 2.412360163953131e-07 0.00021 2.412460163953131e-07 0 2.4129610168854484e-07 0 2.4130610168854485e-07 0.00021 2.4131610168854486e-07 0 2.413176935536708e-07 0 2.413276935536708e-07 0.00021 2.4133769355367083e-07 0 2.413388624659486e-07 0 2.413488624659486e-07 0.00021 2.4135886246594863e-07 0 2.414243082698464e-07 0 2.414343082698464e-07 0.00021 2.414443082698464e-07 0 2.414818075711453e-07 0 2.4149180757114533e-07 0.00021 2.4150180757114535e-07 0 2.415931124355101e-07 0 2.416031124355101e-07 0.00021 2.416131124355101e-07 0 2.416131124355101e-07 0 2.416231124355101e-07 0.00021 2.4163311243551013e-07 0 2.4163311243551013e-07 0 2.4164311243551014e-07 0.00021 2.4165311243551015e-07 0 2.417225092707982e-07 0 2.417325092707982e-07 0.00021 2.417425092707982e-07 0 2.417425092707982e-07 0 2.4175250927079823e-07 0.00021 2.4176250927079824e-07 0 2.4187770990026764e-07 0 2.4188770990026765e-07 0.00021 2.4189770990026766e-07 0 2.4198263349491137e-07 0 2.419926334949114e-07 0.00021 2.420026334949114e-07 0 2.4203474955952193e-07 0 2.4204474955952194e-07 0.00021 2.4205474955952196e-07 0 2.4205474955952196e-07 0 2.4206474955952197e-07 0.00021 2.42074749559522e-07 0 2.420865874876358e-07 0 2.420965874876358e-07 0.00021 2.421065874876358e-07 0 2.4210739104994953e-07 0 2.4211739104994955e-07 0.00021 2.4212739104994956e-07 0 2.4215729063924355e-07 0 2.4216729063924356e-07 0.00021 2.4217729063924357e-07 0 2.4217729063924357e-07 0 2.421872906392436e-07 0.00021 2.421972906392436e-07 0 2.421972906392436e-07 0 2.422072906392436e-07 0.00021 2.422172906392436e-07 0 2.4223224031064144e-07 0 2.4224224031064145e-07 0.00021 2.4225224031064146e-07 0 2.4225747745984265e-07 0 2.4226747745984266e-07 0.00021 2.422774774598427e-07 0 2.4233792040380333e-07 0 2.4234792040380334e-07 0.00021 2.4235792040380335e-07 0 2.4238129858032554e-07 0 2.4239129858032555e-07 0.00021 2.4240129858032556e-07 0 2.424244418352247e-07 0 2.424344418352247e-07 0.00021 2.4244444183522473e-07 0 2.424865015199873e-07 0 2.424965015199873e-07 0.00021 2.425065015199873e-07 0 2.4259987868385824e-07 0 2.4260987868385825e-07 0.00021 2.4261987868385826e-07 0 2.4261987868385826e-07 0 2.426298786838583e-07 0.00021 2.426398786838583e-07 0 2.4269884920452005e-07 0 2.4270884920452006e-07 0.00021 2.427188492045201e-07 0 2.427188492045201e-07 0 2.427288492045201e-07 0.00021 2.427388492045201e-07 0 2.427388492045201e-07 0 2.427488492045201e-07 0.00021 2.427588492045201e-07 0 2.42831772734859e-07 0 2.42841772734859e-07 0.00021 2.42851772734859e-07 0 2.428949989826693e-07 0 2.429049989826693e-07 0.00021 2.429149989826693e-07 0 2.4292553624537647e-07 0 2.429355362453765e-07 0.00021 2.429455362453765e-07 0 2.4301673800342613e-07 0 2.4302673800342614e-07 0.00021 2.4303673800342615e-07 0 2.4303673800342615e-07 0 2.4304673800342616e-07 0.00021 2.430567380034262e-07 0 2.430567380034262e-07 0 2.430667380034262e-07 0.00021 2.430767380034262e-07 0 2.4321738562644574e-07 0 2.4322738562644575e-07 0.00021 2.4323738562644576e-07 0 2.4323738562644576e-07 0 2.4324738562644577e-07 0.00021 2.432573856264458e-07 0 2.433215000495246e-07 0 2.433315000495246e-07 0.00021 2.4334150004952464e-07 0 2.433549638878388e-07 0 2.433649638878388e-07 0.00021 2.433749638878388e-07 0 2.4342664795017955e-07 0 2.4343664795017957e-07 0.00021 2.434466479501796e-07 0 2.435223248972343e-07 0 2.4353232489723434e-07 0.00021 2.4354232489723435e-07 0 2.4354232489723435e-07 0 2.4355232489723436e-07 0.00021 2.4356232489723437e-07 0 2.436751890739408e-07 0 2.436851890739408e-07 0.00021 2.436951890739408e-07 0 2.4369585936104796e-07 0 2.4370585936104797e-07 0.00021 2.43715859361048e-07 0 2.4373054182885644e-07 0 2.4374054182885646e-07 0.00021 2.4375054182885647e-07 0 2.4375054182885647e-07 0 2.437605418288565e-07 0.00021 2.437705418288565e-07 0 2.4386639106675986e-07 0 2.438763910667599e-07 0.00021 2.438863910667599e-07 0 2.438863910667599e-07 0 2.438963910667599e-07 0.00021 2.439063910667599e-07 0 2.439063910667599e-07 0 2.439163910667599e-07 0.00021 2.4392639106675993e-07 0 2.440207180457583e-07 0 2.440307180457583e-07 0.00021 2.440407180457583e-07 0 2.440407180457583e-07 0 2.4405071804575834e-07 0.00021 2.4406071804575835e-07 0 2.4406071804575835e-07 0 2.4407071804575836e-07 0.00021 2.4408071804575837e-07 0 2.4408071804575837e-07 0 2.440907180457584e-07 0.00021 2.441007180457584e-07 0 2.4416411979605967e-07 0 2.441741197960597e-07 0.00021 2.441841197960597e-07 0 2.441841197960597e-07 0 2.441941197960597e-07 0.00021 2.442041197960597e-07 0 2.444803225028503e-07 0 2.444903225028503e-07 0.00021 2.445003225028503e-07 0 2.4471530542994895e-07 0 2.4472530542994896e-07 0.00021 2.4473530542994897e-07 0 2.4477743400239086e-07 0 2.447874340023909e-07 0.00021 2.447974340023909e-07 0 2.4487641196310776e-07 0 2.4488641196310777e-07 0.00021 2.448964119631078e-07 0 2.448964119631078e-07 0 2.449064119631078e-07 0.00021 2.449164119631078e-07 0 2.449164119631078e-07 0 2.449264119631078e-07 0.00021 2.4493641196310783e-07 0 2.449493114771561e-07 0 2.449593114771561e-07 0.00021 2.449693114771561e-07 0 2.4503478994259137e-07 0 2.450447899425914e-07 0.00021 2.450547899425914e-07 0 2.4507549072889723e-07 0 2.4508549072889724e-07 0.00021 2.4509549072889725e-07 0 2.451630800901278e-07 0 2.451730800901278e-07 0.00021 2.4518308009012783e-07 0 2.451913962282964e-07 0 2.4520139622829643e-07 0.00021 2.4521139622829644e-07 0 2.4539473436905344e-07 0 2.4540473436905345e-07 0.00021 2.4541473436905346e-07 0 2.4541473436905346e-07 0 2.454247343690535e-07 0.00021 2.454347343690535e-07 0 2.4549279622482286e-07 0 2.4550279622482287e-07 0.00021 2.455127962248229e-07 0 2.455579380282191e-07 0 2.455679380282191e-07 0.00021 2.455779380282191e-07 0 2.457640848308772e-07 0 2.457740848308772e-07 0.00021 2.4578408483087724e-07 0 2.4578408483087724e-07 0 2.4579408483087725e-07 0.00021 2.4580408483087726e-07 0 2.4583706754301105e-07 0 2.4584706754301106e-07 0.00021 2.4585706754301107e-07 0 2.458830939785115e-07 0 2.458930939785115e-07 0.00021 2.459030939785115e-07 0 2.4615103190951793e-07 0 2.4616103190951794e-07 0.00021 2.4617103190951795e-07 0 2.461850888251993e-07 0 2.461950888251993e-07 0.00021 2.462050888251993e-07 0 2.4623826466853787e-07 0 2.462482646685379e-07 0.00021 2.462582646685379e-07 0 2.462704071396801e-07 0 2.4628040713968013e-07 0.00021 2.4629040713968014e-07 0 2.4629040713968014e-07 0 2.4630040713968015e-07 0.00021 2.4631040713968016e-07 0 2.4631040713968016e-07 0 2.4632040713968017e-07 0.00021 2.463304071396802e-07 0 2.464614239716949e-07 0 2.464714239716949e-07 0.00021 2.464814239716949e-07 0 2.464879987191392e-07 0 2.464979987191392e-07 0.00021 2.465079987191392e-07 0 2.4676969091700964e-07 0 2.4677969091700965e-07 0.00021 2.4678969091700966e-07 0 2.468427798411759e-07 0 2.468527798411759e-07 0.00021 2.468627798411759e-07 0 2.468627798411759e-07 0 2.4687277984117593e-07 0.00021 2.4688277984117595e-07 0 2.4694072063721783e-07 0 2.4695072063721785e-07 0.00021 2.4696072063721786e-07 0 2.4696567775473445e-07 0 2.4697567775473446e-07 0.00021 2.4698567775473447e-07 0 2.4718769287137866e-07 0 2.4719769287137867e-07 0.00021 2.472076928713787e-07 0 2.473172653756545e-07 0 2.473272653756545e-07 0.00021 2.4733726537565453e-07 0 2.4788856588710784e-07 0 2.4789856588710785e-07 0.00021 2.4790856588710786e-07 0 2.479621651008271e-07 0 2.4797216510082713e-07 0.00021 2.4798216510082714e-07 0 2.4814055288167097e-07 0 2.48150552881671e-07 0.00021 2.48160552881671e-07 0 2.4825561233494943e-07 0 2.4826561233494944e-07 0.00021 2.4827561233494945e-07 0 2.4827561233494945e-07 0 2.4828561233494946e-07 0.00021 2.482956123349495e-07 0 2.4837733898034115e-07 0 2.4838733898034116e-07 0.00021 2.4839733898034117e-07 0 2.4839733898034117e-07 0 2.484073389803412e-07 0.00021 2.484173389803412e-07 0 2.484711187244278e-07 0 2.4848111872442783e-07 0.00021 2.4849111872442784e-07 0 2.484944441906624e-07 0 2.485044441906624e-07 0.00021 2.485144441906624e-07 0 2.485831691759938e-07 0 2.485931691759938e-07 0.00021 2.486031691759938e-07 0 2.4862368211764136e-07 0 2.486336821176414e-07 0.00021 2.486436821176414e-07 0 2.486436821176414e-07 0 2.486536821176414e-07 0.00021 2.486636821176414e-07 0 2.4875741012334784e-07 0 2.4876741012334785e-07 0.00021 2.4877741012334786e-07 0 2.4882550931677407e-07 0 2.488355093167741e-07 0.00021 2.488455093167741e-07 0 2.4905149440547773e-07 0 2.4906149440547774e-07 0.00021 2.4907149440547775e-07 0 2.491053831235518e-07 0 2.491153831235518e-07 0.00021 2.491253831235518e-07 0 2.4916974985770015e-07 0 2.4917974985770016e-07 0.00021 2.491897498577002e-07 0 2.4926865312178697e-07 0 2.49278653121787e-07 0.00021 2.49288653121787e-07 0 2.493023447037861e-07 0 2.493123447037861e-07 0.00021 2.493223447037861e-07 0 2.494480480389812e-07 0 2.494580480389812e-07 0.00021 2.4946804803898123e-07 0 2.495267730640063e-07 0 2.495367730640063e-07 0.00021 2.495467730640063e-07 0 2.4956239417769335e-07 0 2.4957239417769336e-07 0.00021 2.4958239417769337e-07 0 2.496777177049597e-07 0 2.496877177049597e-07 0.00021 2.4969771770495974e-07 0 2.497945796928956e-07 0 2.498045796928956e-07 0.00021 2.4981457969289563e-07 0 2.498939251344121e-07 0 2.499039251344121e-07 0.00021 2.499139251344121e-07 0 2.4992933212398654e-07 0 2.4993933212398655e-07 0.00021 2.4994933212398656e-07 0 2.5003106389641715e-07 0 2.5004106389641716e-07 0.00021 2.500510638964172e-07 0 2.5005975400557227e-07 0 2.500697540055723e-07 0.00021 2.500797540055723e-07 0 2.5009991706907486e-07 0 2.5010991706907487e-07 0.00021 2.501199170690749e-07 0 2.5018432887782096e-07 0 2.50194328877821e-07 0.00021 2.50204328877821e-07 0 2.502731643923954e-07 0 2.502831643923954e-07 0.00021 2.502931643923954e-07 0 2.5048489140531867e-07 0 2.504948914053187e-07 0.00021 2.505048914053187e-07 0 2.505054302850605e-07 0 2.505154302850605e-07 0.00021 2.505254302850605e-07 0 2.5061038043824383e-07 0 2.5062038043824384e-07 0.00021 2.5063038043824385e-07 0 2.5063038043824385e-07 0 2.5064038043824386e-07 0.00021 2.506503804382439e-07 0 2.506700519364384e-07 0 2.5068005193643843e-07 0.00021 2.5069005193643844e-07 0 2.5069512379391914e-07 0 2.5070512379391915e-07 0.00021 2.5071512379391917e-07 0 2.5071512379391917e-07 0 2.507251237939192e-07 0.00021 2.507351237939192e-07 0 2.509329287109965e-07 0 2.509429287109965e-07 0.00021 2.5095292871099653e-07 0 2.50967509175806e-07 0 2.5097750917580603e-07 0.00021 2.5098750917580605e-07 0 2.510527764366919e-07 0 2.510627764366919e-07 0.00021 2.510727764366919e-07 0 2.5107868899226633e-07 0 2.5108868899226634e-07 0.00021 2.5109868899226635e-07 0 2.512205771787264e-07 0 2.512305771787264e-07 0.00021 2.5124057717872643e-07 0 2.5124883906581033e-07 0 2.5125883906581034e-07 0.00021 2.5126883906581035e-07 0 2.514145601911651e-07 0 2.514245601911651e-07 0.00021 2.514345601911651e-07 0 2.51504072089391e-07 0 2.51514072089391e-07 0.00021 2.51524072089391e-07 0 2.516395102665894e-07 0 2.516495102665894e-07 0.00021 2.516595102665894e-07 0 2.517108818523403e-07 0 2.517208818523403e-07 0.00021 2.517308818523403e-07 0 2.517918523844855e-07 0 2.518018523844855e-07 0.00021 2.5181185238448554e-07 0 2.5181185238448554e-07 0 2.5182185238448555e-07 0.00021 2.5183185238448556e-07 0 2.5206120026824904e-07 0 2.5207120026824905e-07 0.00021 2.5208120026824906e-07 0 2.521276948494746e-07 0 2.521376948494746e-07 0.00021 2.521476948494746e-07 0 2.522514341184487e-07 0 2.522614341184487e-07 0.00021 2.522714341184487e-07 0 2.523115516547351e-07 0 2.523215516547351e-07 0.00021 2.5233155165473513e-07 0 2.5233155165473513e-07 0 2.5234155165473514e-07 0.00021 2.5235155165473515e-07 0 2.5235155165473515e-07 0 2.5236155165473517e-07 0.00021 2.523715516547352e-07 0 2.523835363067144e-07 0 2.523935363067144e-07 0.00021 2.524035363067144e-07 0 2.524100434139097e-07 0 2.524200434139097e-07 0.00021 2.5243004341390973e-07 0 2.5243004341390973e-07 0 2.5244004341390974e-07 0.00021 2.5245004341390975e-07 0 2.52506251333978e-07 0 2.52516251333978e-07 0.00021 2.52526251333978e-07 0 2.5270300567187847e-07 0 2.527130056718785e-07 0.00021 2.527230056718785e-07 0 2.527554569187078e-07 0 2.527654569187078e-07 0.00021 2.527754569187078e-07 0 2.528601653109246e-07 0 2.528701653109246e-07 0.00021 2.528801653109246e-07 0 2.5300208578435213e-07 0 2.5301208578435215e-07 0.00021 2.5302208578435216e-07 0 2.5305964939830005e-07 0 2.5306964939830006e-07 0.00021 2.530796493983001e-07 0 2.530796493983001e-07 0 2.530896493983001e-07 0.00021 2.530996493983001e-07 0 2.53255353099093e-07 0 2.5326535309909303e-07 0.00021 2.5327535309909304e-07 0 2.5327535309909304e-07 0 2.5328535309909305e-07 0.00021 2.5329535309909306e-07 0 2.5343276224099604e-07 0 2.5344276224099605e-07 0.00021 2.5345276224099606e-07 0 2.5349070353705905e-07 0 2.5350070353705907e-07 0.00021 2.535107035370591e-07 0 2.536544626886042e-07 0 2.536644626886042e-07 0.00021 2.5367446268860423e-07 0 2.5367446268860423e-07 0 2.5368446268860424e-07 0.00021 2.5369446268860425e-07 0 2.5369446268860425e-07 0 2.5370446268860426e-07 0.00021 2.537144626886043e-07 0 2.539343334587118e-07 0 2.539443334587118e-07 0.00021 2.539543334587118e-07 0 2.53959210619386e-07 0 2.53969210619386e-07 0.00021 2.53979210619386e-07 0 2.5412399790082266e-07 0 2.5413399790082267e-07 0.00021 2.541439979008227e-07 0 2.541439979008227e-07 0 2.541539979008227e-07 0.00021 2.541639979008227e-07 0 2.5419121365267164e-07 0 2.5420121365267165e-07 0.00021 2.5421121365267166e-07 0 2.5424120521877946e-07 0 2.5425120521877947e-07 0.00021 2.542612052187795e-07 0 2.542840229728937e-07 0 2.542940229728937e-07 0.00021 2.543040229728937e-07 0 2.543096441736853e-07 0 2.543196441736853e-07 0.00021 2.5432964417368533e-07 0 2.544646005020541e-07 0 2.544746005020541e-07 0.00021 2.544846005020541e-07 0 2.544846005020541e-07 0 2.544946005020541e-07 0.00021 2.5450460050205413e-07 0 2.54758590331925e-07 0 2.54768590331925e-07 0.00021 2.5477859033192503e-07 0 2.5479095841978074e-07 0 2.5480095841978075e-07 0.00021 2.5481095841978076e-07 0 2.5486211983893595e-07 0 2.5487211983893596e-07 0.00021 2.54882119838936e-07 0 2.549880369076791e-07 0 2.549980369076791e-07 0.00021 2.550080369076791e-07 0 2.5503849393016454e-07 0 2.5504849393016456e-07 0.00021 2.5505849393016457e-07 0 2.5513388461086273e-07 0 2.5514388461086275e-07 0.00021 2.5515388461086276e-07 0 2.552059989948811e-07 0 2.552159989948811e-07 0.00021 2.552259989948811e-07 0 2.553014547667269e-07 0 2.553114547667269e-07 0.00021 2.5532145476672694e-07 0 2.553687609211304e-07 0 2.553787609211304e-07 0.00021 2.553887609211304e-07 0 2.553887609211304e-07 0 2.553987609211304e-07 0.00021 2.554087609211304e-07 0 2.554557131249659e-07 0 2.554657131249659e-07 0.00021 2.554757131249659e-07 0 2.5554901944407213e-07 0 2.5555901944407215e-07 0.00021 2.5556901944407216e-07 0 2.55570734878772e-07 0 2.55580734878772e-07 0.00021 2.55590734878772e-07 0 2.55590734878772e-07 0 2.55600734878772e-07 0.00021 2.55610734878772e-07 0 2.55610734878772e-07 0 2.5562073487877204e-07 0.00021 2.5563073487877205e-07 0 2.559295935101599e-07 0 2.559395935101599e-07 0.00021 2.559495935101599e-07 0 2.559495935101599e-07 0 2.5595959351015993e-07 0.00021 2.5596959351015994e-07 0 2.5596959351015994e-07 0 2.5597959351015995e-07 0.00021 2.5598959351015996e-07 0 2.5599475428295897e-07 0 2.56004754282959e-07 0.00021 2.56014754282959e-07 0 2.5609454087372636e-07 0 2.5610454087372637e-07 0.00021 2.561145408737264e-07 0 2.561145408737264e-07 0 2.561245408737264e-07 0.00021 2.561345408737264e-07 0 2.5624695899631373e-07 0 2.5625695899631374e-07 0.00021 2.5626695899631375e-07 0 2.562985153429593e-07 0 2.563085153429593e-07 0.00021 2.563185153429593e-07 0 2.563185153429593e-07 0 2.5632851534295933e-07 0.00021 2.5633851534295934e-07 0 2.563445892750205e-07 0 2.563545892750205e-07 0.00021 2.563645892750205e-07 0 2.56424286119284e-07 0 2.56434286119284e-07 0.00021 2.56444286119284e-07 0 2.5649874994037515e-07 0 2.5650874994037516e-07 0.00021 2.5651874994037517e-07 0 2.5659740324317475e-07 0 2.5660740324317476e-07 0.00021 2.566174032431748e-07 0 2.566174032431748e-07 0 2.566274032431748e-07 0.00021 2.566374032431748e-07 0 2.567013908470317e-07 0 2.567113908470317e-07 0.00021 2.5672139084703173e-07 0 2.568434538903121e-07 0 2.568534538903121e-07 0.00021 2.568634538903121e-07 0 2.569629879373486e-07 0 2.569729879373486e-07 0.00021 2.5698298793734863e-07 0 2.5704409953306163e-07 0 2.5705409953306164e-07 0.00021 2.5706409953306165e-07 0 2.570894203446767e-07 0 2.570994203446767e-07 0.00021 2.5710942034467673e-07 0 2.5725217574090216e-07 0 2.5726217574090217e-07 0.00021 2.572721757409022e-07 0 2.572721757409022e-07 0 2.572821757409022e-07 0.00021 2.572921757409022e-07 0 2.573316078011372e-07 0 2.573416078011372e-07 0.00021 2.573516078011372e-07 0 2.573516078011372e-07 0 2.5736160780113724e-07 0.00021 2.5737160780113725e-07 0 2.575075107992838e-07 0 2.575175107992838e-07 0.00021 2.575275107992838e-07 0 2.5763066681939256e-07 0 2.5764066681939257e-07 0.00021 2.576506668193926e-07 0 2.577795509392714e-07 0 2.5778955093927144e-07 0.00021 2.5779955093927145e-07 0 2.581002529516816e-07 0 2.5811025295168163e-07 0.00021 2.5812025295168164e-07 0 2.5812025295168164e-07 0 2.5813025295168165e-07 0.00021 2.5814025295168167e-07 0 2.5818817898079604e-07 0 2.5819817898079605e-07 0.00021 2.5820817898079606e-07 0 2.582836117350436e-07 0 2.582936117350436e-07 0.00021 2.583036117350436e-07 0 2.585465848537803e-07 0 2.585565848537803e-07 0.00021 2.585665848537803e-07 0 2.587599890060311e-07 0 2.5876998900603113e-07 0.00021 2.5877998900603114e-07 0 2.59064822699973e-07 0 2.59074822699973e-07 0.00021 2.5908482269997303e-07 0 2.5908482269997303e-07 0 2.5909482269997304e-07 0.00021 2.5910482269997305e-07 0 2.591351492019895e-07 0 2.5914514920198953e-07 0.00021 2.5915514920198954e-07 0 2.5915514920198954e-07 0 2.5916514920198955e-07 0.00021 2.5917514920198957e-07 0 2.5925807824550696e-07 0 2.59268078245507e-07 0.00021 2.59278078245507e-07 0 2.59278078245507e-07 0 2.59288078245507e-07 0.00021 2.59298078245507e-07 0 2.5932377517367543e-07 0 2.5933377517367544e-07 0.00021 2.5934377517367545e-07 0 2.5934377517367545e-07 0 2.5935377517367546e-07 0.00021 2.5936377517367547e-07 0 2.5939980544397824e-07 0 2.5940980544397825e-07 0.00021 2.5941980544397826e-07 0 2.5949011226386965e-07 0 2.5950011226386966e-07 0.00021 2.5951011226386967e-07 0 2.5958568293840214e-07 0 2.5959568293840215e-07 0.00021 2.5960568293840217e-07 0 2.5980043906614177e-07 0 2.598104390661418e-07 0.00021 2.598204390661418e-07 0 2.5986637899338563e-07 0 2.5987637899338564e-07 0.00021 2.5988637899338565e-07 0 2.598968513933894e-07 0 2.5990685139338943e-07 0.00021 2.5991685139338944e-07 0 2.5991685139338944e-07 0 2.5992685139338945e-07 0.00021 2.5993685139338947e-07 0 2.6001782616168035e-07 0 2.6002782616168036e-07 0.00021 2.6003782616168037e-07 0 2.6006272388345626e-07 0 2.6007272388345627e-07 0.00021 2.600827238834563e-07 0 2.600827238834563e-07 0 2.600927238834563e-07 0.00021 2.601027238834563e-07 0 2.601027238834563e-07 0 2.601127238834563e-07 0.00021 2.601227238834563e-07 0 2.601227238834563e-07 0 2.6013272388345634e-07 0.00021 2.6014272388345635e-07 0 2.6014272388345635e-07 0 2.6015272388345636e-07 0.00021 2.6016272388345637e-07 0 2.6016272388345637e-07 0 2.601727238834564e-07 0.00021 2.601827238834564e-07 0 2.601827238834564e-07 0 2.601927238834564e-07 0.00021 2.602027238834564e-07 0 2.602027238834564e-07 0 2.602127238834564e-07 0.00021 2.6022272388345644e-07 0 2.602930853742779e-07 0 2.603030853742779e-07 0.00021 2.603130853742779e-07 0 2.603130853742779e-07 0 2.6032308537427793e-07 0.00021 2.6033308537427794e-07 0 2.6065678798727153e-07 0 2.6066678798727154e-07 0.00021 2.6067678798727155e-07 0 2.6068062802930885e-07 0 2.6069062802930886e-07 0.00021 2.607006280293089e-07 0 2.608884969771478e-07 0 2.608984969771478e-07 0.00021 2.609084969771478e-07 0 2.6104911476749723e-07 0 2.6105911476749724e-07 0.00021 2.6106911476749725e-07 0 2.6106911476749725e-07 0 2.6107911476749726e-07 0.00021 2.610891147674973e-07 0 2.611543000271096e-07 0 2.6116430002710963e-07 0.00021 2.6117430002710964e-07 0 2.6120721679913996e-07 0 2.6121721679914e-07 0.00021 2.6122721679914e-07 0 2.6129829991885437e-07 0 2.613082999188544e-07 0.00021 2.613182999188544e-07 0 2.6136800559415357e-07 0 2.613780055941536e-07 0.00021 2.613880055941536e-07 0 2.613880055941536e-07 0 2.613980055941536e-07 0.00021 2.614080055941536e-07 0 2.6151863926844006e-07 0 2.6152863926844007e-07 0.00021 2.615386392684401e-07 0 2.616105809370222e-07 0 2.616205809370222e-07 0.00021 2.6163058093702224e-07 0 2.616471828935696e-07 0 2.616571828935696e-07 0.00021 2.616671828935696e-07 0 2.617861613391222e-07 0 2.617961613391222e-07 0.00021 2.618061613391222e-07 0 2.619406371093555e-07 0 2.619506371093555e-07 0.00021 2.6196063710935553e-07 0 2.620440767204291e-07 0 2.620540767204291e-07 0.00021 2.620640767204291e-07 0 2.622028253067772e-07 0 2.622128253067772e-07 0.00021 2.6222282530677723e-07 0 2.622796103436177e-07 0 2.622896103436177e-07 0.00021 2.6229961034361774e-07 0 2.6229961034361774e-07 0 2.6230961034361775e-07 0.00021 2.6231961034361776e-07 0 2.62328370083235e-07 0 2.6233837008323504e-07 0.00021 2.6234837008323505e-07 0 2.6234837008323505e-07 0 2.6235837008323506e-07 0.00021 2.6236837008323507e-07 0 2.6236837008323507e-07 0 2.623783700832351e-07 0.00021 2.623883700832351e-07 0 2.623883700832351e-07 0 2.623983700832351e-07 0.00021 2.624083700832351e-07 0 2.624181235478452e-07 0 2.624281235478452e-07 0.00021 2.624381235478452e-07 0 2.624381235478452e-07 0 2.6244812354784523e-07 0.00021 2.6245812354784524e-07 0 2.6245812354784524e-07 0 2.6246812354784525e-07 0.00021 2.6247812354784527e-07 0 2.6273283100558716e-07 0 2.6274283100558717e-07 0.00021 2.627528310055872e-07 0 2.6281784358130905e-07 0 2.6282784358130907e-07 0.00021 2.628378435813091e-07 0 2.628378435813091e-07 0 2.628478435813091e-07 0.00021 2.628578435813091e-07 0 2.628617700986673e-07 0 2.628717700986673e-07 0.00021 2.628817700986673e-07 0 2.628817700986673e-07 0 2.6289177009866733e-07 0.00021 2.6290177009866734e-07 0 2.630001674098748e-07 0 2.630101674098748e-07 0.00021 2.630201674098748e-07 0 2.6317049416971617e-07 0 2.631804941697162e-07 0.00021 2.631904941697162e-07 0 2.6321625099294364e-07 0 2.6322625099294365e-07 0.00021 2.6323625099294366e-07 0 2.632700517016673e-07 0 2.632800517016673e-07 0.00021 2.632900517016673e-07 0 2.6335038654412243e-07 0 2.6336038654412245e-07 0.00021 2.6337038654412246e-07 0 2.6342446327172886e-07 0 2.6343446327172887e-07 0.00021 2.634444632717289e-07 0 2.634790325349576e-07 0 2.634890325349576e-07 0.00021 2.634990325349576e-07 0 2.6372552915299805e-07 0 2.6373552915299806e-07 0.00021 2.637455291529981e-07 0 2.637993114635055e-07 0 2.638093114635055e-07 0.00021 2.638193114635055e-07 0 2.639654194365633e-07 0 2.639754194365633e-07 0.00021 2.639854194365633e-07 0 2.642275726717094e-07 0 2.6423757267170943e-07 0.00021 2.6424757267170944e-07 0 2.6425836779456997e-07 0 2.6426836779457e-07 0.00021 2.6427836779457e-07 0 2.643017296646468e-07 0 2.6431172966464684e-07 0.00021 2.6432172966464685e-07 0 2.6446025180668843e-07 0 2.6447025180668845e-07 0.00021 2.6448025180668846e-07 0 2.645963023436399e-07 0 2.646063023436399e-07 0.00021 2.646163023436399e-07 0 2.6512453140301537e-07 0 2.651345314030154e-07 0.00021 2.651445314030154e-07 0 2.6515305781323505e-07 0 2.6516305781323506e-07 0.00021 2.6517305781323507e-07 0 2.6517305781323507e-07 0 2.651830578132351e-07 0.00021 2.651930578132351e-07 0 2.652056756758315e-07 0 2.652156756758315e-07 0.00021 2.6522567567583153e-07 0 2.6522567567583153e-07 0 2.6523567567583154e-07 0.00021 2.6524567567583155e-07 0 2.6524567567583155e-07 0 2.6525567567583156e-07 0.00021 2.652656756758316e-07 0 2.652957100146951e-07 0 2.653057100146951e-07 0.00021 2.653157100146951e-07 0 2.653686747652049e-07 0 2.653786747652049e-07 0.00021 2.6538867476520494e-07 0 2.6540579382674003e-07 0 2.6541579382674004e-07 0.00021 2.6542579382674005e-07 0 2.6542579382674005e-07 0 2.6543579382674006e-07 0.00021 2.6544579382674007e-07 0 2.655448524678979e-07 0 2.655548524678979e-07 0.00021 2.655648524678979e-07 0 2.655648524678979e-07 0 2.655748524678979e-07 0.00021 2.6558485246789793e-07 0 2.655877833417046e-07 0 2.6559778334170463e-07 0.00021 2.6560778334170464e-07 0 2.656640560741528e-07 0 2.6567405607415283e-07 0.00021 2.6568405607415284e-07 0 2.6581090237017093e-07 0 2.6582090237017094e-07 0.00021 2.6583090237017096e-07 0 2.65860949581212e-07 0 2.65870949581212e-07 0.00021 2.6588094958121204e-07 0 2.658916172857158e-07 0 2.659016172857158e-07 0.00021 2.659116172857158e-07 0 2.659540986499354e-07 0 2.659640986499354e-07 0.00021 2.659740986499354e-07 0 2.659907520791908e-07 0 2.660007520791908e-07 0.00021 2.660107520791908e-07 0 2.66229288904916e-07 0 2.66239288904916e-07 0.00021 2.66249288904916e-07 0 2.6656539793733726e-07 0 2.665753979373373e-07 0.00021 2.665853979373373e-07 0 2.6666796964842133e-07 0 2.6667796964842134e-07 0.00021 2.6668796964842136e-07 0 2.6668927692458954e-07 0 2.6669927692458955e-07 0.00021 2.6670927692458957e-07 0 2.6670927692458957e-07 0 2.667192769245896e-07 0.00021 2.667292769245896e-07 0 2.667292769245896e-07 0 2.667392769245896e-07 0.00021 2.667492769245896e-07 0 2.6687849180274186e-07 0 2.6688849180274187e-07 0.00021 2.668984918027419e-07 0 2.670408960765402e-07 0 2.670508960765402e-07 0.00021 2.670608960765402e-07 0 2.671729259876879e-07 0 2.671829259876879e-07 0.00021 2.671929259876879e-07 0 2.672029271378043e-07 0 2.672129271378043e-07 0.00021 2.6722292713780433e-07 0 2.6722544898324177e-07 0 2.672354489832418e-07 0.00021 2.672454489832418e-07 0 2.672454489832418e-07 0 2.672554489832418e-07 0.00021 2.672654489832418e-07 0 2.6728528597594655e-07 0 2.6729528597594656e-07 0.00021 2.6730528597594657e-07 0 2.6737481524994263e-07 0 2.6738481524994264e-07 0.00021 2.6739481524994265e-07 0 2.6739481524994265e-07 0 2.6740481524994266e-07 0.00021 2.674148152499427e-07 0 2.6748708208549106e-07 0 2.6749708208549107e-07 0.00021 2.675070820854911e-07 0 2.67550491455074e-07 0 2.67560491455074e-07 0.00021 2.67570491455074e-07 0 2.6761475856850824e-07 0 2.6762475856850825e-07 0.00021 2.6763475856850826e-07 0 2.6768352654479174e-07 0 2.6769352654479176e-07 0.00021 2.6770352654479177e-07 0 2.67734625083881e-07 0 2.67744625083881e-07 0.00021 2.6775462508388103e-07 0 2.6777345501338175e-07 0 2.6778345501338176e-07 0.00021 2.677934550133818e-07 0 2.678579498394094e-07 0 2.678679498394094e-07 0.00021 2.678779498394094e-07 0 2.6789757214940077e-07 0 2.679075721494008e-07 0.00021 2.679175721494008e-07 0 2.679175721494008e-07 0 2.679275721494008e-07 0.00021 2.679375721494008e-07 0 2.6808364358044604e-07 0 2.6809364358044605e-07 0.00021 2.6810364358044606e-07 0 2.6820353751561415e-07 0 2.6821353751561416e-07 0.00021 2.682235375156142e-07 0 2.682235375156142e-07 0 2.682335375156142e-07 0.00021 2.682435375156142e-07 0 2.682489364728259e-07 0 2.682589364728259e-07 0.00021 2.682689364728259e-07 0 2.685536467852512e-07 0 2.685636467852512e-07 0.00021 2.6857364678525123e-07 0 2.688202113880521e-07 0 2.6883021138805213e-07 0.00021 2.6884021138805215e-07 0 2.6891851948020334e-07 0 2.6892851948020335e-07 0.00021 2.6893851948020336e-07 0 2.6905279788918176e-07 0 2.6906279788918177e-07 0.00021 2.690727978891818e-07 0 2.692141510389682e-07 0 2.692241510389682e-07 0.00021 2.6923415103896823e-07 0 2.696608428625716e-07 0 2.696708428625716e-07 0.00021 2.696808428625716e-07 0 2.6971415838223743e-07 0 2.6972415838223744e-07 0.00021 2.6973415838223745e-07 0 2.6979627721279716e-07 0 2.698062772127972e-07 0.00021 2.698162772127972e-07 0 2.698162772127972e-07 0 2.698262772127972e-07 0.00021 2.698362772127972e-07 0 2.698362772127972e-07 0 2.698462772127972e-07 0.00021 2.6985627721279723e-07 0 2.6985627721279723e-07 0 2.6986627721279724e-07 0.00021 2.6987627721279725e-07 0 2.6987627721279725e-07 0 2.6988627721279727e-07 0.00021 2.698962772127973e-07 0 2.698962772127973e-07 0 2.699062772127973e-07 0.00021 2.699162772127973e-07 0 2.699162772127973e-07 0 2.699262772127973e-07 0.00021 2.699362772127973e-07 0 2.699669394291974e-07 0 2.699769394291974e-07 0.00021 2.6998693942919743e-07 0 2.6998693942919743e-07 0 2.6999693942919744e-07 0.00021 2.7000693942919745e-07 0 2.7000693942919745e-07 0 2.7001693942919746e-07 0.00021 2.700269394291975e-07 0 2.700269394291975e-07 0 2.700369394291975e-07 0.00021 2.700469394291975e-07 0 2.700469394291975e-07 0 2.700569394291975e-07 0.00021 2.700669394291975e-07 0 2.702466923353964e-07 0 2.702566923353964e-07 0.00021 2.702666923353964e-07 0 2.704369535223459e-07 0 2.704469535223459e-07 0.00021 2.704569535223459e-07 0 2.7055347111442773e-07 0 2.7056347111442775e-07 0.00021 2.7057347111442776e-07 0 2.705784025758346e-07 0 2.705884025758346e-07 0.00021 2.705984025758346e-07 0 2.7070790925809063e-07 0 2.7071790925809064e-07 0.00021 2.7072790925809065e-07 0 2.707450065716144e-07 0 2.7075500657161443e-07 0.00021 2.7076500657161444e-07 0 2.709000835200613e-07 0 2.709100835200613e-07 0.00021 2.709200835200613e-07 0 2.7097104543432517e-07 0 2.709810454343252e-07 0.00021 2.709910454343252e-07 0 2.710123410909411e-07 0 2.7102234109094113e-07 0.00021 2.7103234109094114e-07 0 2.7103234109094114e-07 0 2.7104234109094116e-07 0.00021 2.7105234109094117e-07 0 2.710589679121637e-07 0 2.710689679121637e-07 0.00021 2.710789679121637e-07 0 2.710789679121637e-07 0 2.7108896791216373e-07 0.00021 2.7109896791216374e-07 0 2.7116411928434516e-07 0 2.711741192843452e-07 0.00021 2.711841192843452e-07 0 2.7124555294993597e-07 0 2.71255552949936e-07 0.00021 2.71265552949936e-07 0 2.7143493876915283e-07 0 2.7144493876915284e-07 0.00021 2.7145493876915285e-07 0 2.7157266296726516e-07 0 2.7158266296726517e-07 0.00021 2.715926629672652e-07 0 2.7163650055315203e-07 0 2.7164650055315204e-07 0.00021 2.7165650055315206e-07 0 2.7165650055315206e-07 0 2.7166650055315207e-07 0.00021 2.716765005531521e-07 0 2.723381407322655e-07 0 2.723481407322655e-07 0.00021 2.723581407322655e-07 0 2.7242226188800493e-07 0 2.7243226188800494e-07 0.00021 2.7244226188800496e-07 0 2.7248863900187074e-07 0 2.7249863900187075e-07 0.00021 2.7250863900187076e-07 0 2.7255664772177087e-07 0 2.725666477217709e-07 0.00021 2.725766477217709e-07 0 2.725794074035552e-07 0 2.725894074035552e-07 0.00021 2.725994074035552e-07 0 2.7262217406451227e-07 0 2.726321740645123e-07 0.00021 2.726421740645123e-07 0 2.727467817107497e-07 0 2.727567817107497e-07 0.00021 2.7276678171074974e-07 0 2.7282382645209593e-07 0 2.7283382645209594e-07 0.00021 2.7284382645209596e-07 0 2.728703633255944e-07 0 2.728803633255944e-07 0.00021 2.7289036332559443e-07 0 2.7301191181050775e-07 0 2.7302191181050776e-07 0.00021 2.730319118105078e-07 0 2.7307578052005335e-07 0 2.7308578052005336e-07 0.00021 2.7309578052005337e-07 0 2.7309578052005337e-07 0 2.731057805200534e-07 0.00021 2.731157805200534e-07 0 2.731157805200534e-07 0 2.731257805200534e-07 0.00021 2.731357805200534e-07 0 2.732076396337237e-07 0 2.732176396337237e-07 0.00021 2.732276396337237e-07 0 2.732276396337237e-07 0 2.7323763963372373e-07 0.00021 2.7324763963372374e-07 0 2.7337725030799125e-07 0 2.7338725030799126e-07 0.00021 2.7339725030799127e-07 0 2.7342517390300133e-07 0 2.7343517390300134e-07 0.00021 2.7344517390300135e-07 0 2.73477472851559e-07 0 2.73487472851559e-07 0.00021 2.73497472851559e-07 0 2.7359721783010153e-07 0 2.7360721783010154e-07 0.00021 2.7361721783010155e-07 0 2.740648807621088e-07 0 2.7407488076210883e-07 0.00021 2.7408488076210884e-07 0 2.741613944892865e-07 0 2.741713944892865e-07 0.00021 2.7418139448928653e-07 0 2.7429752256802625e-07 0 2.7430752256802626e-07 0.00021 2.7431752256802627e-07 0 2.747718863772563e-07 0 2.747818863772563e-07 0.00021 2.747918863772563e-07 0 2.7496012124744854e-07 0 2.7497012124744855e-07 0.00021 2.7498012124744856e-07 0 2.7498012124744856e-07 0 2.7499012124744857e-07 0.00021 2.750001212474486e-07 0 2.750001212474486e-07 0 2.750101212474486e-07 0.00021 2.750201212474486e-07 0 2.750332898138545e-07 0 2.7504328981385453e-07 0.00021 2.7505328981385455e-07 0 2.7523732428157705e-07 0 2.7524732428157706e-07 0.00021 2.7525732428157707e-07 0 2.753607095525835e-07 0 2.7537070955258353e-07 0.00021 2.7538070955258354e-07 0 2.755555936317313e-07 0 2.7556559363173133e-07 0.00021 2.7557559363173134e-07 0 2.757377904746773e-07 0 2.757477904746773e-07 0.00021 2.757577904746773e-07 0 2.758990440487575e-07 0 2.759090440487575e-07 0.00021 2.759190440487575e-07 0 2.759190440487575e-07 0 2.7592904404875753e-07 0.00021 2.7593904404875754e-07 0 2.7595322868286244e-07 0 2.7596322868286245e-07 0.00021 2.7597322868286246e-07 0 2.76043657927173e-07 0 2.7605365792717303e-07 0.00021 2.7606365792717304e-07 0 2.7606365792717304e-07 0 2.7607365792717305e-07 0.00021 2.7608365792717306e-07 0 2.761889782146881e-07 0 2.761989782146881e-07 0.00021 2.7620897821468813e-07 0 2.7621363647800437e-07 0 2.762236364780044e-07 0.00021 2.762336364780044e-07 0 2.7627181357548444e-07 0 2.7628181357548445e-07 0.00021 2.7629181357548446e-07 0 2.7629181357548446e-07 0 2.7630181357548447e-07 0.00021 2.763118135754845e-07 0 2.763118135754845e-07 0 2.763218135754845e-07 0.00021 2.763318135754845e-07 0 2.763365647130309e-07 0 2.763465647130309e-07 0.00021 2.763565647130309e-07 0 2.7636871883127447e-07 0 2.763787188312745e-07 0.00021 2.763887188312745e-07 0 2.7643471081371955e-07 0 2.7644471081371956e-07 0.00021 2.7645471081371957e-07 0 2.76477707455626e-07 0 2.76487707455626e-07 0.00021 2.76497707455626e-07 0 2.7654913621681387e-07 0 2.765591362168139e-07 0.00021 2.765691362168139e-07 0 2.765691362168139e-07 0 2.765791362168139e-07 0.00021 2.765891362168139e-07 0 2.765900999650225e-07 0 2.7660009996502254e-07 0.00021 2.7661009996502255e-07 0 2.7664237246491187e-07 0 2.766523724649119e-07 0.00021 2.766623724649119e-07 0 2.768100754432443e-07 0 2.768200754432443e-07 0.00021 2.768300754432443e-07 0 2.7685288661303087e-07 0 2.768628866130309e-07 0.00021 2.768728866130309e-07 0 2.769617663845659e-07 0 2.769717663845659e-07 0.00021 2.769817663845659e-07 0 2.770374354326445e-07 0 2.770474354326445e-07 0.00021 2.770574354326445e-07 0 2.770945622122457e-07 0 2.771045622122457e-07 0.00021 2.771145622122457e-07 0 2.771222241958264e-07 0 2.771322241958264e-07 0.00021 2.771422241958264e-07 0 2.7715048460904064e-07 0 2.7716048460904065e-07 0.00021 2.7717048460904067e-07 0 2.772586874617392e-07 0 2.772686874617392e-07 0.00021 2.772786874617392e-07 0 2.7739442461539165e-07 0 2.7740442461539166e-07 0.00021 2.7741442461539167e-07 0 2.7741442461539167e-07 0 2.774244246153917e-07 0.00021 2.774344246153917e-07 0 2.774382037329475e-07 0 2.774482037329475e-07 0.00021 2.774582037329475e-07 0 2.7751547289660677e-07 0 2.775254728966068e-07 0.00021 2.775354728966068e-07 0 2.775354728966068e-07 0 2.775454728966068e-07 0.00021 2.775554728966068e-07 0 2.775689024837334e-07 0 2.7757890248373344e-07 0.00021 2.7758890248373345e-07 0 2.77719626183567e-07 0 2.7772962618356703e-07 0.00021 2.7773962618356704e-07 0 2.777710968658106e-07 0 2.777810968658106e-07 0.00021 2.777910968658106e-07 0 2.778275339829992e-07 0 2.778375339829992e-07 0.00021 2.778475339829992e-07 0 2.778582874825205e-07 0 2.778682874825205e-07 0.00021 2.778782874825205e-07 0 2.7791624411167496e-07 0 2.77926244111675e-07 0.00021 2.77936244111675e-07 0 2.77936244111675e-07 0 2.77946244111675e-07 0.00021 2.77956244111675e-07 0 2.77956244111675e-07 0 2.77966244111675e-07 0.00021 2.7797624411167503e-07 0 2.7800994560028764e-07 0 2.7801994560028765e-07 0.00021 2.7802994560028766e-07 0 2.7802994560028766e-07 0 2.780399456002877e-07 0.00021 2.780499456002877e-07 0 2.7841854911792986e-07 0 2.7842854911792987e-07 0.00021 2.784385491179299e-07 0 2.7854186677631067e-07 0 2.785518667763107e-07 0.00021 2.785618667763107e-07 0 2.785618667763107e-07 0 2.785718667763107e-07 0.00021 2.785818667763107e-07 0 2.7867024403045616e-07 0 2.7868024403045617e-07 0.00021 2.786902440304562e-07 0 2.786943110205263e-07 0 2.787043110205263e-07 0.00021 2.787143110205263e-07 0 2.7878610122917616e-07 0 2.7879610122917617e-07 0.00021 2.788061012291762e-07 0 2.788061012291762e-07 0 2.788161012291762e-07 0.00021 2.788261012291762e-07 0 2.788261012291762e-07 0 2.788361012291762e-07 0.00021 2.7884610122917623e-07 0 2.7901365098249084e-07 0 2.7902365098249085e-07 0.00021 2.7903365098249086e-07 0 2.792327349275642e-07 0 2.792427349275642e-07 0.00021 2.792527349275642e-07 0 2.792527349275642e-07 0 2.792627349275642e-07 0.00021 2.7927273492756424e-07 0 2.7935503595488234e-07 0 2.7936503595488235e-07 0.00021 2.7937503595488236e-07 0 2.7967609519057473e-07 0 2.7968609519057474e-07 0.00021 2.7969609519057476e-07 0 2.7977154705307945e-07 0 2.7978154705307946e-07 0.00021 2.7979154705307947e-07 0 2.7996948513095095e-07 0 2.7997948513095096e-07 0.00021 2.7998948513095097e-07 0 2.7998948513095097e-07 0 2.79999485130951e-07 0.00021 2.80009485130951e-07 0 2.800723375808969e-07 0 2.800823375808969e-07 0.00021 2.800923375808969e-07 0 2.804077620461071e-07 0 2.8041776204610713e-07 0.00021 2.8042776204610714e-07 0 2.804568514592908e-07 0 2.804668514592908e-07 0.00021 2.804768514592908e-07 0 2.805216081379873e-07 0 2.805316081379873e-07 0.00021 2.8054160813798734e-07 0 2.8059772238748905e-07 0 2.8060772238748906e-07 0.00021 2.8061772238748907e-07 0 2.806291427712283e-07 0 2.8063914277122833e-07 0.00021 2.8064914277122834e-07 0 2.8067027570866003e-07 0 2.8068027570866004e-07 0.00021 2.8069027570866006e-07 0 2.807928235584019e-07 0 2.808028235584019e-07 0.00021 2.808128235584019e-07 0 2.8087592410375126e-07 0 2.8088592410375127e-07 0.00021 2.808959241037513e-07 0 2.810775308152541e-07 0 2.810875308152541e-07 0.00021 2.810975308152541e-07 0 2.8110715845216876e-07 0 2.8111715845216877e-07 0.00021 2.811271584521688e-07 0 2.811623820099088e-07 0 2.8117238200990884e-07 0.00021 2.8118238200990885e-07 0 2.8133187329332736e-07 0 2.8134187329332737e-07 0.00021 2.813518732933274e-07 0 2.814580662342908e-07 0 2.814680662342908e-07 0.00021 2.814780662342908e-07 0 2.815176610162989e-07 0 2.815276610162989e-07 0.00021 2.8153766101629893e-07 0 2.8155917647945836e-07 0 2.8156917647945837e-07 0.00021 2.815791764794584e-07 0 2.816063582205522e-07 0 2.816163582205522e-07 0.00021 2.816263582205522e-07 0 2.8176073291117993e-07 0 2.8177073291117994e-07 0.00021 2.8178073291117995e-07 0 2.818494430922889e-07 0 2.818594430922889e-07 0.00021 2.818694430922889e-07 0 2.8194022222328176e-07 0 2.8195022222328177e-07 0.00021 2.819602222232818e-07 0 2.819602222232818e-07 0 2.819702222232818e-07 0.00021 2.819802222232818e-07 0 2.8211398845330487e-07 0 2.821239884533049e-07 0.00021 2.821339884533049e-07 0 2.8217249667311955e-07 0 2.8218249667311956e-07 0.00021 2.821924966731196e-07 0 2.822723171550861e-07 0 2.822823171550861e-07 0.00021 2.8229231715508613e-07 0 2.823127758946518e-07 0 2.8232277589465183e-07 0.00021 2.8233277589465184e-07 0 2.8233294292666044e-07 0 2.8234294292666045e-07 0.00021 2.8235294292666047e-07 0 2.823805598007982e-07 0 2.8239055980079823e-07 0.00021 2.8240055980079824e-07 0 2.8253564114005584e-07 0 2.8254564114005585e-07 0.00021 2.8255564114005587e-07 0 2.8255564114005587e-07 0 2.825656411400559e-07 0.00021 2.825756411400559e-07 0 2.825756411400559e-07 0 2.825856411400559e-07 0.00021 2.825956411400559e-07 0 2.8260677911030717e-07 0 2.826167791103072e-07 0.00021 2.826267791103072e-07 0 2.827686152350081e-07 0 2.8277861523500813e-07 0.00021 2.8278861523500814e-07 0 2.8289304795182167e-07 0 2.829030479518217e-07 0.00021 2.829130479518217e-07 0 2.8293988297946757e-07 0 2.829498829794676e-07 0.00021 2.829598829794676e-07 0 2.8303948824016557e-07 0 2.830494882401656e-07 0.00021 2.830594882401656e-07 0 2.832585190110753e-07 0 2.832685190110753e-07 0.00021 2.8327851901107533e-07 0 2.834863648728752e-07 0 2.834963648728752e-07 0.00021 2.835063648728752e-07 0 2.8358603263767374e-07 0 2.8359603263767375e-07 0.00021 2.8360603263767376e-07 0 2.837085925075828e-07 0 2.8371859250758283e-07 0.00021 2.8372859250758284e-07 0 2.83831792051637e-07 0 2.83841792051637e-07 0.00021 2.83851792051637e-07 0 2.838647957880101e-07 0 2.838747957880101e-07 0.00021 2.838847957880101e-07 0 2.8390009207623594e-07 0 2.8391009207623595e-07 0.00021 2.8392009207623596e-07 0 2.8393889017323024e-07 0 2.8394889017323025e-07 0.00021 2.8395889017323026e-07 0 2.8395889017323026e-07 0 2.8396889017323027e-07 0.00021 2.839788901732303e-07 0 2.840084674144486e-07 0 2.8401846741444864e-07 0.00021 2.8402846741444865e-07 0 2.8403112855429015e-07 0 2.8404112855429016e-07 0.00021 2.840511285542902e-07 0 2.841842603195777e-07 0 2.841942603195777e-07 0.00021 2.842042603195777e-07 0 2.8432047865521755e-07 0 2.8433047865521756e-07 0.00021 2.843404786552176e-07 0 2.843404786552176e-07 0 2.843504786552176e-07 0.00021 2.843604786552176e-07 0 2.843713771966215e-07 0 2.843813771966215e-07 0.00021 2.8439137719662153e-07 0 2.844509992701523e-07 0 2.8446099927015234e-07 0.00021 2.8447099927015235e-07 0 2.8449706424415977e-07 0 2.845070642441598e-07 0.00021 2.845170642441598e-07 0 2.845170642441598e-07 0 2.845270642441598e-07 0.00021 2.845370642441598e-07 0 2.845437533444552e-07 0 2.845537533444552e-07 0.00021 2.845637533444552e-07 0 2.846749837626011e-07 0 2.8468498376260113e-07 0.00021 2.8469498376260114e-07 0 2.84784323381793e-07 0 2.84794323381793e-07 0.00021 2.8480432338179303e-07 0 2.8482396085368263e-07 0 2.8483396085368264e-07 0.00021 2.8484396085368265e-07 0 2.8514830000289374e-07 0 2.8515830000289375e-07 0.00021 2.8516830000289376e-07 0 2.8516893522244663e-07 0 2.8517893522244665e-07 0.00021 2.8518893522244666e-07 0 2.85236506254078e-07 0 2.8524650625407804e-07 0.00021 2.8525650625407805e-07 0 2.8533315235252545e-07 0 2.8534315235252546e-07 0.00021 2.853531523525255e-07 0 2.8535503531220734e-07 0 2.8536503531220735e-07 0.00021 2.8537503531220737e-07 0 2.8537503531220737e-07 0 2.853850353122074e-07 0.00021 2.853950353122074e-07 0 2.855178352635587e-07 0 2.855278352635587e-07 0.00021 2.8553783526355873e-07 0 2.8553783526355873e-07 0 2.8554783526355874e-07 0.00021 2.8555783526355875e-07 0 2.856880166048373e-07 0 2.856980166048373e-07 0.00021 2.857080166048373e-07 0 2.859481654928305e-07 0 2.859581654928305e-07 0.00021 2.8596816549283053e-07 0 2.8596816549283053e-07 0 2.8597816549283054e-07 0.00021 2.8598816549283055e-07 0 2.8598816549283055e-07 0 2.8599816549283056e-07 0.00021 2.860081654928306e-07 0 2.86012267527202e-07 0 2.86022267527202e-07 0.00021 2.8603226752720203e-07 0 2.8609837369177724e-07 0 2.8610837369177725e-07 0.00021 2.8611837369177726e-07 0 2.861437553588367e-07 0 2.861537553588367e-07 0.00021 2.861637553588367e-07 0 2.861637553588367e-07 0 2.861737553588367e-07 0.00021 2.861837553588367e-07 0 2.861837553588367e-07 0 2.8619375535883673e-07 0.00021 2.8620375535883674e-07 0 2.862125808454323e-07 0 2.862225808454323e-07 0.00021 2.862325808454323e-07 0 2.864356851159525e-07 0 2.864456851159525e-07 0.00021 2.864556851159525e-07 0 2.8657680993734893e-07 0 2.8658680993734894e-07 0.00021 2.8659680993734895e-07 0 2.8665177236694204e-07 0 2.8666177236694205e-07 0.00021 2.8667177236694207e-07 0 2.869633301668426e-07 0 2.869733301668426e-07 0.00021 2.869833301668426e-07 0 2.86985182769859e-07 0 2.86995182769859e-07 0.00021 2.87005182769859e-07 0 2.87005182769859e-07 0 2.87015182769859e-07 0.00021 2.87025182769859e-07 0 2.870724619038896e-07 0 2.870824619038896e-07 0.00021 2.870924619038896e-07 0 2.8710038502619046e-07 0 2.8711038502619047e-07 0.00021 2.871203850261905e-07 0 2.872427671894163e-07 0 2.8725276718941633e-07 0.00021 2.8726276718941634e-07 0 2.873749816666939e-07 0 2.873849816666939e-07 0.00021 2.873949816666939e-07 0 2.874245519380659e-07 0 2.874345519380659e-07 0.00021 2.8744455193806594e-07 0 2.874797079806181e-07 0 2.8748970798061813e-07 0.00021 2.8749970798061814e-07 0 2.875259454588812e-07 0 2.875359454588812e-07 0.00021 2.875459454588812e-07 0 2.875459454588812e-07 0 2.8755594545888123e-07 0.00021 2.8756594545888125e-07 0 2.876201775381464e-07 0 2.876301775381464e-07 0.00021 2.876401775381464e-07 0 2.8764713776435846e-07 0 2.8765713776435847e-07 0.00021 2.876671377643585e-07 0 2.876671377643585e-07 0 2.876771377643585e-07 0.00021 2.876871377643585e-07 0 2.876937755737017e-07 0 2.877037755737017e-07 0.00021 2.877137755737017e-07 0 2.87800864363876e-07 0 2.8781086436387603e-07 0.00021 2.8782086436387604e-07 0 2.879392298344815e-07 0 2.879492298344815e-07 0.00021 2.879592298344815e-07 0 2.8800071565137753e-07 0 2.8801071565137754e-07 0.00021 2.8802071565137756e-07 0 2.881724650418421e-07 0 2.8818246504184213e-07 0.00021 2.8819246504184214e-07 0 2.8820976318469913e-07 0 2.8821976318469914e-07 0.00021 2.8822976318469916e-07 0 2.882307686142551e-07 0 2.8824076861425514e-07 0.00021 2.8825076861425515e-07 0 2.8831618641686696e-07 0 2.8832618641686697e-07 0.00021 2.88336186416867e-07 0 2.8836233769259113e-07 0 2.8837233769259114e-07 0.00021 2.8838233769259115e-07 0 2.8838684012324994e-07 0 2.8839684012324995e-07 0.00021 2.8840684012324996e-07 0 2.885214719235904e-07 0 2.885314719235904e-07 0.00021 2.8854147192359044e-07 0 2.886636644097092e-07 0 2.886736644097092e-07 0.00021 2.886836644097092e-07 0 2.887377528402536e-07 0 2.887477528402536e-07 0.00021 2.887577528402536e-07 0 2.889247877376535e-07 0 2.889347877376535e-07 0.00021 2.889447877376535e-07 0 2.890215717366034e-07 0 2.8903157173660343e-07 0.00021 2.8904157173660344e-07 0 2.8904157173660344e-07 0 2.8905157173660345e-07 0.00021 2.8906157173660347e-07 0 2.8906157173660347e-07 0 2.890715717366035e-07 0.00021 2.890815717366035e-07 0 2.8908514476164257e-07 0 2.890951447616426e-07 0.00021 2.891051447616426e-07 0 2.891051447616426e-07 0 2.891151447616426e-07 0.00021 2.891251447616426e-07 0 2.8945351814332887e-07 0 2.894635181433289e-07 0.00021 2.894735181433289e-07 0 2.894735181433289e-07 0 2.894835181433289e-07 0.00021 2.894935181433289e-07 0 2.8950382015447947e-07 0 2.895138201544795e-07 0.00021 2.895238201544795e-07 0 2.895238201544795e-07 0 2.895338201544795e-07 0.00021 2.895438201544795e-07 0 2.895459841335396e-07 0 2.895559841335396e-07 0.00021 2.895659841335396e-07 0 2.8960407114358505e-07 0 2.8961407114358506e-07 0.00021 2.896240711435851e-07 0 2.8964114222995246e-07 0 2.8965114222995247e-07 0.00021 2.896611422299525e-07 0 2.896611422299525e-07 0 2.896711422299525e-07 0.00021 2.896811422299525e-07 0 2.8974267707953864e-07 0 2.8975267707953865e-07 0.00021 2.8976267707953866e-07 0 2.8978435769186416e-07 0 2.8979435769186417e-07 0.00021 2.898043576918642e-07 0 2.8980522401248115e-07 0 2.8981522401248116e-07 0.00021 2.8982522401248117e-07 0 2.8982522401248117e-07 0 2.898352240124812e-07 0.00021 2.898452240124812e-07 0 2.8986177522000205e-07 0 2.8987177522000206e-07 0.00021 2.8988177522000207e-07 0 2.898924292152889e-07 0 2.8990242921528893e-07 0.00021 2.8991242921528894e-07 0 2.8998235801422834e-07 0 2.8999235801422835e-07 0.00021 2.9000235801422836e-07 0 2.900394570790494e-07 0 2.900494570790494e-07 0.00021 2.9005945707904944e-07 0 2.9005945707904944e-07 0 2.9006945707904945e-07 0.00021 2.9007945707904946e-07 0 2.901740574340683e-07 0 2.901840574340683e-07 0.00021 2.901940574340683e-07 0 2.9026047290740334e-07 0 2.9027047290740335e-07 0.00021 2.9028047290740336e-07 0 2.9034398049877506e-07 0 2.903539804987751e-07 0.00021 2.903639804987751e-07 0 2.903674346403678e-07 0 2.903774346403678e-07 0.00021 2.903874346403678e-07 0 2.903874346403678e-07 0 2.9039743464036783e-07 0.00021 2.9040743464036784e-07 0 2.9040743464036784e-07 0 2.9041743464036785e-07 0.00021 2.9042743464036786e-07 0 2.9045319893238943e-07 0 2.9046319893238944e-07 0.00021 2.9047319893238945e-07 0 2.9054509922427895e-07 0 2.9055509922427896e-07 0.00021 2.9056509922427897e-07 0 2.9058341432530845e-07 0 2.9059341432530846e-07 0.00021 2.906034143253085e-07 0 2.906034143253085e-07 0 2.906134143253085e-07 0.00021 2.906234143253085e-07 0 2.906234143253085e-07 0 2.906334143253085e-07 0.00021 2.906434143253085e-07 0 2.906434143253085e-07 0 2.9065341432530853e-07 0.00021 2.9066341432530854e-07 0 2.9069365320462355e-07 0 2.9070365320462356e-07 0.00021 2.907136532046236e-07 0 2.909151207573799e-07 0 2.909251207573799e-07 0.00021 2.909351207573799e-07 0 2.909541305400681e-07 0 2.909641305400681e-07 0.00021 2.909741305400681e-07 0 2.9106280463551206e-07 0 2.9107280463551207e-07 0.00021 2.910828046355121e-07 0 2.9114765010733613e-07 0 2.9115765010733614e-07 0.00021 2.9116765010733615e-07 0 2.9122194572789305e-07 0 2.9123194572789306e-07 0.00021 2.9124194572789307e-07 0 2.9124194572789307e-07 0 2.912519457278931e-07 0.00021 2.912619457278931e-07 0 2.912714640214287e-07 0 2.9128146402142873e-07 0.00021 2.9129146402142874e-07 0 2.9136947537080624e-07 0 2.9137947537080626e-07 0.00021 2.9138947537080627e-07 0 2.9152565030822434e-07 0 2.9153565030822436e-07 0.00021 2.9154565030822437e-07 0 2.915638440460159e-07 0 2.915738440460159e-07 0.00021 2.915838440460159e-07 0 2.917562985096107e-07 0 2.917662985096107e-07 0.00021 2.917762985096107e-07 0 2.918438065804666e-07 0 2.918538065804666e-07 0.00021 2.918638065804666e-07 0 2.921473169075053e-07 0 2.921573169075053e-07 0.00021 2.9216731690750534e-07 0 2.9229362233300845e-07 0 2.9230362233300846e-07 0.00021 2.9231362233300847e-07 0 2.9231362233300847e-07 0 2.923236223330085e-07 0.00021 2.923336223330085e-07 0 2.9240529609013346e-07 0 2.9241529609013347e-07 0.00021 2.924252960901335e-07 0 2.9257171714680665e-07 0 2.9258171714680666e-07 0.00021 2.925917171468067e-07 0 2.926812971066506e-07 0 2.926912971066506e-07 0.00021 2.927012971066506e-07 0 2.927012971066506e-07 0 2.9271129710665063e-07 0.00021 2.9272129710665064e-07 0 2.9272129710665064e-07 0 2.9273129710665065e-07 0.00021 2.9274129710665067e-07 0 2.9274129710665067e-07 0 2.927512971066507e-07 0.00021 2.927612971066507e-07 0 2.9289600314385657e-07 0 2.929060031438566e-07 0.00021 2.929160031438566e-07 0 2.929160031438566e-07 0 2.929260031438566e-07 0.00021 2.929360031438566e-07 0 2.929360031438566e-07 0 2.9294600314385663e-07 0.00021 2.9295600314385664e-07 0 2.9296801213223306e-07 0 2.929780121322331e-07 0.00021 2.929880121322331e-07 0 2.9329414939618046e-07 0 2.9330414939618047e-07 0.00021 2.933141493961805e-07 0 2.933141493961805e-07 0 2.933241493961805e-07 0.00021 2.933341493961805e-07 0 2.9340688737503153e-07 0 2.9341688737503154e-07 0.00021 2.9342688737503155e-07 0 2.935521165836228e-07 0 2.935621165836228e-07 0.00021 2.935721165836228e-07 0 2.9357385548641614e-07 0 2.9358385548641615e-07 0.00021 2.9359385548641617e-07 0 2.9364641269531674e-07 0 2.9365641269531675e-07 0.00021 2.9366641269531676e-07 0 2.9370422689573477e-07 0 2.937142268957348e-07 0.00021 2.937242268957348e-07 0 2.939484981445715e-07 0 2.939584981445715e-07 0.00021 2.939684981445715e-07 0 2.9397916456088317e-07 0 2.939891645608832e-07 0.00021 2.939991645608832e-07 0 2.940168243932427e-07 0 2.9402682439324274e-07 0.00021 2.9403682439324275e-07 0 2.942360284664718e-07 0 2.942460284664718e-07 0.00021 2.942560284664718e-07 0 2.94373981938712e-07 0 2.94383981938712e-07 0.00021 2.94393981938712e-07 0 2.94393981938712e-07 0 2.94403981938712e-07 0.00021 2.94413981938712e-07 0 2.9456186090106373e-07 0 2.9457186090106374e-07 0.00021 2.9458186090106375e-07 0 2.9458186090106375e-07 0 2.9459186090106377e-07 0.00021 2.946018609010638e-07 0 2.947792564440826e-07 0 2.947892564440826e-07 0.00021 2.947992564440826e-07 0 2.947992564440826e-07 0 2.948092564440826e-07 0.00021 2.9481925644408264e-07 0 2.9481925644408264e-07 0 2.9482925644408265e-07 0.00021 2.9483925644408266e-07 0 2.9483925644408266e-07 0 2.9484925644408267e-07 0.00021 2.948592564440827e-07 0 2.948592564440827e-07 0 2.948692564440827e-07 0.00021 2.948792564440827e-07 0 2.948949899603052e-07 0 2.949049899603052e-07 0.00021 2.949149899603052e-07 0 2.949415966731545e-07 0 2.949515966731545e-07 0.00021 2.949615966731545e-07 0 2.949841012328464e-07 0 2.949941012328464e-07 0.00021 2.9500410123284643e-07 0 2.950479148283205e-07 0 2.950579148283205e-07 0.00021 2.950679148283205e-07 0 2.9523286611749326e-07 0 2.9524286611749327e-07 0.00021 2.952528661174933e-07 0 2.9525333661300873e-07 0 2.9526333661300874e-07 0.00021 2.9527333661300876e-07 0 2.9534979800915004e-07 0 2.9535979800915005e-07 0.00021 2.9536979800915006e-07 0 2.954093971672099e-07 0 2.9541939716720993e-07 0.00021 2.9542939716720994e-07 0 2.9542939716720994e-07 0 2.9543939716720996e-07 0.00021 2.9544939716720997e-07 0 2.9551226224959756e-07 0 2.9552226224959757e-07 0.00021 2.955322622495976e-07 0 2.956085642984975e-07 0 2.956185642984975e-07 0.00021 2.956285642984975e-07 0 2.956407512802894e-07 0 2.956507512802894e-07 0.00021 2.956607512802894e-07 0 2.9571189895720964e-07 0 2.9572189895720965e-07 0.00021 2.9573189895720966e-07 0 2.957580404997378e-07 0 2.9576804049973784e-07 0.00021 2.9577804049973785e-07 0 2.958321627118458e-07 0 2.958421627118458e-07 0.00021 2.958521627118458e-07 0 2.959020493510765e-07 0 2.959120493510765e-07 0.00021 2.959220493510765e-07 0 2.9592383584387977e-07 0 2.959338358438798e-07 0.00021 2.959438358438798e-07 0 2.9602839923981366e-07 0 2.960383992398137e-07 0.00021 2.960483992398137e-07 0 2.960483992398137e-07 0 2.960583992398137e-07 0.00021 2.960683992398137e-07 0 2.9609605476040624e-07 0 2.9610605476040625e-07 0.00021 2.9611605476040627e-07 0 2.962748939961255e-07 0 2.9628489399612553e-07 0.00021 2.9629489399612555e-07 0 2.9642537899579663e-07 0 2.9643537899579664e-07 0.00021 2.9644537899579666e-07 0 2.9644537899579666e-07 0 2.9645537899579667e-07 0.00021 2.964653789957967e-07 0 2.9659839434344194e-07 0 2.9660839434344195e-07 0.00021 2.9661839434344197e-07 0 2.966495253920357e-07 0 2.9665952539203573e-07 0.00021 2.9666952539203575e-07 0 2.9668825745109674e-07 0 2.9669825745109675e-07 0.00021 2.9670825745109676e-07 0 2.9670825745109676e-07 0 2.9671825745109677e-07 0.00021 2.967282574510968e-07 0 2.967282574510968e-07 0 2.967382574510968e-07 0.00021 2.967482574510968e-07 0 2.967490658148357e-07 0 2.967590658148357e-07 0.00021 2.967690658148357e-07 0 2.970145604653595e-07 0 2.970245604653595e-07 0.00021 2.970345604653595e-07 0 2.970345604653595e-07 0 2.970445604653595e-07 0.00021 2.9705456046535953e-07 0 2.9706347812544087e-07 0 2.970734781254409e-07 0.00021 2.970834781254409e-07 0 2.970834781254409e-07 0 2.970934781254409e-07 0.00021 2.971034781254409e-07 0 2.9717048046086364e-07 0 2.9718048046086365e-07 0.00021 2.9719048046086366e-07 0 2.9719481444647696e-07 0 2.97204814446477e-07 0.00021 2.97214814446477e-07 0 2.9725826503284975e-07 0 2.9726826503284976e-07 0.00021 2.9727826503284977e-07 0 2.9727826503284977e-07 0 2.972882650328498e-07 0.00021 2.972982650328498e-07 0 2.972982650328498e-07 0 2.973082650328498e-07 0.00021 2.973182650328498e-07 0 2.974214233831974e-07 0 2.974314233831974e-07 0.00021 2.974414233831974e-07 0 2.974628541793429e-07 0 2.9747285417934293e-07 0.00021 2.9748285417934294e-07 0 2.9748285417934294e-07 0 2.9749285417934295e-07 0.00021 2.9750285417934296e-07 0 2.975040794320204e-07 0 2.975140794320204e-07 0.00021 2.975240794320204e-07 0 2.975397756273019e-07 0 2.975497756273019e-07 0.00021 2.975597756273019e-07 0 2.978688703581934e-07 0 2.978788703581934e-07 0.00021 2.978888703581934e-07 0 2.978888703581934e-07 0 2.978988703581934e-07 0.00021 2.9790887035819343e-07 0 2.9790887035819343e-07 0 2.9791887035819344e-07 0.00021 2.9792887035819345e-07 0 2.979907862151019e-07 0 2.980007862151019e-07 0.00021 2.980107862151019e-07 0 2.981585593687554e-07 0 2.981685593687554e-07 0.00021 2.981785593687554e-07 0 2.9830387363178577e-07 0 2.983138736317858e-07 0.00021 2.983238736317858e-07 0 2.983705035615323e-07 0 2.983805035615323e-07 0.00021 2.983905035615323e-07 0 2.98397051740365e-07 0 2.98407051740365e-07 0.00021 2.98417051740365e-07 0 2.9843415001425374e-07 0 2.9844415001425375e-07 0.00021 2.9845415001425376e-07 0 2.9845415001425376e-07 0 2.9846415001425377e-07 0.00021 2.984741500142538e-07 0 2.9852521360325984e-07 0 2.9853521360325985e-07 0.00021 2.9854521360325987e-07 0 2.988118464873923e-07 0 2.9882184648739234e-07 0.00021 2.9883184648739235e-07 0 2.9902152442114103e-07 0 2.9903152442114104e-07 0.00021 2.9904152442114105e-07 0 2.99158094633743e-07 0 2.9916809463374303e-07 0.00021 2.9917809463374304e-07 0 2.992996613433512e-07 0 2.993096613433512e-07 0.00021 2.993196613433512e-07 0 2.9946795971306074e-07 0 2.9947795971306075e-07 0.00021 2.9948795971306076e-07 0 2.9948795971306076e-07 0 2.9949795971306077e-07 0.00021 2.995079597130608e-07 0 2.9959461774649884e-07 0 2.9960461774649885e-07 0.00021 2.9961461774649886e-07 0 2.997349525932976e-07 0 2.9974495259329764e-07 0.00021 2.9975495259329765e-07 0 2.9982437710507374e-07 0 2.9983437710507375e-07 0.00021 2.9984437710507376e-07 0 3.001176990478792e-07 0 3.001276990478792e-07 0.00021 3.0013769904787923e-07 0 3.002243227252292e-07 0 3.0023432272522923e-07 0.00021 3.0024432272522924e-07 0 3.0024432272522924e-07 0 3.0025432272522925e-07 0.00021 3.0026432272522926e-07 0 3.0026432272522926e-07 0 3.002743227252293e-07 0.00021 3.002843227252293e-07 0 3.0033871856993587e-07 0 3.003487185699359e-07 0.00021 3.003587185699359e-07 0 3.003587185699359e-07 0 3.003687185699359e-07 0.00021 3.003787185699359e-07 0 3.0037989664866555e-07 0 3.0038989664866556e-07 0.00021 3.0039989664866557e-07 0 3.0039989664866557e-07 0 3.004098966486656e-07 0.00021 3.004198966486656e-07 0 3.005547317820081e-07 0 3.0056473178200813e-07 0.00021 3.0057473178200814e-07 0 3.0057473178200814e-07 0 3.0058473178200815e-07 0.00021 3.0059473178200816e-07 0 3.0095061020270175e-07 0 3.0096061020270177e-07 0.00021 3.009706102027018e-07 0 3.009706102027018e-07 0 3.009806102027018e-07 0.00021 3.009906102027018e-07 0 3.01047505054603e-07 0 3.01057505054603e-07 0.00021 3.01067505054603e-07 0 3.010829789203357e-07 0 3.010929789203357e-07 0.00021 3.0110297892033573e-07 0 3.011766417657759e-07 0 3.011866417657759e-07 0.00021 3.0119664176577593e-07 0 3.012652831793469e-07 0 3.012752831793469e-07 0.00021 3.012852831793469e-07 0 3.012852831793469e-07 0 3.012952831793469e-07 0.00021 3.013052831793469e-07 0 3.013130974291717e-07 0 3.013230974291717e-07 0.00021 3.013330974291717e-07 0 3.014053082682098e-07 0 3.014153082682098e-07 0.00021 3.014253082682098e-07 0 3.0159163911625337e-07 0 3.016016391162534e-07 0.00021 3.016116391162534e-07 0 3.01660498578956e-07 0 3.01670498578956e-07 0.00021 3.01680498578956e-07 0 3.0175429305826816e-07 0 3.0176429305826817e-07 0.00021 3.017742930582682e-07 0 3.0199727531985324e-07 0 3.0200727531985325e-07 0.00021 3.0201727531985326e-07 0 3.0201727531985326e-07 0 3.0202727531985327e-07 0.00021 3.020372753198533e-07 0 3.0212875216765306e-07 0 3.021387521676531e-07 0.00021 3.021487521676531e-07 0 3.022909757868963e-07 0 3.023009757868963e-07 0.00021 3.023109757868963e-07 0 3.023109757868963e-07 0 3.023209757868963e-07 0.00021 3.0233097578689633e-07 0 3.0236832137913123e-07 0 3.0237832137913124e-07 0.00021 3.0238832137913125e-07 0 3.0255254174867683e-07 0 3.0256254174867684e-07 0.00021 3.0257254174867685e-07 0 3.027499439390623e-07 0 3.0275994393906233e-07 0.00021 3.0276994393906234e-07 0 3.0276994393906234e-07 0 3.0277994393906236e-07 0.00021 3.0278994393906237e-07 0 3.0279456680893067e-07 0 3.028045668089307e-07 0.00021 3.028145668089307e-07 0 3.028493195393311e-07 0 3.028593195393311e-07 0.00021 3.028693195393311e-07 0 3.0293291638795773e-07 0 3.0294291638795774e-07 0.00021 3.0295291638795775e-07 0 3.0304266444895803e-07 0 3.0305266444895804e-07 0.00021 3.0306266444895805e-07 0 3.0306266444895805e-07 0 3.0307266444895806e-07 0.00021 3.030826644489581e-07 0 3.0312521865902404e-07 0 3.0313521865902405e-07 0.00021 3.0314521865902406e-07 0 3.031569637921066e-07 0 3.031669637921066e-07 0.00021 3.031769637921066e-07 0 3.031769637921066e-07 0 3.031869637921066e-07 0.00021 3.0319696379210663e-07 0 3.032014038602303e-07 0 3.0321140386023034e-07 0.00021 3.0322140386023035e-07 0 3.032316422225188e-07 0 3.032416422225188e-07 0.00021 3.0325164222251883e-07 0 3.0331630527187157e-07 0 3.033263052718716e-07 0.00021 3.033363052718716e-07 0 3.0341977729771094e-07 0 3.0342977729771095e-07 0.00021 3.0343977729771097e-07 0 3.036529097509591e-07 0 3.036629097509591e-07 0.00021 3.036729097509591e-07 0 3.037229942092171e-07 0 3.0373299420921713e-07 0.00021 3.0374299420921714e-07 0 3.039524226981166e-07 0 3.039624226981166e-07 0.00021 3.039724226981166e-07 0 3.0397897106636633e-07 0 3.0398897106636634e-07 0.00021 3.0399897106636635e-07 0 3.0407675318810016e-07 0 3.040867531881002e-07 0.00021 3.040967531881002e-07 0 3.0415853924924075e-07 0 3.0416853924924077e-07 0.00021 3.041785392492408e-07 0 3.042036955965752e-07 0 3.042136955965752e-07 0.00021 3.042236955965752e-07 0 3.042236955965752e-07 0 3.0423369559657523e-07 0.00021 3.0424369559657524e-07 0 3.043776340293425e-07 0 3.043876340293425e-07 0.00021 3.0439763402934254e-07 0 3.0442188085034766e-07 0 3.044318808503477e-07 0.00021 3.044418808503477e-07 0 3.044418808503477e-07 0 3.044518808503477e-07 0.00021 3.044618808503477e-07 0 3.044618808503477e-07 0 3.044718808503477e-07 0.00021 3.0448188085034773e-07 0 3.0448188085034773e-07 0 3.0449188085034774e-07 0.00021 3.0450188085034776e-07 0 3.0450188085034776e-07 0 3.0451188085034777e-07 0.00021 3.045218808503478e-07 0 3.045218808503478e-07 0 3.045318808503478e-07 0.00021 3.045418808503478e-07 0 3.0463895521263256e-07 0 3.0464895521263257e-07 0.00021 3.046589552126326e-07 0 3.0486674275411215e-07 0 3.0487674275411216e-07 0.00021 3.048867427541122e-07 0 3.048867427541122e-07 0 3.048967427541122e-07 0.00021 3.049067427541122e-07 0 3.0493411299105137e-07 0 3.049441129910514e-07 0.00021 3.049541129910514e-07 0 3.050239296146123e-07 0 3.0503392961461233e-07 0.00021 3.0504392961461234e-07 0 3.0527113215637415e-07 0 3.0528113215637416e-07 0.00021 3.0529113215637417e-07 0 3.0529113215637417e-07 0 3.053011321563742e-07 0.00021 3.053111321563742e-07 0 3.053111321563742e-07 0 3.053211321563742e-07 0.00021 3.053311321563742e-07 0 3.0545723481295015e-07 0 3.0546723481295016e-07 0.00021 3.0547723481295017e-07 0 3.055409099537154e-07 0 3.055509099537154e-07 0.00021 3.0556090995371543e-07 0 3.0561879889815746e-07 0 3.0562879889815747e-07 0.00021 3.056387988981575e-07 0 3.056387988981575e-07 0 3.056487988981575e-07 0.00021 3.056587988981575e-07 0 3.056587988981575e-07 0 3.056687988981575e-07 0.00021 3.0567879889815753e-07 0 3.057415246485544e-07 0 3.057515246485544e-07 0.00021 3.057615246485544e-07 0 3.057615246485544e-07 0 3.0577152464855443e-07 0.00021 3.0578152464855444e-07 0 3.058622513339586e-07 0 3.058722513339586e-07 0.00021 3.058822513339586e-07 0 3.0593908571237855e-07 0 3.0594908571237856e-07 0.00021 3.0595908571237857e-07 0 3.061528027867206e-07 0 3.0616280278672064e-07 0.00021 3.0617280278672065e-07 0 3.0617280278672065e-07 0 3.0618280278672066e-07 0.00021 3.0619280278672067e-07 0 3.0619280278672067e-07 0 3.062028027867207e-07 0.00021 3.062128027867207e-07 0 3.063097877458567e-07 0 3.063197877458567e-07 0.00021 3.063297877458567e-07 0 3.064758457668159e-07 0 3.064858457668159e-07 0.00021 3.064958457668159e-07 0 3.065300404169703e-07 0 3.065400404169703e-07 0.00021 3.0655004041697033e-07 0 3.0655004041697033e-07 0 3.0656004041697034e-07 0.00021 3.0657004041697035e-07 0 3.0657004041697035e-07 0 3.0658004041697036e-07 0.00021 3.0659004041697037e-07 0 3.066446964934756e-07 0 3.066546964934756e-07 0.00021 3.0666469649347563e-07 0 3.0673985626759244e-07 0 3.0674985626759245e-07 0.00021 3.0675985626759246e-07 0 3.0675985626759246e-07 0 3.0676985626759247e-07 0.00021 3.067798562675925e-07 0 3.067798562675925e-07 0 3.067898562675925e-07 0.00021 3.067998562675925e-07 0 3.0699680271760915e-07 0 3.0700680271760916e-07 0.00021 3.0701680271760917e-07 0 3.070238358454841e-07 0 3.070338358454841e-07 0.00021 3.070438358454841e-07 0 3.070581535256841e-07 0 3.070681535256841e-07 0.00021 3.070781535256841e-07 0 3.071875124917002e-07 0 3.071975124917002e-07 0.00021 3.0720751249170023e-07 0 3.0720751249170023e-07 0 3.0721751249170024e-07 0.00021 3.0722751249170025e-07 0 3.073078718870827e-07 0 3.073178718870827e-07 0.00021 3.073278718870827e-07 0 3.073719203659848e-07 0 3.073819203659848e-07 0.00021 3.073919203659848e-07 0 3.074719872886784e-07 0 3.074819872886784e-07 0.00021 3.0749198728867843e-07 0 3.076102379740586e-07 0 3.076202379740586e-07 0.00021 3.0763023797405864e-07 0 3.0764252023976877e-07 0 3.076525202397688e-07 0.00021 3.076625202397688e-07 0 3.077197992576304e-07 0 3.077297992576304e-07 0.00021 3.077397992576304e-07 0 3.0794816199956055e-07 0 3.0795816199956056e-07 0.00021 3.079681619995606e-07 0 3.079795090637417e-07 0 3.0798950906374173e-07 0.00021 3.0799950906374174e-07 0 3.085241712345553e-07 0 3.085341712345553e-07 0.00021 3.085441712345553e-07 0 3.085441712345553e-07 0 3.085541712345553e-07 0.00021 3.0856417123455533e-07 0 3.0875127543328745e-07 0 3.0876127543328746e-07 0.00021 3.0877127543328747e-07 0 3.0877127543328747e-07 0 3.087812754332875e-07 0.00021 3.087912754332875e-07 0 3.0913822365046777e-07 0 3.091482236504678e-07 0.00021 3.091582236504678e-07 0 3.092127828205939e-07 0 3.092227828205939e-07 0.00021 3.0923278282059393e-07 0 3.0924882381608846e-07 0 3.092588238160885e-07 0.00021 3.092688238160885e-07 0 3.092688238160885e-07 0 3.092788238160885e-07 0.00021 3.092888238160885e-07 0 3.092888238160885e-07 0 3.092988238160885e-07 0.00021 3.0930882381608853e-07 0 3.0930882381608853e-07 0 3.0931882381608854e-07 0.00021 3.0932882381608855e-07 0 3.0932882381608855e-07 0 3.0933882381608857e-07 0.00021 3.093488238160886e-07 0 3.093488238160886e-07 0 3.093588238160886e-07 0.00021 3.093688238160886e-07 0 3.093688238160886e-07 0 3.093788238160886e-07 0.00021 3.093888238160886e-07 0 3.0957227951357545e-07 0 3.0958227951357546e-07 0.00021 3.0959227951357547e-07 0 3.0964820884497935e-07 0 3.0965820884497936e-07 0.00021 3.0966820884497937e-07 0 3.0966820884497937e-07 0 3.096782088449794e-07 0.00021 3.096882088449794e-07 0 3.097096152383746e-07 0 3.0971961523837464e-07 0.00021 3.0972961523837465e-07 0 3.098087123517641e-07 0 3.098187123517641e-07 0.00021 3.098287123517641e-07 0 3.099240350204302e-07 0 3.099340350204302e-07 0.00021 3.0994403502043023e-07 0 3.099584051771689e-07 0 3.099684051771689e-07 0.00021 3.099784051771689e-07 0 3.1007307224985455e-07 0 3.1008307224985456e-07 0.00021 3.1009307224985457e-07 0 3.101388062962342e-07 0 3.1014880629623423e-07 0.00021 3.1015880629623424e-07 0 3.103167557721141e-07 0 3.1032675577211414e-07 0.00021 3.1033675577211415e-07 0 3.103600026939769e-07 0 3.103700026939769e-07 0.00021 3.103800026939769e-07 0 3.1057122920420346e-07 0 3.105812292042035e-07 0.00021 3.105912292042035e-07 0 3.10617786386516e-07 0 3.10627786386516e-07 0.00021 3.10637786386516e-07 0 3.107990001888222e-07 0 3.108090001888222e-07 0.00021 3.108190001888222e-07 0 3.1094013527449735e-07 0 3.1095013527449736e-07 0.00021 3.1096013527449737e-07 0 3.110355415121571e-07 0 3.110455415121571e-07 0.00021 3.110555415121571e-07 0 3.110555415121571e-07 0 3.110655415121571e-07 0.00021 3.110755415121571e-07 0 3.110755415121571e-07 0 3.1108554151215713e-07 0.00021 3.1109554151215715e-07 0 3.1109554151215715e-07 0 3.1110554151215716e-07 0.00021 3.1111554151215717e-07 0 3.112096201721014e-07 0 3.112196201721014e-07 0.00021 3.1122962017210144e-07 0 3.11436112787958e-07 0 3.11446112787958e-07 0.00021 3.11456112787958e-07 0 3.115360583568488e-07 0 3.115460583568488e-07 0.00021 3.115560583568488e-07 0 3.1155952769447363e-07 0 3.1156952769447364e-07 0.00021 3.1157952769447365e-07 0 3.116078924948648e-07 0 3.116178924948648e-07 0.00021 3.1162789249486483e-07 0 3.117184842147536e-07 0 3.117284842147536e-07 0.00021 3.1173848421475363e-07 0 3.1176198339657206e-07 0 3.117719833965721e-07 0.00021 3.117819833965721e-07 0 3.117827431655222e-07 0 3.117927431655222e-07 0.00021 3.118027431655222e-07 0 3.118099814139978e-07 0 3.118199814139978e-07 0.00021 3.118299814139978e-07 0 3.12034120636896e-07 0 3.1204412063689603e-07 0.00021 3.1205412063689605e-07 0 3.1217626549003983e-07 0 3.1218626549003984e-07 0.00021 3.1219626549003985e-07 0 3.1232830078922445e-07 0 3.1233830078922446e-07 0.00021 3.1234830078922447e-07 0 3.1235921811212386e-07 0 3.123692181121239e-07 0.00021 3.123792181121239e-07 0 3.1257006903643505e-07 0 3.1258006903643507e-07 0.00021 3.125900690364351e-07 0 3.1263357920012077e-07 0 3.126435792001208e-07 0.00021 3.126535792001208e-07 0 3.1269174486171775e-07 0 3.1270174486171776e-07 0.00021 3.1271174486171777e-07 0 3.1271803408920874e-07 0 3.1272803408920875e-07 0.00021 3.1273803408920876e-07 0 3.1273803408920876e-07 0 3.127480340892088e-07 0.00021 3.127580340892088e-07 0 3.128442443537888e-07 0 3.128542443537888e-07 0.00021 3.1286424435378883e-07 0 3.128966490527157e-07 0 3.129066490527157e-07 0.00021 3.129166490527157e-07 0 3.129166490527157e-07 0 3.1292664905271573e-07 0.00021 3.1293664905271575e-07 0 3.1314581404740137e-07 0 3.131558140474014e-07 0.00021 3.131658140474014e-07 0 3.1318766708839797e-07 0 3.13197667088398e-07 0.00021 3.13207667088398e-07 0 3.132303527603083e-07 0 3.132403527603083e-07 0.00021 3.132503527603083e-07 0 3.132503527603083e-07 0 3.132603527603083e-07 0.00021 3.132703527603083e-07 0 3.1329557677165376e-07 0 3.133055767716538e-07 0.00021 3.133155767716538e-07 0 3.1340851514832496e-07 0 3.1341851514832497e-07 0.00021 3.13428515148325e-07 0 3.1350039586131233e-07 0 3.1351039586131234e-07 0.00021 3.1352039586131236e-07 0 3.1354433302096135e-07 0 3.1355433302096136e-07 0.00021 3.1356433302096137e-07 0 3.1356433302096137e-07 0 3.135743330209614e-07 0.00021 3.135843330209614e-07 0 3.136169479295899e-07 0 3.136269479295899e-07 0.00021 3.136369479295899e-07 0 3.136369479295899e-07 0 3.136469479295899e-07 0.00021 3.136569479295899e-07 0 3.1382323827279e-07 0 3.1383323827279e-07 0.00021 3.1384323827279003e-07 0 3.1386911765177016e-07 0 3.138791176517702e-07 0.00021 3.138891176517702e-07 0 3.139734129479633e-07 0 3.1398341294796333e-07 0.00021 3.1399341294796334e-07 0 3.1399341294796334e-07 0 3.1400341294796335e-07 0.00021 3.1401341294796336e-07 0 3.1401341294796336e-07 0 3.1402341294796337e-07 0.00021 3.140334129479634e-07 0 3.1414327982220193e-07 0 3.1415327982220194e-07 0.00021 3.1416327982220195e-07 0 3.141662846688985e-07 0 3.141762846688985e-07 0.00021 3.1418628466889853e-07 0 3.143025190572538e-07 0 3.143125190572538e-07 0.00021 3.143225190572538e-07 0 3.143225190572538e-07 0 3.1433251905725383e-07 0.00021 3.1434251905725384e-07 0 3.1434251905725384e-07 0 3.1435251905725385e-07 0.00021 3.1436251905725386e-07 0 3.144143935510293e-07 0 3.144243935510293e-07 0.00021 3.1443439355102933e-07 0 3.145669734445626e-07 0 3.1457697344456263e-07 0.00021 3.1458697344456264e-07 0 3.148278074813052e-07 0 3.148378074813052e-07 0.00021 3.148478074813052e-07 0 3.150841279223901e-07 0 3.150941279223901e-07 0.00021 3.1510412792239013e-07 0 3.1510412792239013e-07 0 3.1511412792239014e-07 0.00021 3.1512412792239015e-07 0 3.1512412792239015e-07 0 3.1513412792239017e-07 0.00021 3.151441279223902e-07 0 3.153425777761128e-07 0 3.153525777761128e-07 0.00021 3.153625777761128e-07 0 3.153832627773575e-07 0 3.153932627773575e-07 0.00021 3.154032627773575e-07 0 3.1546489656065743e-07 0 3.1547489656065744e-07 0.00021 3.1548489656065745e-07 0 3.1562290494846585e-07 0 3.1563290494846586e-07 0.00021 3.1564290494846587e-07 0 3.16117049368479e-07 0 3.1612704936847903e-07 0.00021 3.1613704936847904e-07 0 3.1619579280783647e-07 0 3.162057928078365e-07 0.00021 3.162157928078365e-07 0 3.162157928078365e-07 0 3.162257928078365e-07 0.00021 3.162357928078365e-07 0 3.162357928078365e-07 0 3.162457928078365e-07 0.00021 3.1625579280783653e-07 0 3.1625579280783653e-07 0 3.1626579280783654e-07 0.00021 3.1627579280783656e-07 0 3.163520292364745e-07 0 3.163620292364745e-07 0.00021 3.163720292364745e-07 0 3.1637679249416383e-07 0 3.1638679249416384e-07 0.00021 3.1639679249416385e-07 0 3.165419783226317e-07 0 3.165519783226317e-07 0.00021 3.165619783226317e-07 0 3.1659474489349e-07 0 3.1660474489349e-07 0.00021 3.1661474489349004e-07 0 3.167239205529909e-07 0 3.167339205529909e-07 0.00021 3.167439205529909e-07 0 3.1675696400814055e-07 0 3.1676696400814056e-07 0.00021 3.167769640081406e-07 0 3.168340947002424e-07 0 3.168440947002424e-07 0.00021 3.168540947002424e-07 0 3.168540947002424e-07 0 3.168640947002424e-07 0.00021 3.1687409470024243e-07 0 3.1711858789236555e-07 0 3.1712858789236556e-07 0.00021 3.1713858789236557e-07 0 3.172266383905532e-07 0 3.172366383905532e-07 0.00021 3.172466383905532e-07 0 3.172742163896984e-07 0 3.172842163896984e-07 0.00021 3.172942163896984e-07 0 3.1733675046820474e-07 0 3.1734675046820475e-07 0.00021 3.1735675046820476e-07 0 3.174826174333789e-07 0 3.174926174333789e-07 0.00021 3.175026174333789e-07 0 3.175026174333789e-07 0 3.175126174333789e-07 0.00021 3.175226174333789e-07 0 3.175226174333789e-07 0 3.1753261743337893e-07 0.00021 3.1754261743337894e-07 0 3.1764060411829244e-07 0 3.1765060411829245e-07 0.00021 3.1766060411829246e-07 0 3.1767373342371764e-07 0 3.1768373342371766e-07 0.00021 3.1769373342371767e-07 0 3.177038576024684e-07 0 3.177138576024684e-07 0.00021 3.177238576024684e-07 0 3.1776631107718136e-07 0 3.1777631107718137e-07 0.00021 3.177863110771814e-07 0 3.1809256398124504e-07 0 3.1810256398124506e-07 0.00021 3.1811256398124507e-07 0 3.1812521725972827e-07 0 3.181352172597283e-07 0.00021 3.181452172597283e-07 0 3.181452172597283e-07 0 3.181552172597283e-07 0.00021 3.181652172597283e-07 0 3.1828476790724703e-07 0 3.1829476790724704e-07 0.00021 3.1830476790724706e-07 0 3.1832747587956385e-07 0 3.1833747587956386e-07 0.00021 3.1834747587956387e-07 0 3.183948344352061e-07 0 3.184048344352061e-07 0.00021 3.1841483443520613e-07 0 3.184413631278697e-07 0 3.184513631278697e-07 0.00021 3.184613631278697e-07 0 3.1849327694461746e-07 0 3.1850327694461747e-07 0.00021 3.185132769446175e-07 0 3.185438494130473e-07 0 3.185538494130473e-07 0.00021 3.185638494130473e-07 0 3.185813258180624e-07 0 3.185913258180624e-07 0.00021 3.186013258180624e-07 0 3.186013258180624e-07 0 3.186113258180624e-07 0.00021 3.1862132581806243e-07 0 3.1862132581806243e-07 0 3.1863132581806244e-07 0.00021 3.1864132581806245e-07 0 3.1864132581806245e-07 0 3.1865132581806246e-07 0.00021 3.1866132581806247e-07 0 3.1866132581806247e-07 0 3.186713258180625e-07 0.00021 3.186813258180625e-07 0 3.1871905279405965e-07 0 3.1872905279405966e-07 0.00021 3.187390527940597e-07 0 3.188964132667912e-07 0 3.1890641326679124e-07 0.00021 3.1891641326679125e-07 0 3.190450903767199e-07 0 3.190550903767199e-07 0.00021 3.190650903767199e-07 0 3.192150459885901e-07 0 3.192250459885901e-07 0.00021 3.192350459885901e-07 0 3.1932326102561417e-07 0 3.193332610256142e-07 0.00021 3.193432610256142e-07 0 3.1956842463181257e-07 0 3.195784246318126e-07 0.00021 3.195884246318126e-07 0 3.1960419907619137e-07 0 3.196141990761914e-07 0.00021 3.196241990761914e-07 0 3.1965974582460173e-07 0 3.1966974582460175e-07 0.00021 3.1967974582460176e-07 0 3.1968829942303673e-07 0 3.1969829942303674e-07 0.00021 3.1970829942303675e-07 0 3.1972646982690376e-07 0 3.1973646982690377e-07 0.00021 3.197464698269038e-07 0 3.1975354154376865e-07 0 3.1976354154376866e-07 0.00021 3.197735415437687e-07 0 3.198477297210089e-07 0 3.198577297210089e-07 0.00021 3.1986772972100894e-07 0 3.198768414443079e-07 0 3.198868414443079e-07 0.00021 3.1989684144430793e-07 0 3.1989684144430793e-07 0 3.1990684144430794e-07 0.00021 3.1991684144430795e-07 0 3.201616465161981e-07 0 3.201716465161981e-07 0.00021 3.201816465161981e-07 0 3.202072102853104e-07 0 3.2021721028531043e-07 0.00021 3.2022721028531044e-07 0 3.202491753011625e-07 0 3.202591753011625e-07 0.00021 3.2026917530116253e-07 0 3.2026917530116253e-07 0 3.2027917530116254e-07 0.00021 3.2028917530116255e-07 0 3.2028917530116255e-07 0 3.2029917530116257e-07 0.00021 3.203091753011626e-07 0 3.204979075497255e-07 0 3.2050790754972553e-07 0.00021 3.2051790754972554e-07 0 3.2055490980582206e-07 0 3.2056490980582207e-07 0.00021 3.205749098058221e-07 0 3.20611082447197e-07 0 3.20621082447197e-07 0.00021 3.20631082447197e-07 0 3.206684718780202e-07 0 3.206784718780202e-07 0.00021 3.206884718780202e-07 0 3.2073236000601565e-07 0 3.2074236000601566e-07 0.00021 3.207523600060157e-07 0 3.20775536657264e-07 0 3.20785536657264e-07 0.00021 3.20795536657264e-07 0 3.208217166067088e-07 0 3.208317166067088e-07 0.00021 3.208417166067088e-07 0 3.208417166067088e-07 0 3.2085171660670884e-07 0.00021 3.2086171660670885e-07 0 3.2093064390821483e-07 0 3.2094064390821484e-07 0.00021 3.2095064390821485e-07 0 3.210418265812598e-07 0 3.2105182658125983e-07 0.00021 3.2106182658125984e-07 0 3.2106858757867016e-07 0 3.2107858757867017e-07 0.00021 3.210885875786702e-07 0 3.2114638566698884e-07 0 3.2115638566698886e-07 0.00021 3.2116638566698887e-07 0 3.2117959284773214e-07 0 3.2118959284773215e-07 0.00021 3.2119959284773217e-07 0 3.2134073553939837e-07 0 3.213507355393984e-07 0.00021 3.213607355393984e-07 0 3.213607355393984e-07 0 3.213707355393984e-07 0.00021 3.213807355393984e-07 0 3.214010300486369e-07 0 3.214110300486369e-07 0.00021 3.214210300486369e-07 0 3.2153447757680094e-07 0 3.2154447757680095e-07 0.00021 3.2155447757680096e-07 0 3.2156098736425313e-07 0 3.2157098736425315e-07 0.00021 3.2158098736425316e-07 0 3.215845486967484e-07 0 3.2159454869674843e-07 0.00021 3.2160454869674845e-07 0 3.2170762471044814e-07 0 3.2171762471044815e-07 0.00021 3.2172762471044816e-07 0 3.2182434534823255e-07 0 3.2183434534823256e-07 0.00021 3.2184434534823257e-07 0 3.2184445459071134e-07 0 3.2185445459071135e-07 0.00021 3.2186445459071136e-07 0 3.219592921408659e-07 0 3.219692921408659e-07 0.00021 3.219792921408659e-07 0 3.219792921408659e-07 0 3.2198929214086593e-07 0.00021 3.2199929214086594e-07 0 3.2206556332590103e-07 0 3.2207556332590104e-07 0.00021 3.2208556332590105e-07 0 3.2208556332590105e-07 0 3.2209556332590107e-07 0.00021 3.221055633259011e-07 0 3.221894890773463e-07 0 3.221994890773463e-07 0.00021 3.222094890773463e-07 0 3.2228193114620537e-07 0 3.222919311462054e-07 0.00021 3.223019311462054e-07 0 3.223019311462054e-07 0 3.223119311462054e-07 0.00021 3.223219311462054e-07 0 3.223734193737593e-07 0 3.223834193737593e-07 0.00021 3.223934193737593e-07 0 3.223934193737593e-07 0 3.224034193737593e-07 0.00021 3.224134193737593e-07 0 3.225558615755754e-07 0 3.2256586157557543e-07 0.00021 3.2257586157557545e-07 0 3.226053967223375e-07 0 3.226153967223375e-07 0.00021 3.226253967223375e-07 0 3.2262648064151953e-07 0 3.2263648064151954e-07 0.00021 3.2264648064151955e-07 0 3.226673020237351e-07 0 3.226773020237351e-07 0.00021 3.2268730202373513e-07 0 3.2268730202373513e-07 0 3.2269730202373514e-07 0.00021 3.2270730202373515e-07 0 3.228995265623402e-07 0 3.229095265623402e-07 0.00021 3.229195265623402e-07 0 3.232071075390201e-07 0 3.232171075390201e-07 0.00021 3.232271075390201e-07 0 3.233190368700607e-07 0 3.233290368700607e-07 0.00021 3.2333903687006073e-07 0 3.2333903687006073e-07 0 3.2334903687006075e-07 0.00021 3.2335903687006076e-07 0 3.2335903687006076e-07 0 3.2336903687006077e-07 0.00021 3.233790368700608e-07 0 3.233992320015797e-07 0 3.234092320015797e-07 0.00021 3.234192320015797e-07 0 3.234192320015797e-07 0 3.234292320015797e-07 0.00021 3.234392320015797e-07 0 3.2356037906825695e-07 0 3.2357037906825696e-07 0.00021 3.23580379068257e-07 0 3.236537444659311e-07 0 3.236637444659311e-07 0.00021 3.2367374446593113e-07 0 3.236974390674812e-07 0 3.237074390674812e-07 0.00021 3.237174390674812e-07 0 3.237174510259236e-07 0 3.237274510259236e-07 0.00021 3.2373745102592363e-07 0 3.2374708004759295e-07 0 3.2375708004759296e-07 0.00021 3.2376708004759297e-07 0 3.2389292737106835e-07 0 3.2390292737106836e-07 0.00021 3.239129273710684e-07 0 3.2396150497945977e-07 0 3.239715049794598e-07 0.00021 3.239815049794598e-07 0 3.239815049794598e-07 0 3.239915049794598e-07 0.00021 3.240015049794598e-07 0 3.240015049794598e-07 0 3.2401150497945983e-07 0.00021 3.2402150497945984e-07 0 3.240427352465643e-07 0 3.240527352465643e-07 0.00021 3.2406273524656433e-07 0 3.240650757165625e-07 0 3.240750757165625e-07 0.00021 3.240850757165625e-07 0 3.2411036321683255e-07 0 3.2412036321683256e-07 0.00021 3.2413036321683257e-07 0 3.2417088836567303e-07 0 3.2418088836567304e-07 0.00021 3.2419088836567306e-07 0 3.2441236745089156e-07 0 3.2442236745089157e-07 0.00021 3.244323674508916e-07 0 3.244885068277629e-07 0 3.244985068277629e-07 0.00021 3.245085068277629e-07 0 3.2454894491058896e-07 0 3.24558944910589e-07 0.00021 3.24568944910589e-07 0 3.2465036888515107e-07 0 3.246603688851511e-07 0.00021 3.246703688851511e-07 0 3.2479834517012675e-07 0 3.2480834517012677e-07 0.00021 3.248183451701268e-07 0 3.2486003015966964e-07 0 3.2487003015966965e-07 0.00021 3.2488003015966967e-07 0 3.2488967701987667e-07 0 3.248996770198767e-07 0.00021 3.249096770198767e-07 0 3.249915526139437e-07 0 3.250015526139437e-07 0.00021 3.250115526139437e-07 0 3.2511477228625794e-07 0 3.2512477228625795e-07 0.00021 3.2513477228625796e-07 0 3.251853287462965e-07 0 3.251953287462965e-07 0.00021 3.252053287462965e-07 0 3.252610081854955e-07 0 3.252710081854955e-07 0.00021 3.252810081854955e-07 0 3.2536278421775347e-07 0 3.253727842177535e-07 0.00021 3.253827842177535e-07 0 3.2544290212739495e-07 0 3.2545290212739496e-07 0.00021 3.2546290212739497e-07 0 3.2546290212739497e-07 0 3.25472902127395e-07 0.00021 3.25482902127395e-07 0 3.255188784893407e-07 0 3.255288784893407e-07 0.00021 3.255388784893407e-07 0 3.255388784893407e-07 0 3.2554887848934073e-07 0.00021 3.2555887848934075e-07 0 3.255829321425044e-07 0 3.255929321425044e-07 0.00021 3.256029321425044e-07 0 3.257743083113813e-07 0 3.2578430831138134e-07 0.00021 3.2579430831138135e-07 0 3.258038484900918e-07 0 3.258138484900918e-07 0.00021 3.258238484900918e-07 0 3.25849991102906e-07 0 3.2585999110290603e-07 0.00021 3.2586999110290605e-07 0 3.2586999110290605e-07 0 3.2587999110290606e-07 0.00021 3.2588999110290607e-07 0 3.2588999110290607e-07 0 3.258999911029061e-07 0.00021 3.259099911029061e-07 0 3.259099911029061e-07 0 3.259199911029061e-07 0.00021 3.259299911029061e-07 0 3.260049889880022e-07 0 3.260149889880022e-07 0.00021 3.260249889880022e-07 0 3.2608778556082606e-07 0 3.2609778556082607e-07 0.00021 3.261077855608261e-07 0 3.2617433625047973e-07 0 3.2618433625047974e-07 0.00021 3.2619433625047976e-07 0 3.263055066209669e-07 0 3.263155066209669e-07 0.00021 3.2632550662096694e-07 0 3.2667007914569954e-07 0 3.2668007914569955e-07 0.00021 3.2669007914569956e-07 0 3.267568405855128e-07 0 3.2676684058551283e-07 0.00021 3.2677684058551284e-07 0 3.2677684058551284e-07 0 3.2678684058551285e-07 0.00021 3.2679684058551286e-07 0 3.2679684058551286e-07 0 3.2680684058551287e-07 0.00021 3.268168405855129e-07 0 3.2682447415961567e-07 0 3.268344741596157e-07 0.00021 3.268444741596157e-07 0 3.269704342857898e-07 0 3.2698043428578984e-07 0.00021 3.2699043428578985e-07 0 3.2713809250699265e-07 0 3.2714809250699266e-07 0.00021 3.2715809250699267e-07 0 3.27222107971692e-07 0 3.27232107971692e-07 0.00021 3.2724210797169203e-07 0 3.272781976300255e-07 0 3.2728819763002553e-07 0.00021 3.2729819763002554e-07 0 3.2729819763002554e-07 0 3.2730819763002555e-07 0.00021 3.2731819763002556e-07 0 3.274213005762859e-07 0 3.274313005762859e-07 0.00021 3.2744130057628594e-07 0 3.2746615869751013e-07 0 3.2747615869751014e-07 0.00021 3.2748615869751015e-07 0 3.2754735821087514e-07 0 3.2755735821087515e-07 0.00021 3.2756735821087516e-07 0 3.2764062201369586e-07 0 3.2765062201369587e-07 0.00021 3.276606220136959e-07 0 3.2772087397233587e-07 0 3.277308739723359e-07 0.00021 3.277408739723359e-07 0 3.2780989178324554e-07 0 3.2781989178324555e-07 0.00021 3.2782989178324556e-07 0 3.2791539269789284e-07 0 3.2792539269789285e-07 0.00021 3.2793539269789286e-07 0 3.2793539269789286e-07 0 3.279453926978929e-07 0.00021 3.279553926978929e-07 0 3.2814310573458674e-07 0 3.2815310573458675e-07 0.00021 3.2816310573458676e-07 0 3.281825312572357e-07 0 3.281925312572357e-07 0.00021 3.282025312572357e-07 0 3.282067657672309e-07 0 3.2821676576723093e-07 0.00021 3.2822676576723094e-07 0 3.2822676576723094e-07 0 3.2823676576723095e-07 0.00021 3.2824676576723096e-07 0 3.285957215582966e-07 0 3.286057215582966e-07 0.00021 3.286157215582966e-07 0 3.286810775835845e-07 0 3.2869107758358453e-07 0.00021 3.2870107758358454e-07 0 3.2885467257703774e-07 0 3.2886467257703776e-07 0.00021 3.2887467257703777e-07 0 3.2909593674428465e-07 0 3.2910593674428466e-07 0.00021 3.291159367442847e-07 0 3.291159367442847e-07 0 3.291259367442847e-07 0.00021 3.291359367442847e-07 0 3.291359367442847e-07 0 3.291459367442847e-07 0.00021 3.291559367442847e-07 0 3.291589105559856e-07 0 3.291689105559856e-07 0.00021 3.291789105559856e-07 0 3.292427399932866e-07 0 3.2925273999328663e-07 0.00021 3.2926273999328664e-07 0 3.293039619927321e-07 0 3.293139619927321e-07 0.00021 3.293239619927321e-07 0 3.294580789716442e-07 0 3.294680789716442e-07 0.00021 3.294780789716442e-07 0 3.2957134943267896e-07 0 3.29581349432679e-07 0.00021 3.29591349432679e-07 0 3.297194238308124e-07 0 3.297294238308124e-07 0.00021 3.2973942383081244e-07 0 3.2973942383081244e-07 0 3.2974942383081245e-07 0.00021 3.2975942383081246e-07 0 3.2975942383081246e-07 0 3.2976942383081247e-07 0.00021 3.297794238308125e-07 0 3.297794238308125e-07 0 3.297894238308125e-07 0.00021 3.297994238308125e-07 0 3.2986233619247926e-07 0 3.2987233619247927e-07 0.00021 3.298823361924793e-07 0 3.2990411652108055e-07 0 3.2991411652108056e-07 0.00021 3.2992411652108057e-07 0 3.2992411652108057e-07 0 3.299341165210806e-07 0.00021 3.299441165210806e-07 0 3.299931196963363e-07 0 3.300031196963363e-07 0.00021 3.300131196963363e-07 0 3.3001330503034204e-07 0 3.3002330503034205e-07 0.00021 3.3003330503034207e-07 0 3.3008919328052307e-07 0 3.300991932805231e-07 0.00021 3.301091932805231e-07 0 3.3013125834530284e-07 0 3.3014125834530286e-07 0.00021 3.3015125834530287e-07 0 3.302086174746827e-07 0 3.3021861747468273e-07 0.00021 3.3022861747468274e-07 0 3.30716902095334e-07 0 3.30726902095334e-07 0.00021 3.3073690209533403e-07 0 3.308277522488719e-07 0 3.308377522488719e-07 0.00021 3.308477522488719e-07 0 3.310061092571353e-07 0 3.310161092571353e-07 0.00021 3.310261092571353e-07 0 3.310261092571353e-07 0 3.310361092571353e-07 0.00021 3.3104610925713534e-07 0 3.3111602198749624e-07 0 3.3112602198749626e-07 0.00021 3.3113602198749627e-07 0 3.311402090351302e-07 0 3.3115020903513023e-07 0.00021 3.3116020903513024e-07 0 3.3121316780315094e-07 0 3.3122316780315095e-07 0.00021 3.3123316780315096e-07 0 3.312411083714302e-07 0 3.312511083714302e-07 0.00021 3.312611083714302e-07 0 3.312631577584353e-07 0 3.312731577584353e-07 0.00021 3.312831577584353e-07 0 3.313129058195128e-07 0 3.3132290581951283e-07 0.00021 3.3133290581951284e-07 0 3.3138189436200164e-07 0 3.3139189436200165e-07 0.00021 3.3140189436200166e-07 0 3.3140189436200166e-07 0 3.314118943620017e-07 0.00021 3.314218943620017e-07 0 3.314734048698052e-07 0 3.3148340486980523e-07 0.00021 3.3149340486980524e-07 0 3.315307214467499e-07 0 3.3154072144674994e-07 0.00021 3.3155072144674995e-07 0 3.3155072144674995e-07 0 3.3156072144674996e-07 0.00021 3.3157072144674997e-07 0 3.3157072144674997e-07 0 3.3158072144675e-07 0.00021 3.3159072144675e-07 0 3.31737237805752e-07 0 3.3174723780575203e-07 0.00021 3.3175723780575204e-07 0 3.3175723780575204e-07 0 3.3176723780575205e-07 0.00021 3.3177723780575206e-07 0 3.3201676710898456e-07 0 3.3202676710898457e-07 0.00021 3.320367671089846e-07 0 3.320631395906758e-07 0 3.320731395906758e-07 0.00021 3.3208313959067583e-07 0 3.3208313959067583e-07 0 3.3209313959067584e-07 0.00021 3.3210313959067585e-07 0 3.3210313959067585e-07 0 3.3211313959067586e-07 0.00021 3.321231395906759e-07 0 3.3224606601314563e-07 0 3.3225606601314564e-07 0.00021 3.3226606601314565e-07 0 3.322899621111333e-07 0 3.322999621111333e-07 0.00021 3.3230996211113333e-07 0 3.3230996211113333e-07 0 3.3231996211113334e-07 0.00021 3.3232996211113335e-07 0 3.3241509364662315e-07 0 3.3242509364662316e-07 0.00021 3.3243509364662317e-07 0 3.3243509364662317e-07 0 3.324450936466232e-07 0.00021 3.324550936466232e-07 0 3.3251680721046146e-07 0 3.3252680721046147e-07 0.00021 3.325368072104615e-07 0 3.325368072104615e-07 0 3.325468072104615e-07 0.00021 3.325568072104615e-07 0 3.3256986062415993e-07 0 3.3257986062415994e-07 0.00021 3.3258986062415995e-07 0 3.3258986062415995e-07 0 3.3259986062415997e-07 0.00021 3.3260986062416e-07 0 3.3266853567428016e-07 0 3.3267853567428017e-07 0.00021 3.326885356742802e-07 0 3.326885356742802e-07 0 3.326985356742802e-07 0.00021 3.327085356742802e-07 0 3.327085356742802e-07 0 3.327185356742802e-07 0.00021 3.3272853567428023e-07 0 3.3272853567428023e-07 0 3.3273853567428024e-07 0.00021 3.3274853567428025e-07 0 3.3295226272684223e-07 0 3.3296226272684224e-07 0.00021 3.3297226272684225e-07 0 3.330998647370749e-07 0 3.331098647370749e-07 0.00021 3.3311986473707493e-07 0 3.3311986473707493e-07 0 3.3312986473707494e-07 0.00021 3.3313986473707496e-07 0 3.3313986473707496e-07 0 3.3314986473707497e-07 0.00021 3.33159864737075e-07 0 3.3317289083592253e-07 0 3.3318289083592255e-07 0.00021 3.3319289083592256e-07 0 3.334374004122678e-07 0 3.334474004122678e-07 0.00021 3.3345740041226784e-07 0 3.335589264590236e-07 0 3.3356892645902363e-07 0.00021 3.3357892645902364e-07 0 3.336421108444589e-07 0 3.336521108444589e-07 0.00021 3.3366211084445894e-07 0 3.3366211084445894e-07 0 3.3367211084445895e-07 0.00021 3.3368211084445896e-07 0 3.3368981722566624e-07 0 3.3369981722566625e-07 0.00021 3.3370981722566627e-07 0 3.338009622812705e-07 0 3.338109622812705e-07 0.00021 3.3382096228127053e-07 0 3.3383283978731315e-07 0 3.3384283978731316e-07 0.00021 3.3385283978731317e-07 0 3.3392754089937397e-07 0 3.33937540899374e-07 0.00021 3.33947540899374e-07 0 3.33947540899374e-07 0 3.33957540899374e-07 0.00021 3.33967540899374e-07 0 3.3399281025931847e-07 0 3.340028102593185e-07 0.00021 3.340128102593185e-07 0 3.3404340239731594e-07 0 3.3405340239731595e-07 0.00021 3.3406340239731597e-07 0 3.34296412202062e-07 0 3.3430641220206203e-07 0.00021 3.3431641220206204e-07 0 3.343933383711664e-07 0 3.344033383711664e-07 0.00021 3.344133383711664e-07 0 3.344337286891753e-07 0 3.3444372868917533e-07 0.00021 3.3445372868917534e-07 0 3.346409160246825e-07 0 3.346509160246825e-07 0.00021 3.3466091602468253e-07 0 3.3466091602468253e-07 0 3.3467091602468255e-07 0.00021 3.3468091602468256e-07 0 3.347176784102891e-07 0 3.3472767841028913e-07 0.00021 3.3473767841028914e-07 0 3.348249729553948e-07 0 3.348349729553948e-07 0.00021 3.348449729553948e-07 0 3.34868209910985e-07 0 3.34878209910985e-07 0.00021 3.34888209910985e-07 0 3.349664320535709e-07 0 3.349764320535709e-07 0.00021 3.349864320535709e-07 0 3.3515884100828215e-07 0 3.3516884100828216e-07 0.00021 3.351788410082822e-07 0 3.352236154081596e-07 0 3.352336154081596e-07 0.00021 3.352436154081596e-07 0 3.3528652726315755e-07 0 3.3529652726315757e-07 0.00021 3.353065272631576e-07 0 3.3532040404230225e-07 0 3.3533040404230226e-07 0.00021 3.353404040423023e-07 0 3.3538557704689787e-07 0 3.353955770468979e-07 0.00021 3.354055770468979e-07 0 3.355194779715129e-07 0 3.355294779715129e-07 0.00021 3.355394779715129e-07 0 3.356254702612728e-07 0 3.356354702612728e-07 0.00021 3.356454702612728e-07 0 3.356454702612728e-07 0 3.356554702612728e-07 0.00021 3.3566547026127284e-07 0 3.3590061129706767e-07 0 3.359106112970677e-07 0.00021 3.359206112970677e-07 0 3.3593995428866874e-07 0 3.3594995428866875e-07 0.00021 3.3595995428866877e-07 0 3.3595995428866877e-07 0 3.359699542886688e-07 0.00021 3.359799542886688e-07 0 3.360694247745858e-07 0 3.360794247745858e-07 0.00021 3.360894247745858e-07 0 3.361266706642452e-07 0 3.3613667066424523e-07 0.00021 3.3614667066424524e-07 0 3.363762880303815e-07 0 3.3638628803038153e-07 0.00021 3.3639628803038154e-07 0 3.3639628803038154e-07 0 3.3640628803038155e-07 0.00021 3.3641628803038156e-07 0 3.3649359101408777e-07 0 3.365035910140878e-07 0.00021 3.365135910140878e-07 0 3.3655940532959513e-07 0 3.3656940532959515e-07 0.00021 3.3657940532959516e-07 0 3.3657940532959516e-07 0 3.3658940532959517e-07 0.00021 3.365994053295952e-07 0 3.365994053295952e-07 0 3.366094053295952e-07 0.00021 3.366194053295952e-07 0 3.366194053295952e-07 0 3.366294053295952e-07 0.00021 3.366394053295952e-07 0 3.366873785154273e-07 0 3.366973785154273e-07 0.00021 3.367073785154273e-07 0 3.368457111598134e-07 0 3.3685571115981343e-07 0.00021 3.3686571115981344e-07 0 3.36897130457031e-07 0 3.36907130457031e-07 0.00021 3.36917130457031e-07 0 3.370432854209655e-07 0 3.370532854209655e-07 0.00021 3.370632854209655e-07 0 3.370958018466667e-07 0 3.371058018466667e-07 0.00021 3.371158018466667e-07 0 3.371158018466667e-07 0 3.3712580184666673e-07 0.00021 3.3713580184666674e-07 0 3.3714721772270306e-07 0 3.3715721772270307e-07 0.00021 3.371672177227031e-07 0 3.372419201622156e-07 0 3.372519201622156e-07 0.00021 3.372619201622156e-07 0 3.3747000696199224e-07 0 3.3748000696199226e-07 0.00021 3.3749000696199227e-07 0 3.3749000696199227e-07 0 3.375000069619923e-07 0.00021 3.375100069619923e-07 0 3.375100069619923e-07 0 3.375200069619923e-07 0.00021 3.375300069619923e-07 0 3.375416114312029e-07 0 3.375516114312029e-07 0.00021 3.375616114312029e-07 0 3.375616114312029e-07 0 3.375716114312029e-07 0.00021 3.3758161143120293e-07 0 3.3758719638359596e-07 0 3.3759719638359597e-07 0.00021 3.37607196383596e-07 0 3.377006551609541e-07 0 3.377106551609541e-07 0.00021 3.3772065516095413e-07 0 3.3772065516095413e-07 0 3.3773065516095414e-07 0.00021 3.3774065516095415e-07 0 3.3774065516095415e-07 0 3.3775065516095416e-07 0.00021 3.377606551609542e-07 0 3.379411724185116e-07 0 3.379511724185116e-07 0.00021 3.3796117241851163e-07 0 3.380439684760855e-07 0 3.380539684760855e-07 0.00021 3.380639684760855e-07 0 3.3813684925791596e-07 0 3.3814684925791597e-07 0.00021 3.38156849257916e-07 0 3.381937877406406e-07 0 3.382037877406406e-07 0.00021 3.382137877406406e-07 0 3.382137877406406e-07 0 3.382237877406406e-07 0.00021 3.3823378774064064e-07 0 3.382458331899626e-07 0 3.3825583318996263e-07 0.00021 3.3826583318996265e-07 0 3.3830455886217517e-07 0 3.383145588621752e-07 0.00021 3.383245588621752e-07 0 3.3851908000545975e-07 0 3.3852908000545976e-07 0.00021 3.3853908000545977e-07 0 3.3856299423181353e-07 0 3.3857299423181354e-07 0.00021 3.3858299423181355e-07 0 3.386352138063701e-07 0 3.386452138063701e-07 0.00021 3.386552138063701e-07 0 3.3865958508413697e-07 0 3.38669585084137e-07 0.00021 3.38679585084137e-07 0 3.3877184606349426e-07 0 3.3878184606349427e-07 0.00021 3.387918460634943e-07 0 3.387918460634943e-07 0 3.388018460634943e-07 0.00021 3.388118460634943e-07 0 3.38908956261523e-07 0 3.38918956261523e-07 0.00021 3.38928956261523e-07 0 3.390325694789642e-07 0 3.390425694789642e-07 0.00021 3.390525694789642e-07 0 3.39118320695077e-07 0 3.39128320695077e-07 0.00021 3.3913832069507704e-07 0 3.3915293907871994e-07 0 3.3916293907871995e-07 0.00021 3.3917293907871997e-07 0 3.3917293907871997e-07 0 3.3918293907872e-07 0.00021 3.3919293907872e-07 0 3.3923727792183446e-07 0 3.3924727792183447e-07 0.00021 3.392572779218345e-07 0 3.392572779218345e-07 0 3.392672779218345e-07 0.00021 3.392772779218345e-07 0 3.392772779218345e-07 0 3.392872779218345e-07 0.00021 3.3929727792183453e-07 0 3.3929727792183453e-07 0 3.3930727792183454e-07 0.00021 3.3931727792183455e-07 0 3.3931727792183455e-07 0 3.3932727792183456e-07 0.00021 3.393372779218346e-07 0 3.3934023397157825e-07 0 3.3935023397157827e-07 0.00021 3.393602339715783e-07 0 3.3939656586439137e-07 0 3.394065658643914e-07 0.00021 3.394165658643914e-07 0 3.394165658643914e-07 0 3.394265658643914e-07 0.00021 3.394365658643914e-07 0 3.394365658643914e-07 0 3.394465658643914e-07 0.00021 3.3945656586439144e-07 0 3.3945656586439144e-07 0 3.3946656586439145e-07 0.00021 3.3947656586439146e-07 0 3.3958362337581183e-07 0 3.3959362337581184e-07 0.00021 3.3960362337581185e-07 0 3.396179285062444e-07 0 3.396279285062444e-07 0.00021 3.396379285062444e-07 0 3.396466937631339e-07 0 3.396566937631339e-07 0.00021 3.396666937631339e-07 0 3.3973533979957526e-07 0 3.3974533979957527e-07 0.00021 3.397553397995753e-07 0 3.398824343332442e-07 0 3.398924343332442e-07 0.00021 3.399024343332442e-07 0 3.399087734041183e-07 0 3.399187734041183e-07 0.00021 3.399287734041183e-07 0 3.3993033128206667e-07 0 3.399403312820667e-07 0.00021 3.399503312820667e-07 0 3.39954382735171e-07 0 3.39964382735171e-07 0.00021 3.3997438273517103e-07 0 3.400675000009234e-07 0 3.400775000009234e-07 0.00021 3.4008750000092343e-07 0 3.401331522676047e-07 0 3.4014315226760473e-07 0.00021 3.4015315226760474e-07 0 3.4015315226760474e-07 0 3.4016315226760476e-07 0.00021 3.4017315226760477e-07 0 3.402612020681937e-07 0 3.402712020681937e-07 0.00021 3.402812020681937e-07 0 3.402812020681937e-07 0 3.4029120206819373e-07 0.00021 3.4030120206819374e-07 0 3.403456679910316e-07 0 3.4035566799103164e-07 0.00021 3.4036566799103165e-07 0 3.403729747551013e-07 0 3.403829747551013e-07 0.00021 3.403929747551013e-07 0 3.403929747551013e-07 0 3.4040297475510133e-07 0.00021 3.4041297475510134e-07 0 3.4050690893475976e-07 0 3.4051690893475977e-07 0.00021 3.405269089347598e-07 0 3.405335584429259e-07 0 3.405435584429259e-07 0.00021 3.405535584429259e-07 0 3.4057793081146e-07 0 3.4058793081146e-07 0.00021 3.4059793081146e-07 0 3.40708624290132e-07 0 3.40718624290132e-07 0.00021 3.40728624290132e-07 0 3.40728624290132e-07 0 3.4073862429013203e-07 0.00021 3.4074862429013204e-07 0 3.407501262117003e-07 0 3.407601262117003e-07 0.00021 3.407701262117003e-07 0 3.407809627469035e-07 0 3.407909627469035e-07 0.00021 3.408009627469035e-07 0 3.408994454982321e-07 0 3.4090944549823214e-07 0.00021 3.4091944549823215e-07 0 3.4097459391702773e-07 0 3.4098459391702774e-07 0.00021 3.4099459391702775e-07 0 3.410330817237153e-07 0 3.410430817237153e-07 0.00021 3.4105308172371533e-07 0 3.411757986954104e-07 0 3.411857986954104e-07 0.00021 3.411957986954104e-07 0 3.41233505756424e-07 0 3.41243505756424e-07 0.00021 3.41253505756424e-07 0 3.41284098703563e-07 0 3.4129409870356303e-07 0.00021 3.4130409870356304e-07 0 3.413356198223835e-07 0 3.413456198223835e-07 0.00021 3.413556198223835e-07 0 3.4143273937920145e-07 0 3.4144273937920146e-07 0.00021 3.4145273937920147e-07 0 3.41466371700629e-07 0 3.41476371700629e-07 0.00021 3.41486371700629e-07 0 3.41488673107202e-07 0 3.41498673107202e-07 0.00021 3.41508673107202e-07 0 3.4152005570404377e-07 0 3.415300557040438e-07 0.00021 3.415400557040438e-07 0 3.4155164795016146e-07 0 3.4156164795016147e-07 0.00021 3.415716479501615e-07 0 3.4168074764956996e-07 0 3.4169074764957e-07 0.00021 3.4170074764957e-07 0 3.417281069401982e-07 0 3.417381069401982e-07 0.00021 3.417481069401982e-07 0 3.417829154867711e-07 0 3.417929154867711e-07 0.00021 3.4180291548677114e-07 0 3.4199137766176733e-07 0 3.4200137766176734e-07 0.00021 3.4201137766176736e-07 0 3.420499126463407e-07 0 3.420599126463407e-07 0.00021 3.420699126463407e-07 0 3.421968338114286e-07 0 3.422068338114286e-07 0.00021 3.422168338114286e-07 0 3.4225075055384414e-07 0 3.4226075055384416e-07 0.00021 3.4227075055384417e-07 0 3.423818179809296e-07 0 3.423918179809296e-07 0.00021 3.424018179809296e-07 0 3.4247506592921846e-07 0 3.4248506592921847e-07 0.00021 3.424950659292185e-07 0 3.4250904349607775e-07 0 3.4251904349607776e-07 0.00021 3.4252904349607777e-07 0 3.4253033683629875e-07 0 3.4254033683629876e-07 0.00021 3.4255033683629877e-07 0 3.4268178479496425e-07 0 3.4269178479496426e-07 0.00021 3.427017847949643e-07 0 3.4277052682621875e-07 0 3.4278052682621876e-07 0.00021 3.4279052682621877e-07 0 3.4279393451329343e-07 0 3.4280393451329345e-07 0.00021 3.4281393451329346e-07 0 3.429103892425294e-07 0 3.429203892425294e-07 0.00021 3.429303892425294e-07 0 3.429303892425294e-07 0 3.429403892425294e-07 0.00021 3.4295038924252943e-07 0 3.429640494677451e-07 0 3.429740494677451e-07 0.00021 3.4298404946774513e-07 0 3.429863954717072e-07 0 3.4299639547170724e-07 0.00021 3.4300639547170725e-07 0 3.4301595717636206e-07 0 3.4302595717636207e-07 0.00021 3.430359571763621e-07 0 3.4311777652670684e-07 0 3.4312777652670685e-07 0.00021 3.4313777652670686e-07 0 3.434546205470552e-07 0 3.4346462054705523e-07 0.00021 3.4347462054705524e-07 0 3.4347462054705524e-07 0 3.4348462054705526e-07 0.00021 3.4349462054705527e-07 0 3.4374211758544803e-07 0 3.4375211758544804e-07 0.00021 3.4376211758544806e-07 0 3.4420444486666066e-07 0 3.4421444486666067e-07 0.00021 3.442244448666607e-07 0 3.442406134903647e-07 0 3.442506134903647e-07 0.00021 3.442606134903647e-07 0 3.442606134903647e-07 0 3.4427061349036474e-07 0.00021 3.4428061349036475e-07 0 3.442965364056733e-07 0 3.443065364056733e-07 0.00021 3.4431653640567334e-07 0 3.444219951474585e-07 0 3.444319951474585e-07 0.00021 3.444419951474585e-07 0 3.4447428802858445e-07 0 3.4448428802858447e-07 0.00021 3.444942880285845e-07 0 3.4454603735663784e-07 0 3.4455603735663786e-07 0.00021 3.4456603735663787e-07 0 3.4456603735663787e-07 0 3.445760373566379e-07 0.00021 3.445860373566379e-07 0 3.445860373566379e-07 0 3.445960373566379e-07 0.00021 3.446060373566379e-07 0 3.446060373566379e-07 0 3.446160373566379e-07 0.00021 3.4462603735663794e-07 0 3.44746295412344e-07 0 3.4475629541234403e-07 0.00021 3.4476629541234405e-07 0 3.4476629541234405e-07 0 3.4477629541234406e-07 0.00021 3.4478629541234407e-07 0 3.4484361986397594e-07 0 3.4485361986397596e-07 0.00021 3.4486361986397597e-07 0 3.448739807870101e-07 0 3.448839807870101e-07 0.00021 3.448939807870101e-07 0 3.4489400531023205e-07 0 3.4490400531023206e-07 0.00021 3.4491400531023207e-07 0 3.4491400531023207e-07 0 3.449240053102321e-07 0.00021 3.449340053102321e-07 0 3.449722394448574e-07 0 3.449822394448574e-07 0.00021 3.449922394448574e-07 0 3.44993095774794e-07 0 3.45003095774794e-07 0.00021 3.45013095774794e-07 0 3.4506445832624153e-07 0 3.4507445832624155e-07 0.00021 3.4508445832624156e-07 0 3.451543363662359e-07 0 3.4516433636623593e-07 0.00021 3.4517433636623594e-07 0 3.4518667697966406e-07 0 3.4519667697966407e-07 0.00021 3.452066769796641e-07 0 3.454504297292091e-07 0 3.454604297292091e-07 0.00021 3.4547042972920913e-07 0 3.4566329290655434e-07 0 3.4567329290655435e-07 0.00021 3.4568329290655436e-07 0 3.4568329290655436e-07 0 3.456932929065544e-07 0.00021 3.457032929065544e-07 0 3.4573062182334015e-07 0 3.4574062182334017e-07 0.00021 3.457506218233402e-07 0 3.4578590190292837e-07 0 3.457959019029284e-07 0.00021 3.458059019029284e-07 0 3.459010560487703e-07 0 3.4591105604877033e-07 0.00021 3.4592105604877034e-07 0 3.4592105604877034e-07 0 3.4593105604877035e-07 0.00021 3.4594105604877036e-07 0 3.4610919186095165e-07 0 3.4611919186095167e-07 0.00021 3.461291918609517e-07 0 3.461291918609517e-07 0 3.461391918609517e-07 0.00021 3.461491918609517e-07 0 3.461491918609517e-07 0 3.461591918609517e-07 0.00021 3.461691918609517e-07 0 3.4618465827037546e-07 0 3.4619465827037547e-07 0.00021 3.462046582703755e-07 0 3.4622710956889146e-07 0 3.4623710956889147e-07 0.00021 3.462471095688915e-07 0 3.462495604767477e-07 0 3.462595604767477e-07 0.00021 3.462695604767477e-07 0 3.462695604767477e-07 0 3.462795604767477e-07 0.00021 3.4628956047674773e-07 0 3.463457887740343e-07 0 3.4635578877403433e-07 0.00021 3.4636578877403434e-07 0 3.463674260221381e-07 0 3.463774260221381e-07 0.00021 3.463874260221381e-07 0 3.464955184664881e-07 0 3.465055184664881e-07 0.00021 3.465155184664881e-07 0 3.465155184664881e-07 0 3.465255184664881e-07 0.00021 3.465355184664881e-07 0 3.4654109376312245e-07 0 3.4655109376312246e-07 0.00021 3.4656109376312247e-07 0 3.4656109376312247e-07 0 3.465710937631225e-07 0.00021 3.465810937631225e-07 0 3.4658582165185243e-07 0 3.4659582165185244e-07 0.00021 3.4660582165185245e-07 0 3.466359211220559e-07 0 3.4664592112205594e-07 0.00021 3.4665592112205595e-07 0 3.468751976310854e-07 0 3.468851976310854e-07 0.00021 3.468951976310854e-07 0 3.471286970787263e-07 0 3.471386970787263e-07 0.00021 3.4714869707872633e-07 0 3.472752661576329e-07 0 3.472852661576329e-07 0.00021 3.472952661576329e-07 0 3.473200766227922e-07 0 3.4733007662279224e-07 0.00021 3.4734007662279225e-07 0 3.4746573053820494e-07 0 3.4747573053820495e-07 0.00021 3.4748573053820497e-07 0 3.475124115413033e-07 0 3.4752241154130333e-07 0.00021 3.4753241154130334e-07 0 3.4753241154130334e-07 0 3.4754241154130335e-07 0.00021 3.4755241154130336e-07 0 3.4755241154130336e-07 0 3.475624115413034e-07 0.00021 3.475724115413034e-07 0 3.4758777231508913e-07 0 3.4759777231508914e-07 0.00021 3.4760777231508915e-07 0 3.4767478145705e-07 0 3.4768478145705e-07 0.00021 3.4769478145705e-07 0 3.4773181992223495e-07 0 3.4774181992223496e-07 0.00021 3.47751819922235e-07 0 3.4778973683754746e-07 0 3.477997368375475e-07 0.00021 3.478097368375475e-07 0 3.478097368375475e-07 0 3.478197368375475e-07 0.00021 3.478297368375475e-07 0 3.479123911986564e-07 0 3.4792239119865644e-07 0.00021 3.4793239119865645e-07 0 3.4794565650278193e-07 0 3.4795565650278194e-07 0.00021 3.4796565650278195e-07 0 3.480819322953437e-07 0 3.480919322953437e-07 0.00021 3.4810193229534373e-07 0 3.4825253086609895e-07 0 3.4826253086609896e-07 0.00021 3.4827253086609897e-07 0 3.485385445097202e-07 0 3.4854854450972023e-07 0.00021 3.4855854450972024e-07 0 3.4858218890848043e-07 0 3.4859218890848045e-07 0.00021 3.4860218890848046e-07 0 3.48647557696847e-07 0 3.48657557696847e-07 0.00021 3.48667557696847e-07 0 3.4871941826775185e-07 0 3.4872941826775186e-07 0.00021 3.4873941826775187e-07 0 3.4875431051802943e-07 0 3.4876431051802944e-07 0.00021 3.4877431051802945e-07 0 3.4885307020857686e-07 0 3.4886307020857687e-07 0.00021 3.488730702085769e-07 0 3.4933972516164537e-07 0 3.493497251616454e-07 0.00021 3.493597251616454e-07 0 3.496256508512789e-07 0 3.496356508512789e-07 0.00021 3.496456508512789e-07 0 3.496456508512789e-07 0 3.4965565085127893e-07 0.00021 3.4966565085127894e-07 0 3.497448383221361e-07 0 3.497548383221361e-07 0.00021 3.497648383221361e-07 0 3.497648383221361e-07 0 3.497748383221361e-07 0.00021 3.4978483832213613e-07 0 3.498673967582995e-07 0 3.498773967582995e-07 0.00021 3.498873967582995e-07 0 3.500247492711852e-07 0 3.500347492711852e-07 0.00021 3.500447492711852e-07 0 3.501279609822602e-07 0 3.501379609822602e-07 0.00021 3.5014796098226023e-07 0 3.501512167130509e-07 0 3.501612167130509e-07 0.00021 3.501712167130509e-07 0 3.50220670236426e-07 0 3.5023067023642604e-07 0.00021 3.5024067023642605e-07 0 3.502447779879554e-07 0 3.5025477798795543e-07 0.00021 3.5026477798795544e-07 0 3.503077396921065e-07 0 3.503177396921065e-07 0.00021 3.5032773969210654e-07 0 3.5032773969210654e-07 0 3.5033773969210655e-07 0.00021 3.5034773969210656e-07 0 3.5035302379177857e-07 0 3.503630237917786e-07 0.00021 3.503730237917786e-07 0 3.5044987167078347e-07 0 3.504598716707835e-07 0.00021 3.504698716707835e-07 0 3.506024004153223e-07 0 3.506124004153223e-07 0.00021 3.506224004153223e-07 0 3.507292950986091e-07 0 3.507392950986091e-07 0.00021 3.507492950986091e-07 0 3.507492950986091e-07 0 3.507592950986091e-07 0.00021 3.5076929509860913e-07 0 3.5076929509860913e-07 0 3.5077929509860915e-07 0.00021 3.5078929509860916e-07 0 3.5080455197083865e-07 0 3.5081455197083867e-07 0.00021 3.508245519708387e-07 0 3.5082677191919974e-07 0 3.5083677191919975e-07 0.00021 3.5084677191919977e-07 0 3.509156744417721e-07 0 3.509256744417721e-07 0.00021 3.509356744417721e-07 0 3.50991042254314e-07 0 3.51001042254314e-07 0.00021 3.51011042254314e-07 0 3.510712025990591e-07 0 3.510812025990591e-07 0.00021 3.510912025990591e-07 0 3.51170770548903e-07 0 3.51180770548903e-07 0.00021 3.51190770548903e-07 0 3.512092579914216e-07 0 3.512192579914216e-07 0.00021 3.5122925799142163e-07 0 3.512680160766249e-07 0 3.512780160766249e-07 0.00021 3.512880160766249e-07 0 3.512880160766249e-07 0 3.512980160766249e-07 0.00021 3.513080160766249e-07 0 3.513566602002317e-07 0 3.513666602002317e-07 0.00021 3.5137666020023173e-07 0 3.5138359957521673e-07 0 3.5139359957521674e-07 0.00021 3.5140359957521675e-07 0 3.514316426609564e-07 0 3.5144164266095643e-07 0.00021 3.5145164266095645e-07 0 3.514539756113636e-07 0 3.514639756113636e-07 0.00021 3.5147397561136364e-07 0 3.5153400010469425e-07 0 3.5154400010469427e-07 0.00021 3.515540001046943e-07 0 3.5173735441748653e-07 0 3.5174735441748655e-07 0.00021 3.5175735441748656e-07 0 3.518136455393737e-07 0 3.518236455393737e-07 0.00021 3.5183364553937373e-07 0 3.5202585688342573e-07 0 3.5203585688342574e-07 0.00021 3.5204585688342575e-07 0 3.521301122384845e-07 0 3.521401122384845e-07 0.00021 3.5215011223848453e-07 0 3.5215011223848453e-07 0 3.5216011223848454e-07 0.00021 3.5217011223848455e-07 0 3.5217011223848455e-07 0 3.5218011223848457e-07 0.00021 3.521901122384846e-07 0 3.524811042722837e-07 0 3.524911042722837e-07 0.00021 3.525011042722837e-07 0 3.5250888999043977e-07 0 3.525188899904398e-07 0.00021 3.525288899904398e-07 0 3.525288899904398e-07 0 3.525388899904398e-07 0.00021 3.525488899904398e-07 0 3.525523509431412e-07 0 3.525623509431412e-07 0.00021 3.525723509431412e-07 0 3.5288346568643e-07 0 3.5289346568643e-07 0.00021 3.5290346568643e-07 0 3.5290970874879317e-07 0 3.529197087487932e-07 0.00021 3.529297087487932e-07 0 3.530017809308714e-07 0 3.5301178093087143e-07 0.00021 3.5302178093087144e-07 0 3.533616453547107e-07 0 3.533716453547107e-07 0.00021 3.533816453547107e-07 0 3.5339364005615356e-07 0 3.5340364005615357e-07 0.00021 3.534136400561536e-07 0 3.534600394650824e-07 0 3.5347003946508243e-07 0.00021 3.5348003946508244e-07 0 3.5353335158350374e-07 0 3.5354335158350375e-07 0.00021 3.5355335158350376e-07 0 3.539032890464318e-07 0 3.539132890464318e-07 0.00021 3.539232890464318e-07 0 3.54018815647186e-07 0 3.54028815647186e-07 0.00021 3.54038815647186e-07 0 3.5417780440658115e-07 0 3.5418780440658116e-07 0.00021 3.5419780440658117e-07 0 3.5421508039394756e-07 0 3.5422508039394757e-07 0.00021 3.542350803939476e-07 0 3.542350803939476e-07 0 3.542450803939476e-07 0.00021 3.542550803939476e-07 0 3.542550803939476e-07 0 3.542650803939476e-07 0.00021 3.542750803939476e-07 0 3.5432529599443844e-07 0 3.5433529599443845e-07 0.00021 3.5434529599443846e-07 0 3.543897626232316e-07 0 3.5439976262323163e-07 0.00021 3.5440976262323164e-07 0 3.5467464246818284e-07 0 3.5468464246818285e-07 0.00021 3.5469464246818286e-07 0 3.5485378714134916e-07 0 3.5486378714134917e-07 0.00021 3.548737871413492e-07 0 3.548737871413492e-07 0 3.548837871413492e-07 0.00021 3.548937871413492e-07 0 3.548937871413492e-07 0 3.549037871413492e-07 0.00021 3.549137871413492e-07 0 3.549137871413492e-07 0 3.5492378714134924e-07 0.00021 3.5493378714134925e-07 0 3.549626430297506e-07 0 3.549726430297506e-07 0.00021 3.5498264302975063e-07 0 3.550340014640166e-07 0 3.550440014640166e-07 0.00021 3.550540014640166e-07 0 3.550540014640166e-07 0 3.550640014640166e-07 0.00021 3.5507400146401664e-07 0 3.5519349908036604e-07 0 3.5520349908036605e-07 0.00021 3.5521349908036607e-07 0 3.5521349908036607e-07 0 3.552234990803661e-07 0.00021 3.552334990803661e-07 0 3.552334990803661e-07 0 3.552434990803661e-07 0.00021 3.552534990803661e-07 0 3.553364426967954e-07 0 3.5534644269679543e-07 0.00021 3.5535644269679544e-07 0 3.554004730131924e-07 0 3.5541047301319243e-07 0.00021 3.5542047301319244e-07 0 3.554558248508971e-07 0 3.554658248508971e-07 0.00021 3.554758248508971e-07 0 3.554758248508971e-07 0 3.554858248508971e-07 0.00021 3.5549582485089713e-07 0 3.5549582485089713e-07 0 3.5550582485089714e-07 0.00021 3.5551582485089715e-07 0 3.555179106970001e-07 0 3.555279106970001e-07 0.00021 3.5553791069700013e-07 0 3.5553791069700013e-07 0 3.5554791069700014e-07 0.00021 3.5555791069700015e-07 0 3.556510832300059e-07 0 3.5566108323000593e-07 0.00021 3.5567108323000594e-07 0 3.558543744609664e-07 0 3.558643744609664e-07 0.00021 3.558743744609664e-07 0 3.5606170504446856e-07 0 3.5607170504446857e-07 0.00021 3.560817050444686e-07 0 3.562053429923981e-07 0 3.5621534299239813e-07 0.00021 3.5622534299239815e-07 0 3.5660610594739663e-07 0 3.5661610594739664e-07 0.00021 3.5662610594739665e-07 0 3.5665167642198297e-07 0 3.56661676421983e-07 0.00021 3.56671676421983e-07 0 3.5674992862892135e-07 0 3.5675992862892136e-07 0.00021 3.5676992862892137e-07 0 3.5676992862892137e-07 0 3.567799286289214e-07 0.00021 3.567899286289214e-07 0 3.567899286289214e-07 0 3.567999286289214e-07 0.00021 3.568099286289214e-07 0 3.568099286289214e-07 0 3.568199286289214e-07 0.00021 3.5682992862892144e-07 0 3.569219245853138e-07 0 3.569319245853138e-07 0.00021 3.569419245853138e-07 0 3.5700533279574145e-07 0 3.5701533279574146e-07 0.00021 3.5702533279574147e-07 0 3.570446838884391e-07 0 3.570546838884391e-07 0.00021 3.5706468388843914e-07 0 3.5707123739004215e-07 0 3.5708123739004216e-07 0.00021 3.5709123739004217e-07 0 3.571136895985967e-07 0 3.571236895985967e-07 0.00021 3.571336895985967e-07 0 3.572984600217101e-07 0 3.5730846002171013e-07 0.00021 3.5731846002171014e-07 0 3.574805717964043e-07 0 3.574905717964043e-07 0.00021 3.5750057179640433e-07 0 3.5750057179640433e-07 0 3.5751057179640434e-07 0.00021 3.5752057179640435e-07 0 3.5754024555598247e-07 0 3.575502455559825e-07 0.00021 3.575602455559825e-07 0 3.575602455559825e-07 0 3.575702455559825e-07 0.00021 3.575802455559825e-07 0 3.576667346923698e-07 0 3.5767673469236983e-07 0.00021 3.5768673469236985e-07 0 3.57738253973726e-07 0 3.57748253973726e-07 0.00021 3.57758253973726e-07 0 3.57791697490732e-07 0 3.5780169749073203e-07 0.00021 3.5781169749073205e-07 0 3.5781169749073205e-07 0 3.5782169749073206e-07 0.00021 3.5783169749073207e-07 0 3.5784271261131884e-07 0 3.5785271261131885e-07 0.00021 3.5786271261131887e-07 0 3.579646027386093e-07 0 3.5797460273860933e-07 0.00021 3.5798460273860934e-07 0 3.5798460273860934e-07 0 3.5799460273860935e-07 0.00021 3.5800460273860936e-07 0 3.5810398222385625e-07 0 3.5811398222385626e-07 0.00021 3.581239822238563e-07 0 3.582000466731942e-07 0 3.582100466731942e-07 0.00021 3.582200466731942e-07 0 3.5825738567363304e-07 0 3.5826738567363306e-07 0.00021 3.5827738567363307e-07 0 3.58485251983139e-07 0 3.5849525198313904e-07 0.00021 3.5850525198313905e-07 0 3.585075938908986e-07 0 3.5851759389089863e-07 0.00021 3.5852759389089864e-07 0 3.5853549276579226e-07 0 3.5854549276579227e-07 0.00021 3.585554927657923e-07 0 3.5857599824992804e-07 0 3.5858599824992805e-07 0.00021 3.5859599824992807e-07 0 3.5869088976114374e-07 0 3.5870088976114375e-07 0.00021 3.5871088976114376e-07 0 3.588452267805162e-07 0 3.588552267805162e-07 0.00021 3.588652267805162e-07 0 3.58947081476434e-07 0 3.58957081476434e-07 0.00021 3.58967081476434e-07 0 3.58967081476434e-07 0 3.58977081476434e-07 0.00021 3.58987081476434e-07 0 3.58987081476434e-07 0 3.5899708147643403e-07 0.00021 3.5900708147643405e-07 0 3.5900708147643405e-07 0 3.5901708147643406e-07 0.00021 3.5902708147643407e-07 0 3.591776916095838e-07 0 3.591876916095838e-07 0.00021 3.591976916095838e-07 0 3.591976916095838e-07 0 3.592076916095838e-07 0.00021 3.5921769160958383e-07 0 3.5927637521390055e-07 0 3.5928637521390056e-07 0.00021 3.5929637521390057e-07 0 3.5929637521390057e-07 0 3.593063752139006e-07 0.00021 3.593163752139006e-07 0 3.593163752139006e-07 0 3.593263752139006e-07 0.00021 3.593363752139006e-07 0 3.593363752139006e-07 0 3.593463752139006e-07 0.00021 3.5935637521390064e-07 0 3.593804830624781e-07 0 3.593904830624781e-07 0.00021 3.594004830624781e-07 0 3.594004830624781e-07 0 3.594104830624781e-07 0.00021 3.5942048306247813e-07 0 3.5942048306247813e-07 0 3.5943048306247814e-07 0.00021 3.5944048306247816e-07 0 3.5944048306247816e-07 0 3.5945048306247817e-07 0.00021 3.594604830624782e-07 0 3.595425622290464e-07 0 3.5955256222904643e-07 0.00021 3.5956256222904645e-07 0 3.5975261929386056e-07 0 3.5976261929386057e-07 0.00021 3.597726192938606e-07 0 3.598003803992116e-07 0 3.598103803992116e-07 0.00021 3.598203803992116e-07 0 3.598427208561128e-07 0 3.598527208561128e-07 0.00021 3.5986272085611284e-07 0 3.5986272085611284e-07 0 3.5987272085611285e-07 0.00021 3.5988272085611286e-07 0 3.5988272085611286e-07 0 3.5989272085611287e-07 0.00021 3.599027208561129e-07 0 3.599291871058186e-07 0 3.599391871058186e-07 0.00021 3.599491871058186e-07 0 3.5998585950657345e-07 0 3.5999585950657346e-07 0.00021 3.6000585950657347e-07 0 3.602849712926909e-07 0 3.602949712926909e-07 0.00021 3.603049712926909e-07 0 3.603049712926909e-07 0 3.603149712926909e-07 0.00021 3.6032497129269093e-07 0 3.603904295510174e-07 0 3.604004295510174e-07 0.00021 3.6041042955101744e-07 0 3.6042739843377054e-07 0 3.6043739843377055e-07 0.00021 3.6044739843377056e-07 0 3.6045479255448486e-07 0 3.6046479255448487e-07 0.00021 3.604747925544849e-07 0 3.6054834991622445e-07 0 3.6055834991622446e-07 0.00021 3.6056834991622447e-07 0 3.609332485154787e-07 0 3.609432485154787e-07 0.00021 3.609532485154787e-07 0 3.6103653422084556e-07 0 3.6104653422084557e-07 0.00021 3.610565342208456e-07 0 3.610565342208456e-07 0 3.610665342208456e-07 0.00021 3.610765342208456e-07 0 3.6109517923915203e-07 0 3.6110517923915204e-07 0.00021 3.6111517923915205e-07 0 3.6119668948590626e-07 0 3.6120668948590627e-07 0.00021 3.612166894859063e-07 0 3.612170183027168e-07 0 3.612270183027168e-07 0.00021 3.612370183027168e-07 0 3.6126948972070513e-07 0 3.6127948972070515e-07 0.00021 3.6128948972070516e-07 0 3.6131857082054454e-07 0 3.6132857082054455e-07 0.00021 3.6133857082054457e-07 0 3.6133857082054457e-07 0 3.613485708205446e-07 0.00021 3.613585708205446e-07 0 3.614061324498067e-07 0 3.614161324498067e-07 0.00021 3.614261324498067e-07 0 3.6151396965262984e-07 0 3.6152396965262985e-07 0.00021 3.6153396965262987e-07 0 3.617797446594947e-07 0 3.617897446594947e-07 0.00021 3.617997446594947e-07 0 3.6192968616082327e-07 0 3.619396861608233e-07 0.00021 3.619496861608233e-07 0 3.622730883767179e-07 0 3.622830883767179e-07 0.00021 3.6229308837671793e-07 0 3.6229627348509925e-07 0 3.6230627348509926e-07 0.00021 3.623162734850993e-07 0 3.6235995578801076e-07 0 3.6236995578801077e-07 0.00021 3.623799557880108e-07 0 3.6248753130436885e-07 0 3.6249753130436886e-07 0.00021 3.625075313043689e-07 0 3.626241261216191e-07 0 3.626341261216191e-07 0.00021 3.626441261216191e-07 0 3.62744993732248e-07 0 3.62754993732248e-07 0.00021 3.62764993732248e-07 0 3.627900556318823e-07 0 3.628000556318823e-07 0.00021 3.6281005563188234e-07 0 3.6281005563188234e-07 0 3.6282005563188235e-07 0.00021 3.6283005563188236e-07 0 3.6283005563188236e-07 0 3.6284005563188237e-07 0.00021 3.628500556318824e-07 0 3.628500556318824e-07 0 3.628600556318824e-07 0.00021 3.628700556318824e-07 0 3.6298587476677034e-07 0 3.6299587476677035e-07 0.00021 3.6300587476677036e-07 0 3.6301404231726754e-07 0 3.6302404231726755e-07 0.00021 3.6303404231726756e-07 0 3.631726075376497e-07 0 3.631826075376497e-07 0.00021 3.631926075376497e-07 0 3.632190365808388e-07 0 3.632290365808388e-07 0.00021 3.6323903658083883e-07 0 3.6327684610795e-07 0 3.6328684610795e-07 0.00021 3.6329684610795003e-07 0 3.633533290710877e-07 0 3.633633290710877e-07 0.00021 3.633733290710877e-07 0 3.63537541916334e-07 0 3.6354754191633403e-07 0.00021 3.6355754191633404e-07 0 3.637014022946138e-07 0 3.637114022946138e-07 0.00021 3.637214022946138e-07 0 3.63731911036648e-07 0 3.63741911036648e-07 0.00021 3.63751911036648e-07 0 3.63751911036648e-07 0 3.63761911036648e-07 0.00021 3.63771911036648e-07 0 3.63771911036648e-07 0 3.6378191103664803e-07 0.00021 3.6379191103664805e-07 0 3.638424137022342e-07 0 3.6385241370223424e-07 0.00021 3.6386241370223425e-07 0 3.6407463611494977e-07 0 3.640846361149498e-07 0.00021 3.640946361149498e-07 0 3.640946361149498e-07 0 3.641046361149498e-07 0.00021 3.641146361149498e-07 0 3.641429203745533e-07 0 3.641529203745533e-07 0.00021 3.641629203745533e-07 0 3.641669559010801e-07 0 3.641769559010801e-07 0.00021 3.641869559010801e-07 0 3.643065928352787e-07 0 3.643165928352787e-07 0.00021 3.6432659283527873e-07 0 3.6440006313973156e-07 0 3.6441006313973157e-07 0.00021 3.644200631397316e-07 0 3.6445704535783616e-07 0 3.6446704535783617e-07 0.00021 3.644770453578362e-07 0 3.6463550886437925e-07 0 3.6464550886437927e-07 0.00021 3.646555088643793e-07 0 3.6468898508069343e-07 0 3.6469898508069344e-07 0.00021 3.6470898508069345e-07 0 3.647091784312511e-07 0 3.6471917843125114e-07 0.00021 3.6472917843125115e-07 0 3.6474081732986223e-07 0 3.6475081732986224e-07 0.00021 3.6476081732986226e-07 0 3.647681374692334e-07 0 3.647781374692334e-07 0.00021 3.6478813746923343e-07 0 3.6480747826254327e-07 0 3.648174782625433e-07 0.00021 3.648274782625433e-07 0 3.6489491871677456e-07 0 3.6490491871677457e-07 0.00021 3.649149187167746e-07 0 3.649432078219472e-07 0 3.649532078219472e-07 0.00021 3.649632078219472e-07 0 3.649975848560855e-07 0 3.650075848560855e-07 0.00021 3.650175848560855e-07 0 3.650175848560855e-07 0 3.650275848560855e-07 0.00021 3.650375848560855e-07 0 3.653430177119278e-07 0 3.653530177119278e-07 0.00021 3.6536301771192783e-07 0 3.65478528502676e-07 0 3.65488528502676e-07 0.00021 3.6549852850267603e-07 0 3.6558178225416703e-07 0 3.6559178225416704e-07 0.00021 3.6560178225416706e-07 0 3.6561045923804503e-07 0 3.6562045923804504e-07 0.00021 3.6563045923804505e-07 0 3.6563045923804505e-07 0 3.6564045923804507e-07 0.00021 3.656504592380451e-07 0 3.656566330528191e-07 0 3.656666330528191e-07 0.00021 3.656766330528191e-07 0 3.656766330528191e-07 0 3.656866330528191e-07 0.00021 3.6569663305281914e-07 0 3.6569663305281914e-07 0 3.6570663305281915e-07 0.00021 3.6571663305281916e-07 0 3.658399099894982e-07 0 3.658499099894982e-07 0.00021 3.6585990998949823e-07 0 3.6589722377726957e-07 0 3.659072237772696e-07 0.00021 3.659172237772696e-07 0 3.659439085524679e-07 0 3.6595390855246793e-07 0.00021 3.6596390855246794e-07 0 3.659896172614261e-07 0 3.659996172614261e-07 0.00021 3.660096172614261e-07 0 3.660096172614261e-07 0 3.660196172614261e-07 0.00021 3.660296172614261e-07 0 3.660296172614261e-07 0 3.6603961726142613e-07 0.00021 3.6604961726142614e-07 0 3.6604961726142614e-07 0 3.6605961726142616e-07 0.00021 3.6606961726142617e-07 0 3.6606961726142617e-07 0 3.660796172614262e-07 0.00021 3.660896172614262e-07 0 3.660896172614262e-07 0 3.660996172614262e-07 0.00021 3.661096172614262e-07 0 3.6619800727609267e-07 0 3.662080072760927e-07 0.00021 3.662180072760927e-07 0 3.662180072760927e-07 0 3.662280072760927e-07 0.00021 3.662380072760927e-07 0 3.662380072760927e-07 0 3.6624800727609273e-07 0.00021 3.6625800727609274e-07 0 3.662739013669059e-07 0 3.662839013669059e-07 0.00021 3.662939013669059e-07 0 3.663126372103752e-07 0 3.663226372103752e-07 0.00021 3.663326372103752e-07 0 3.663402774631186e-07 0 3.663502774631186e-07 0.00021 3.663602774631186e-07 0 3.6665145609679554e-07 0 3.6666145609679555e-07 0.00021 3.6667145609679556e-07 0 3.669017859585368e-07 0 3.669117859585368e-07 0.00021 3.669217859585368e-07 0 3.6695226585183806e-07 0 3.6696226585183807e-07 0.00021 3.669722658518381e-07 0 3.669722658518381e-07 0 3.669822658518381e-07 0.00021 3.669922658518381e-07 0 3.669922658518381e-07 0 3.670022658518381e-07 0.00021 3.670122658518381e-07 0 3.670122658518381e-07 0 3.6702226585183814e-07 0.00021 3.6703226585183815e-07 0 3.670932047572588e-07 0 3.671032047572588e-07 0.00021 3.671132047572588e-07 0 3.6719769004539783e-07 0 3.6720769004539784e-07 0.00021 3.6721769004539786e-07 0 3.673639190846614e-07 0 3.6737391908466143e-07 0.00021 3.6738391908466145e-07 0 3.6738391908466145e-07 0 3.6739391908466146e-07 0.00021 3.6740391908466147e-07 0 3.6740391908466147e-07 0 3.674139190846615e-07 0.00021 3.674239190846615e-07 0 3.674239190846615e-07 0 3.674339190846615e-07 0.00021 3.674439190846615e-07 0 3.6769185394774075e-07 0 3.6770185394774076e-07 0.00021 3.6771185394774077e-07 0 3.678485551544456e-07 0 3.678585551544456e-07 0.00021 3.6786855515444563e-07 0 3.6791865064883555e-07 0 3.6792865064883556e-07 0.00021 3.6793865064883557e-07 0 3.6793865064883557e-07 0 3.679486506488356e-07 0.00021 3.679586506488356e-07 0 3.679586506488356e-07 0 3.679686506488356e-07 0.00021 3.679786506488356e-07 0 3.679786506488356e-07 0 3.6798865064883563e-07 0.00021 3.6799865064883564e-07 0 3.681873642181018e-07 0 3.681973642181018e-07 0.00021 3.6820736421810183e-07 0 3.684095302757467e-07 0 3.684195302757467e-07 0.00021 3.684295302757467e-07 0 3.6845198943206956e-07 0 3.6846198943206957e-07 0.00021 3.684719894320696e-07 0 3.685182543144066e-07 0 3.685282543144066e-07 0.00021 3.685382543144066e-07 0 3.6862526390689844e-07 0 3.6863526390689845e-07 0.00021 3.6864526390689846e-07 0 3.6865867216923503e-07 0 3.6866867216923504e-07 0.00021 3.6867867216923506e-07 0 3.6869522622092393e-07 0 3.6870522622092394e-07 0.00021 3.6871522622092396e-07 0 3.687707924319666e-07 0 3.687807924319666e-07 0.00021 3.687907924319666e-07 0 3.687981277610036e-07 0 3.6880812776100364e-07 0.00021 3.6881812776100365e-07 0 3.6906921384443035e-07 0 3.6907921384443036e-07 0.00021 3.6908921384443037e-07 0 3.6912486880766687e-07 0 3.691348688076669e-07 0.00021 3.691448688076669e-07 0 3.6915653260589344e-07 0 3.6916653260589345e-07 0.00021 3.6917653260589346e-07 0 3.6920632837529804e-07 0 3.6921632837529805e-07 0.00021 3.6922632837529806e-07 0 3.6922632837529806e-07 0 3.692363283752981e-07 0.00021 3.692463283752981e-07 0 3.692635624959796e-07 0 3.692735624959796e-07 0.00021 3.692835624959796e-07 0 3.6928828077388673e-07 0 3.6929828077388674e-07 0.00021 3.6930828077388675e-07 0 3.6933350585912915e-07 0 3.6934350585912917e-07 0.00021 3.693535058591292e-07 0 3.694436574858116e-07 0 3.694536574858116e-07 0.00021 3.694636574858116e-07 0 3.6976282450475934e-07 0 3.6977282450475936e-07 0.00021 3.6978282450475937e-07 0 3.6985052770047084e-07 0 3.6986052770047085e-07 0.00021 3.6987052770047086e-07 0 3.70093757974458e-07 0 3.70103757974458e-07 0.00021 3.7011375797445804e-07 0 3.7026682364292666e-07 0 3.7027682364292667e-07 0.00021 3.702868236429267e-07 0 3.702945617890966e-07 0 3.7030456178909664e-07 0.00021 3.7031456178909665e-07 0 3.703253823693181e-07 0 3.703353823693181e-07 0.00021 3.703453823693181e-07 0 3.7049261325654217e-07 0 3.705026132565422e-07 0.00021 3.705126132565422e-07 0 3.7061934067603056e-07 0 3.7062934067603057e-07 0.00021 3.706393406760306e-07 0 3.706393406760306e-07 0 3.706493406760306e-07 0.00021 3.706593406760306e-07 0 3.707515852462239e-07 0 3.707615852462239e-07 0.00021 3.707715852462239e-07 0 3.707715852462239e-07 0 3.707815852462239e-07 0.00021 3.7079158524622393e-07 0 3.708286349575706e-07 0 3.708386349575706e-07 0.00021 3.708486349575706e-07 0 3.708728675268166e-07 0 3.708828675268166e-07 0.00021 3.708928675268166e-07 0 3.7096582964638297e-07 0 3.70975829646383e-07 0.00021 3.70985829646383e-07 0 3.7112934016338377e-07 0 3.711393401633838e-07 0.00021 3.711493401633838e-07 0 3.711493401633838e-07 0 3.711593401633838e-07 0.00021 3.711693401633838e-07 0 3.712289238214351e-07 0 3.7123892382143513e-07 0.00021 3.7124892382143514e-07 0 3.714639594690962e-07 0 3.714739594690962e-07 0.00021 3.714839594690962e-07 0 3.7149949459430376e-07 0 3.7150949459430377e-07 0.00021 3.715194945943038e-07 0 3.716664013935275e-07 0 3.716764013935275e-07 0.00021 3.716864013935275e-07 0 3.716864013935275e-07 0 3.7169640139352753e-07 0.00021 3.7170640139352754e-07 0 3.718391393033602e-07 0 3.7184913930336023e-07 0.00021 3.7185913930336024e-07 0 3.720409361058176e-07 0 3.720509361058176e-07 0.00021 3.720609361058176e-07 0 3.7207385862405834e-07 0 3.7208385862405835e-07 0.00021 3.7209385862405836e-07 0 3.7212799877579856e-07 0 3.721379987757986e-07 0.00021 3.721479987757986e-07 0 3.7230682563077135e-07 0 3.7231682563077137e-07 0.00021 3.723268256307714e-07 0 3.7236221471203015e-07 0 3.7237221471203017e-07 0.00021 3.723822147120302e-07 0 3.7241399010081154e-07 0 3.7242399010081155e-07 0.00021 3.7243399010081156e-07 0 3.7243399010081156e-07 0 3.7244399010081157e-07 0.00021 3.724539901008116e-07 0 3.724539901008116e-07 0 3.724639901008116e-07 0.00021 3.724739901008116e-07 0 3.7255384880088476e-07 0 3.7256384880088477e-07 0.00021 3.725738488008848e-07 0 3.7266482341554635e-07 0 3.7267482341554636e-07 0.00021 3.7268482341554637e-07 0 3.727231171978672e-07 0 3.727331171978672e-07 0.00021 3.7274311719786723e-07 0 3.7276678748264293e-07 0 3.7277678748264295e-07 0.00021 3.7278678748264296e-07 0 3.727979886973501e-07 0 3.728079886973501e-07 0.00021 3.7281798869735014e-07 0 3.7291857307092455e-07 0 3.7292857307092456e-07 0.00021 3.7293857307092457e-07 0 3.7293857307092457e-07 0 3.729485730709246e-07 0.00021 3.729585730709246e-07 0 3.729585730709246e-07 0 3.729685730709246e-07 0.00021 3.729785730709246e-07 0 3.73037746833943e-07 0 3.73047746833943e-07 0.00021 3.73057746833943e-07 0 3.731216968784779e-07 0 3.731316968784779e-07 0.00021 3.731416968784779e-07 0 3.7321277922729813e-07 0 3.7322277922729814e-07 0.00021 3.7323277922729815e-07 0 3.7323373434673226e-07 0 3.7324373434673227e-07 0.00021 3.732537343467323e-07 0 3.735248225582246e-07 0 3.7353482255822463e-07 0.00021 3.7354482255822464e-07 0 3.7359938022984465e-07 0 3.7360938022984466e-07 0.00021 3.736193802298447e-07 0 3.736193802298447e-07 0 3.736293802298447e-07 0.00021 3.736393802298447e-07 0 3.73888559566268e-07 0 3.73898559566268e-07 0.00021 3.73908559566268e-07 0 3.7393340765202594e-07 0 3.7394340765202595e-07 0.00021 3.7395340765202596e-07 0 3.7398929252319177e-07 0 3.739992925231918e-07 0.00021 3.740092925231918e-07 0 3.740619161646295e-07 0 3.740719161646295e-07 0.00021 3.740819161646295e-07 0 3.741810656138914e-07 0 3.741910656138914e-07 0.00021 3.742010656138914e-07 0 3.7434278804611666e-07 0 3.7435278804611667e-07 0.00021 3.743627880461167e-07 0 3.74377016678193e-07 0 3.74387016678193e-07 0.00021 3.74397016678193e-07 0 3.7442611875469333e-07 0 3.7443611875469334e-07 0.00021 3.7444611875469335e-07 0 3.74481432290566e-07 0 3.74491432290566e-07 0.00021 3.74501432290566e-07 0 3.7457663980347644e-07 0 3.7458663980347645e-07 0.00021 3.7459663980347646e-07 0 3.747059363631329e-07 0 3.747159363631329e-07 0.00021 3.747259363631329e-07 0 3.747417998408806e-07 0 3.7475179984088063e-07 0.00021 3.7476179984088065e-07 0 3.7476179984088065e-07 0 3.7477179984088066e-07 0.00021 3.7478179984088067e-07 0 3.748581832600233e-07 0 3.7486818326002333e-07 0.00021 3.7487818326002334e-07 0 3.7497282425335915e-07 0 3.7498282425335916e-07 0.00021 3.7499282425335917e-07 0 3.750971108415382e-07 0 3.751071108415382e-07 0.00021 3.7511711084153823e-07 0 3.7515675248155083e-07 0 3.7516675248155084e-07 0.00021 3.7517675248155086e-07 0 3.7540822034821895e-07 0 3.7541822034821896e-07 0.00021 3.7542822034821897e-07 0 3.7551732527050394e-07 0 3.7552732527050395e-07 0.00021 3.7553732527050397e-07 0 3.7555748272219457e-07 0 3.755674827221946e-07 0.00021 3.755774827221946e-07 0 3.756632611915269e-07 0 3.756732611915269e-07 0.00021 3.756832611915269e-07 0 3.7587874408164196e-07 0 3.7588874408164197e-07 0.00021 3.75898744081642e-07 0 3.7602396905324137e-07 0 3.760339690532414e-07 0.00021 3.760439690532414e-07 0 3.760439690532414e-07 0 3.760539690532414e-07 0.00021 3.760639690532414e-07 0 3.760832458297303e-07 0 3.7609324582973033e-07 0.00021 3.7610324582973035e-07 0 3.7621694240462747e-07 0 3.762269424046275e-07 0.00021 3.762369424046275e-07 0 3.762369424046275e-07 0 3.762469424046275e-07 0.00021 3.762569424046275e-07 0 3.762569424046275e-07 0 3.762669424046275e-07 0.00021 3.7627694240462754e-07 0 3.7627694240462754e-07 0 3.7628694240462755e-07 0.00021 3.7629694240462756e-07 0 3.763664071010285e-07 0 3.763764071010285e-07 0.00021 3.763864071010285e-07 0 3.763864071010285e-07 0 3.7639640710102853e-07 0.00021 3.7640640710102854e-07 0 3.7655508382544307e-07 0 3.765650838254431e-07 0.00021 3.765750838254431e-07 0 3.766592705824141e-07 0 3.7666927058241413e-07 0.00021 3.7667927058241414e-07 0 3.7667927058241414e-07 0 3.7668927058241416e-07 0.00021 3.7669927058241417e-07 0 3.7669927058241417e-07 0 3.767092705824142e-07 0.00021 3.767192705824142e-07 0 3.7684280351132243e-07 0 3.7685280351132244e-07 0.00021 3.7686280351132245e-07 0 3.769490291707453e-07 0 3.769590291707453e-07 0.00021 3.769690291707453e-07 0 3.770705416776707e-07 0 3.770805416776707e-07 0.00021 3.770905416776707e-07 0 3.770943253299185e-07 0 3.771043253299185e-07 0.00021 3.771143253299185e-07 0 3.77147106755361e-07 0 3.77157106755361e-07 0.00021 3.77167106755361e-07 0 3.7718280595127703e-07 0 3.7719280595127704e-07 0.00021 3.7720280595127705e-07 0 3.772299401735175e-07 0 3.772399401735175e-07 0.00021 3.772499401735175e-07 0 3.774652053604219e-07 0 3.7747520536042193e-07 0.00021 3.7748520536042194e-07 0 3.7760847574270287e-07 0 3.776184757427029e-07 0.00021 3.776284757427029e-07 0 3.776284757427029e-07 0 3.776384757427029e-07 0.00021 3.776484757427029e-07 0 3.776484757427029e-07 0 3.7765847574270293e-07 0.00021 3.7766847574270294e-07 0 3.7773480167796833e-07 0 3.7774480167796834e-07 0.00021 3.7775480167796835e-07 0 3.7775480167796835e-07 0 3.7776480167796836e-07 0.00021 3.7777480167796837e-07 0 3.7777480167796837e-07 0 3.777848016779684e-07 0.00021 3.777948016779684e-07 0 3.777948016779684e-07 0 3.778048016779684e-07 0.00021 3.778148016779684e-07 0 3.778604986956214e-07 0 3.778704986956214e-07 0.00021 3.778804986956214e-07 0 3.7791678603322193e-07 0 3.7792678603322194e-07 0.00021 3.7793678603322195e-07 0 3.7793678603322195e-07 0 3.7794678603322196e-07 0.00021 3.77956786033222e-07 0 3.781108111149452e-07 0 3.781208111149452e-07 0.00021 3.781308111149452e-07 0 3.782604162920648e-07 0 3.7827041629206483e-07 0.00021 3.7828041629206484e-07 0 3.7828041629206484e-07 0 3.7829041629206486e-07 0.00021 3.7830041629206487e-07 0 3.7830041629206487e-07 0 3.783104162920649e-07 0.00021 3.783204162920649e-07 0 3.7836708019205113e-07 0 3.7837708019205114e-07 0.00021 3.7838708019205115e-07 0 3.786884741424373e-07 0 3.786984741424373e-07 0.00021 3.7870847414243733e-07 0 3.787793211656311e-07 0 3.787893211656311e-07 0.00021 3.787993211656311e-07 0 3.787993211656311e-07 0 3.788093211656311e-07 0.00021 3.788193211656311e-07 0 3.790401436138787e-07 0 3.790501436138787e-07 0.00021 3.790601436138787e-07 0 3.7907235104296566e-07 0 3.790823510429657e-07 0.00021 3.790923510429657e-07 0 3.791160501796579e-07 0 3.791260501796579e-07 0.00021 3.791360501796579e-07 0 3.791360501796579e-07 0 3.7914605017965793e-07 0.00021 3.7915605017965794e-07 0 3.791893356684595e-07 0 3.7919933566845953e-07 0.00021 3.7920933566845954e-07 0 3.7920933566845954e-07 0 3.7921933566845956e-07 0.00021 3.7922933566845957e-07 0 3.7923456505324304e-07 0 3.7924456505324305e-07 0.00021 3.7925456505324306e-07 0 3.7925456505324306e-07 0 3.792645650532431e-07 0.00021 3.792745650532431e-07 0 3.792745650532431e-07 0 3.792845650532431e-07 0.00021 3.792945650532431e-07 0 3.795547218467292e-07 0 3.795647218467292e-07 0.00021 3.795747218467292e-07 0 3.795747218467292e-07 0 3.795847218467292e-07 0.00021 3.7959472184672923e-07 0 3.7960734060706977e-07 0 3.796173406070698e-07 0.00021 3.796273406070698e-07 0 3.79720514757832e-07 0 3.79730514757832e-07 0.00021 3.79740514757832e-07 0 3.798089126971352e-07 0 3.798189126971352e-07 0.00021 3.798289126971352e-07 0 3.7994951314716265e-07 0 3.7995951314716266e-07 0.00021 3.7996951314716267e-07 0 3.799786508909892e-07 0 3.799886508909892e-07 0.00021 3.7999865089098923e-07 0 3.801263262766962e-07 0 3.801363262766962e-07 0.00021 3.801463262766962e-07 0 3.801875951600416e-07 0 3.801975951600416e-07 0.00021 3.8020759516004163e-07 0 3.8032196244060857e-07 0 3.803319624406086e-07 0.00021 3.803419624406086e-07 0 3.8037319506150794e-07 0 3.8038319506150795e-07 0.00021 3.8039319506150796e-07 0 3.8039319506150796e-07 0 3.8040319506150797e-07 0.00021 3.80413195061508e-07 0 3.80413195061508e-07 0 3.80423195061508e-07 0.00021 3.80433195061508e-07 0 3.8053436667947044e-07 0 3.8054436667947045e-07 0.00021 3.8055436667947047e-07 0 3.8055436667947047e-07 0 3.805643666794705e-07 0.00021 3.805743666794705e-07 0 3.8088795852359884e-07 0 3.8089795852359885e-07 0.00021 3.8090795852359886e-07 0 3.8099834346221673e-07 0 3.8100834346221674e-07 0.00021 3.8101834346221675e-07 0 3.8113492772305777e-07 0 3.811449277230578e-07 0.00021 3.811549277230578e-07 0 3.8120832106500343e-07 0 3.8121832106500344e-07 0.00021 3.8122832106500346e-07 0 3.812507018017952e-07 0 3.812607018017952e-07 0.00021 3.812707018017952e-07 0 3.813396326818548e-07 0 3.813496326818548e-07 0.00021 3.813596326818548e-07 0 3.814670117665576e-07 0 3.814770117665576e-07 0.00021 3.8148701176655764e-07 0 3.815052558521573e-07 0 3.815152558521573e-07 0.00021 3.8152525585215733e-07 0 3.815544080143865e-07 0 3.815644080143865e-07 0.00021 3.8157440801438653e-07 0 3.8176049331094393e-07 0 3.8177049331094394e-07 0.00021 3.8178049331094395e-07 0 3.819050351924925e-07 0 3.8191503519249254e-07 0.00021 3.8192503519249255e-07 0 3.819403888929135e-07 0 3.819503888929135e-07 0.00021 3.8196038889291354e-07 0 3.820396758641584e-07 0 3.820496758641584e-07 0.00021 3.820596758641584e-07 0 3.820675218934329e-07 0 3.8207752189343293e-07 0.00021 3.8208752189343294e-07 0 3.821088553354327e-07 0 3.8211885533543274e-07 0.00021 3.8212885533543275e-07 0 3.8212932117947015e-07 0 3.8213932117947017e-07 0.00021 3.821493211794702e-07 0 3.82257053833198e-07 0 3.82267053833198e-07 0.00021 3.82277053833198e-07 0 3.82277053833198e-07 0 3.82287053833198e-07 0.00021 3.82297053833198e-07 0 3.82297053833198e-07 0 3.8230705383319803e-07 0.00021 3.8231705383319804e-07 0 3.824538322705696e-07 0 3.824638322705696e-07 0.00021 3.8247383227056963e-07 0 3.8247383227056963e-07 0 3.8248383227056964e-07 0.00021 3.8249383227056965e-07 0 3.8267651260848976e-07 0 3.826865126084898e-07 0.00021 3.826965126084898e-07 0 3.829394962505314e-07 0 3.8294949625053143e-07 0.00021 3.8295949625053144e-07 0 3.829830430738229e-07 0 3.8299304307382294e-07 0.00021 3.8300304307382295e-07 0 3.8300304307382295e-07 0 3.8301304307382296e-07 0.00021 3.8302304307382297e-07 0 3.8302304307382297e-07 0 3.83033043073823e-07 0.00021 3.83043043073823e-07 0 3.8328675749118533e-07 0 3.8329675749118534e-07 0.00021 3.8330675749118535e-07 0 3.833903209381933e-07 0 3.8340032093819333e-07 0.00021 3.8341032093819335e-07 0 3.8344495880210964e-07 0 3.8345495880210965e-07 0.00021 3.8346495880210966e-07 0 3.8346495880210966e-07 0 3.8347495880210967e-07 0.00021 3.834849588021097e-07 0 3.836033019433679e-07 0 3.836133019433679e-07 0.00021 3.836233019433679e-07 0 3.8365107806678036e-07 0 3.8366107806678037e-07 0.00021 3.836710780667804e-07 0 3.838602939944124e-07 0 3.838702939944124e-07 0.00021 3.838802939944124e-07 0 3.840074839901182e-07 0 3.840174839901182e-07 0.00021 3.840274839901182e-07 0 3.841020770445271e-07 0 3.841120770445271e-07 0.00021 3.8412207704452714e-07 0 3.8422968955439935e-07 0 3.8423968955439936e-07 0.00021 3.8424968955439937e-07 0 3.8425472945890807e-07 0 3.842647294589081e-07 0.00021 3.842747294589081e-07 0 3.8428178934739487e-07 0 3.842917893473949e-07 0.00021 3.843017893473949e-07 0 3.84318487838147e-07 0 3.84328487838147e-07 0.00021 3.84338487838147e-07 0 3.8459436968747904e-07 0 3.8460436968747905e-07 0.00021 3.8461436968747907e-07 0 3.8461436968747907e-07 0 3.846243696874791e-07 0.00021 3.846343696874791e-07 0 3.846343696874791e-07 0 3.846443696874791e-07 0.00021 3.846543696874791e-07 0 3.846543696874791e-07 0 3.846643696874791e-07 0.00021 3.8467436968747913e-07 0 3.8467436968747913e-07 0 3.8468436968747914e-07 0.00021 3.8469436968747916e-07 0 3.8478425456550017e-07 0 3.847942545655002e-07 0.00021 3.848042545655002e-07 0 3.8482079710450074e-07 0 3.8483079710450075e-07 0.00021 3.8484079710450076e-07 0 3.848624047797267e-07 0 3.848724047797267e-07 0.00021 3.8488240477972673e-07 0 3.849046974579795e-07 0 3.849146974579795e-07 0.00021 3.849246974579795e-07 0 3.849246974579795e-07 0 3.8493469745797953e-07 0.00021 3.8494469745797954e-07 0 3.8498442247071786e-07 0 3.8499442247071787e-07 0.00021 3.850044224707179e-07 0 3.8505594417794493e-07 0 3.8506594417794494e-07 0.00021 3.8507594417794495e-07 0 3.8512827329308837e-07 0 3.851382732930884e-07 0.00021 3.851482732930884e-07 0 3.8515007445776835e-07 0 3.8516007445776836e-07 0.00021 3.8517007445776837e-07 0 3.853547832970919e-07 0 3.853647832970919e-07 0.00021 3.8537478329709194e-07 0 3.854717742283156e-07 0 3.854817742283156e-07 0.00021 3.8549177422831564e-07 0 3.8550056636913663e-07 0 3.8551056636913664e-07 0.00021 3.8552056636913666e-07 0 3.8552056636913666e-07 0 3.8553056636913667e-07 0.00021 3.855405663691367e-07 0 3.8562590961478067e-07 0 3.856359096147807e-07 0.00021 3.856459096147807e-07 0 3.856459096147807e-07 0 3.856559096147807e-07 0.00021 3.856659096147807e-07 0 3.856659096147807e-07 0 3.8567590961478073e-07 0.00021 3.8568590961478074e-07 0 3.85976931413223e-07 0 3.8598693141322303e-07 0.00021 3.8599693141322304e-07 0 3.860349092456908e-07 0 3.860449092456908e-07 0.00021 3.860549092456908e-07 0 3.8607259800413565e-07 0 3.8608259800413567e-07 0.00021 3.860925980041357e-07 0 3.862352987168679e-07 0 3.862452987168679e-07 0.00021 3.862552987168679e-07 0 3.863952561506976e-07 0 3.864052561506976e-07 0.00021 3.8641525615069763e-07 0 3.8641525615069763e-07 0 3.8642525615069764e-07 0.00021 3.8643525615069765e-07 0 3.8649102735666507e-07 0 3.865010273566651e-07 0.00021 3.865110273566651e-07 0 3.8651778753132727e-07 0 3.865277875313273e-07 0.00021 3.865377875313273e-07 0 3.8655339591446996e-07 0 3.8656339591447e-07 0.00021 3.8657339591447e-07 0 3.8657339591447e-07 0 3.8658339591447e-07 0.00021 3.8659339591447e-07 0 3.8659339591447e-07 0 3.8660339591447e-07 0.00021 3.8661339591447003e-07 0 3.8661339591447003e-07 0 3.8662339591447004e-07 0.00021 3.8663339591447005e-07 0 3.866900847574983e-07 0 3.867000847574983e-07 0.00021 3.867100847574983e-07 0 3.867100847574983e-07 0 3.8672008475749833e-07 0.00021 3.8673008475749835e-07 0 3.8673008475749835e-07 0 3.8674008475749836e-07 0.00021 3.8675008475749837e-07 0 3.8675008475749837e-07 0 3.867600847574984e-07 0.00021 3.867700847574984e-07 0 3.869840323061701e-07 0 3.8699403230617013e-07 0.00021 3.8700403230617014e-07 0 3.870247017509023e-07 0 3.8703470175090233e-07 0.00021 3.8704470175090234e-07 0 3.8704470175090234e-07 0 3.8705470175090235e-07 0.00021 3.8706470175090236e-07 0 3.871052879891962e-07 0 3.871152879891962e-07 0.00021 3.871252879891962e-07 0 3.871481476985907e-07 0 3.871581476985907e-07 0.00021 3.8716814769859073e-07 0 3.872040773093156e-07 0 3.8721407730931563e-07 0.00021 3.8722407730931564e-07 0 3.8728724189096396e-07 0 3.8729724189096397e-07 0.00021 3.87307241890964e-07 0 3.87307241890964e-07 0 3.87317241890964e-07 0.00021 3.87327241890964e-07 0 3.87327241890964e-07 0 3.87337241890964e-07 0.00021 3.8734724189096403e-07 0 3.8734724189096403e-07 0 3.8735724189096404e-07 0.00021 3.8736724189096405e-07 0 3.8742052141932826e-07 0 3.8743052141932827e-07 0.00021 3.874405214193283e-07 0 3.8744258291477285e-07 0 3.8745258291477286e-07 0.00021 3.8746258291477287e-07 0 3.874785827330669e-07 0 3.874885827330669e-07 0.00021 3.8749858273306693e-07 0 3.8749858273306693e-07 0 3.8750858273306694e-07 0.00021 3.8751858273306695e-07 0 3.8756424333696474e-07 0 3.8757424333696475e-07 0.00021 3.8758424333696476e-07 0 3.8758424333696476e-07 0 3.8759424333696477e-07 0.00021 3.876042433369648e-07 0 3.876042433369648e-07 0 3.876142433369648e-07 0.00021 3.876242433369648e-07 0 3.876468895214371e-07 0 3.876568895214371e-07 0.00021 3.876668895214371e-07 0 3.876668895214371e-07 0 3.876768895214371e-07 0.00021 3.876868895214371e-07 0 3.876868895214371e-07 0 3.8769688952143714e-07 0.00021 3.8770688952143715e-07 0 3.8770688952143715e-07 0 3.8771688952143716e-07 0.00021 3.8772688952143717e-07 0 3.8776614554348194e-07 0 3.8777614554348195e-07 0.00021 3.8778614554348196e-07 0 3.878611037234075e-07 0 3.878711037234075e-07 0.00021 3.878811037234075e-07 0 3.878811037234075e-07 0 3.8789110372340753e-07 0.00021 3.8790110372340754e-07 0 3.879059974651533e-07 0 3.879159974651533e-07 0.00021 3.879259974651533e-07 0 3.8808164483410267e-07 0 3.880916448341027e-07 0.00021 3.881016448341027e-07 0 3.881016448341027e-07 0 3.881116448341027e-07 0.00021 3.881216448341027e-07 0 3.881465538592345e-07 0 3.881565538592345e-07 0.00021 3.881665538592345e-07 0 3.881665538592345e-07 0 3.881765538592345e-07 0.00021 3.8818655385923454e-07 0 3.8818655385923454e-07 0 3.8819655385923455e-07 0.00021 3.8820655385923456e-07 0 3.882237918385442e-07 0 3.882337918385442e-07 0.00021 3.882437918385442e-07 0 3.882437918385442e-07 0 3.8825379183854423e-07 0.00021 3.8826379183854425e-07 0 3.8831341411142555e-07 0 3.8832341411142557e-07 0.00021 3.883334141114256e-07 0 3.883334141114256e-07 0 3.883434141114256e-07 0.00021 3.883534141114256e-07 0 3.883534141114256e-07 0 3.883634141114256e-07 0.00021 3.883734141114256e-07 0 3.883734141114256e-07 0 3.8838341411142563e-07 0.00021 3.8839341411142564e-07 0 3.8847616861812713e-07 0 3.8848616861812714e-07 0.00021 3.8849616861812715e-07 0 3.88521524798213e-07 0 3.88531524798213e-07 0.00021 3.88541524798213e-07 0 3.889740939001886e-07 0 3.889840939001886e-07 0.00021 3.889940939001886e-07 0 3.89084321305512e-07 0 3.8909432130551203e-07 0.00021 3.8910432130551204e-07 0 3.8915833621781545e-07 0 3.8916833621781546e-07 0.00021 3.8917833621781547e-07 0 3.892228909187633e-07 0 3.892328909187633e-07 0.00021 3.892428909187633e-07 0 3.892961269056015e-07 0 3.8930612690560153e-07 0.00021 3.8931612690560154e-07 0 3.8931612690560154e-07 0 3.8932612690560155e-07 0.00021 3.8933612690560156e-07 0 3.8933612690560156e-07 0 3.893461269056016e-07 0.00021 3.893561269056016e-07 0 3.8943152903518474e-07 0 3.8944152903518476e-07 0.00021 3.8945152903518477e-07 0 3.895248957095874e-07 0 3.895348957095874e-07 0.00021 3.895448957095874e-07 0 3.8993337528244606e-07 0 3.8994337528244607e-07 0.00021 3.899533752824461e-07 0 3.899643367946537e-07 0 3.899743367946537e-07 0.00021 3.899843367946537e-07 0 3.899843367946537e-07 0 3.899943367946537e-07 0.00021 3.9000433679465373e-07 0 3.900182854491177e-07 0 3.900282854491177e-07 0.00021 3.900382854491177e-07 0 3.902307557555788e-07 0 3.902407557555788e-07 0.00021 3.9025075575557883e-07 0 3.9028283710067923e-07 0 3.9029283710067924e-07 0.00021 3.9030283710067925e-07 0 3.9036247152799717e-07 0 3.903724715279972e-07 0.00021 3.903824715279972e-07 0 3.9042535674934355e-07 0 3.9043535674934356e-07 0.00021 3.9044535674934357e-07 0 3.904469945921361e-07 0 3.9045699459213613e-07 0.00021 3.9046699459213615e-07 0 3.905692012417048e-07 0 3.9057920124170483e-07 0.00021 3.9058920124170484e-07 0 3.9058920124170484e-07 0 3.9059920124170485e-07 0.00021 3.9060920124170486e-07 0 3.906366274357056e-07 0 3.906466274357056e-07 0.00021 3.906566274357056e-07 0 3.906566274357056e-07 0 3.9066662743570563e-07 0.00021 3.9067662743570564e-07 0 3.9075561450429113e-07 0 3.9076561450429115e-07 0.00021 3.9077561450429116e-07 0 3.908520672476308e-07 0 3.908620672476308e-07 0.00021 3.908720672476308e-07 0 3.909541789936468e-07 0 3.909641789936468e-07 0.00021 3.909741789936468e-07 0 3.909741789936468e-07 0 3.909841789936468e-07 0.00021 3.9099417899364683e-07 0 3.909991377615691e-07 0 3.910091377615691e-07 0.00021 3.9101913776156913e-07 0 3.910963320532496e-07 0 3.911063320532496e-07 0.00021 3.9111633205324963e-07 0 3.9134195816034764e-07 0 3.9135195816034765e-07 0.00021 3.9136195816034767e-07 0 3.914282529477869e-07 0 3.914382529477869e-07 0.00021 3.914482529477869e-07 0 3.9176748692242476e-07 0 3.9177748692242477e-07 0.00021 3.917874869224248e-07 0 3.917874869224248e-07 0 3.917974869224248e-07 0.00021 3.918074869224248e-07 0 3.921196846959393e-07 0 3.921296846959393e-07 0.00021 3.921396846959393e-07 0 3.924550172633543e-07 0 3.924650172633543e-07 0.00021 3.924750172633543e-07 0 3.9266638402276496e-07 0 3.9267638402276497e-07 0.00021 3.92686384022765e-07 0 3.927146393726118e-07 0 3.9272463937261184e-07 0.00021 3.9273463937261185e-07 0 3.929893937833037e-07 0 3.9299939378330373e-07 0.00021 3.9300939378330374e-07 0 3.930858378046654e-07 0 3.930958378046654e-07 0.00021 3.931058378046654e-07 0 3.931058378046654e-07 0 3.931158378046654e-07 0.00021 3.9312583780466543e-07 0 3.9312611748073463e-07 0 3.9313611748073464e-07 0.00021 3.9314611748073465e-07 0 3.931873888495649e-07 0 3.931973888495649e-07 0.00021 3.932073888495649e-07 0 3.9321122617559656e-07 0 3.9322122617559657e-07 0.00021 3.932312261755966e-07 0 3.9323615303146824e-07 0 3.9324615303146825e-07 0.00021 3.9325615303146826e-07 0 3.9329141743437544e-07 0 3.9330141743437545e-07 0.00021 3.9331141743437546e-07 0 3.934492443873421e-07 0 3.934592443873421e-07 0.00021 3.9346924438734213e-07 0 3.936936453534768e-07 0 3.9370364535347683e-07 0.00021 3.9371364535347684e-07 0 3.940625692573081e-07 0 3.940725692573081e-07 0.00021 3.940825692573081e-07 0 3.940825692573081e-07 0 3.9409256925730813e-07 0.00021 3.9410256925730814e-07 0 3.9410256925730814e-07 0 3.9411256925730815e-07 0.00021 3.9412256925730816e-07 0 3.9443782873900045e-07 0 3.9444782873900046e-07 0.00021 3.9445782873900047e-07 0 3.9446222219705746e-07 0 3.944722221970575e-07 0.00021 3.944822221970575e-07 0 3.945173401693481e-07 0 3.945273401693481e-07 0.00021 3.945373401693481e-07 0 3.9467258174536953e-07 0 3.9468258174536954e-07 0.00021 3.9469258174536955e-07 0 3.95002384200063e-07 0 3.95012384200063e-07 0.00021 3.95022384200063e-07 0 3.9508487603868703e-07 0 3.9509487603868704e-07 0.00021 3.9510487603868706e-07 0 3.9516358276020585e-07 0 3.9517358276020586e-07 0.00021 3.9518358276020587e-07 0 3.9526627496965044e-07 0 3.9527627496965046e-07 0.00021 3.9528627496965047e-07 0 3.953341586110793e-07 0 3.953441586110793e-07 0.00021 3.953541586110793e-07 0 3.953541586110793e-07 0 3.9536415861107933e-07 0.00021 3.9537415861107934e-07 0 3.953832506836661e-07 0 3.953932506836661e-07 0.00021 3.954032506836661e-07 0 3.9550146207638265e-07 0 3.9551146207638266e-07 0.00021 3.9552146207638267e-07 0 3.9553506302002194e-07 0 3.9554506302002196e-07 0.00021 3.9555506302002197e-07 0 3.9566898233468316e-07 0 3.9567898233468317e-07 0.00021 3.956889823346832e-07 0 3.9570480738834343e-07 0 3.9571480738834344e-07 0.00021 3.9572480738834345e-07 0 3.9589904951443295e-07 0 3.9590904951443296e-07 0.00021 3.9591904951443297e-07 0 3.959193538715534e-07 0 3.959293538715534e-07 0.00021 3.959393538715534e-07 0 3.95992779597573e-07 0 3.9600277959757303e-07 0.00021 3.9601277959757304e-07 0 3.960887261953076e-07 0 3.9609872619530763e-07 0.00021 3.9610872619530764e-07 0 3.9611191829327514e-07 0 3.9612191829327515e-07 0.00021 3.9613191829327516e-07 0 3.9620048893339784e-07 0 3.9621048893339785e-07 0.00021 3.9622048893339786e-07 0 3.9623974736596174e-07 0 3.9624974736596175e-07 0.00021 3.9625974736596176e-07 0 3.962663975008271e-07 0 3.9627639750082713e-07 0.00021 3.9628639750082715e-07 0 3.9636980111648827e-07 0 3.963798011164883e-07 0.00021 3.963898011164883e-07 0 3.9649039312131314e-07 0 3.9650039312131315e-07 0.00021 3.9651039312131316e-07 0 3.966362314215289e-07 0 3.966462314215289e-07 0.00021 3.966562314215289e-07 0 3.966562314215289e-07 0 3.966662314215289e-07 0.00021 3.966762314215289e-07 0 3.966762314215289e-07 0 3.9668623142152894e-07 0.00021 3.9669623142152895e-07 0 3.9671498979196056e-07 0 3.9672498979196057e-07 0.00021 3.967349897919606e-07 0 3.967349897919606e-07 0 3.967449897919606e-07 0.00021 3.967549897919606e-07 0 3.967737959120577e-07 0 3.967837959120577e-07 0.00021 3.967937959120577e-07 0 3.9690224394956904e-07 0 3.9691224394956905e-07 0.00021 3.9692224394956906e-07 0 3.9707467379142355e-07 0 3.9708467379142356e-07 0.00021 3.9709467379142357e-07 0 3.9709467379142357e-07 0 3.971046737914236e-07 0.00021 3.971146737914236e-07 0 3.9714479949738067e-07 0 3.971547994973807e-07 0.00021 3.971647994973807e-07 0 3.9717008807833043e-07 0 3.9718008807833045e-07 0.00021 3.9719008807833046e-07 0 3.9725535422244216e-07 0 3.9726535422244217e-07 0.00021 3.972753542224422e-07 0 3.9735867440458197e-07 0 3.97368674404582e-07 0.00021 3.97378674404582e-07 0 3.97378674404582e-07 0 3.97388674404582e-07 0.00021 3.97398674404582e-07 0 3.9753398570161104e-07 0 3.9754398570161105e-07 0.00021 3.9755398570161106e-07 0 3.976961110466437e-07 0 3.9770611104664373e-07 0.00021 3.9771611104664374e-07 0 3.977179341580998e-07 0 3.9772793415809984e-07 0.00021 3.9773793415809985e-07 0 3.9780433422443284e-07 0 3.9781433422443285e-07 0.00021 3.9782433422443286e-07 0 3.9792120278813554e-07 0 3.9793120278813555e-07 0.00021 3.9794120278813556e-07 0 3.9804014001748743e-07 0 3.9805014001748744e-07 0.00021 3.9806014001748746e-07 0 3.98060502868836e-07 0 3.9807050286883604e-07 0.00021 3.9808050286883605e-07 0 3.981434450481026e-07 0 3.9815344504810264e-07 0.00021 3.9816344504810265e-07 0 3.9824562414346956e-07 0 3.9825562414346957e-07 0.00021 3.982656241434696e-07 0 3.982656241434696e-07 0 3.982756241434696e-07 0.00021 3.982856241434696e-07 0 3.982856241434696e-07 0 3.982956241434696e-07 0.00021 3.983056241434696e-07 0 3.983138762047144e-07 0 3.9832387620471443e-07 0.00021 3.9833387620471444e-07 0 3.983962599654794e-07 0 3.984062599654794e-07 0.00021 3.984162599654794e-07 0 3.984162599654794e-07 0 3.984262599654794e-07 0.00021 3.9843625996547944e-07 0 3.9843625996547944e-07 0 3.9844625996547945e-07 0.00021 3.9845625996547946e-07 0 3.984570178724207e-07 0 3.984670178724207e-07 0.00021 3.9847701787242073e-07 0 3.9847701787242073e-07 0 3.9848701787242074e-07 0.00021 3.9849701787242076e-07 0 3.9849701787242076e-07 0 3.9850701787242077e-07 0.00021 3.985170178724208e-07 0 3.986392134168392e-07 0 3.986492134168392e-07 0.00021 3.986592134168392e-07 0 3.9867445445431906e-07 0 3.9868445445431907e-07 0.00021 3.986944544543191e-07 0 3.987479204969249e-07 0 3.9875792049692493e-07 0.00021 3.9876792049692494e-07 0 3.9887845721584485e-07 0 3.9888845721584486e-07 0.00021 3.9889845721584487e-07 0 3.9889845721584487e-07 0 3.989084572158449e-07 0.00021 3.989184572158449e-07 0 3.990074162304011e-07 0 3.990174162304011e-07 0.00021 3.990274162304011e-07 0 3.9915220868436846e-07 0 3.9916220868436847e-07 0.00021 3.991722086843685e-07 0 3.991988552282421e-07 0 3.992088552282421e-07 0.00021 3.992188552282421e-07 0 3.9945926146351435e-07 0 3.9946926146351436e-07 0.00021 3.9947926146351437e-07 0 3.995669894036179e-07 0 3.995769894036179e-07 0.00021 3.995869894036179e-07 0 3.996123261939957e-07 0 3.996223261939957e-07 0.00021 3.996323261939957e-07 0 3.9967534351790584e-07 0 3.9968534351790585e-07 0.00021 3.9969534351790586e-07 0 3.9969534351790586e-07 0 3.9970534351790587e-07 0.00021 3.997153435179059e-07 0 3.997153435179059e-07 0 3.997253435179059e-07 0.00021 3.997353435179059e-07 0 3.998105840402819e-07 0 3.998205840402819e-07 0.00021 3.998305840402819e-07 0 3.998849508289749e-07 0 3.998949508289749e-07 0.00021 3.9990495082897493e-07 0 3.999802128779117e-07 0 3.999902128779117e-07 0.00021 4.000002128779117e-07 0 4.000382276894048e-07 0 4.000482276894048e-07 0.00021 4.000582276894048e-07 0 4.000582276894048e-07 0 4.000682276894048e-07 0.00021 4.000782276894048e-07 0 4.000782276894048e-07 0 4.0008822768940483e-07 0.00021 4.0009822768940484e-07 0 4.0011038883595426e-07 0 4.001203888359543e-07 0.00021 4.001303888359543e-07 0 4.0031550734636705e-07 0 4.0032550734636706e-07 0.00021 4.003355073463671e-07 0 4.00415196281505e-07 0 4.0042519628150503e-07 0.00021 4.0043519628150504e-07 0 4.004729577500352e-07 0 4.004829577500352e-07 0.00021 4.004929577500352e-07 0 4.004929577500352e-07 0 4.0050295775003523e-07 0.00021 4.0051295775003524e-07 0 4.0051295775003524e-07 0 4.0052295775003526e-07 0.00021 4.0053295775003527e-07 0 4.0053295775003527e-07 0 4.005429577500353e-07 0.00021 4.005529577500353e-07 0 4.0061536892744695e-07 0 4.0062536892744696e-07 0.00021 4.0063536892744697e-07 0 4.0064227959555874e-07 0 4.0065227959555875e-07 0.00021 4.0066227959555876e-07 0 4.0068297731277614e-07 0 4.0069297731277615e-07 0.00021 4.0070297731277616e-07 0 4.0070632534549103e-07 0 4.0071632534549104e-07 0.00021 4.0072632534549105e-07 0 4.008285580433838e-07 0 4.008385580433838e-07 0.00021 4.008485580433838e-07 0 4.0091498620086e-07 0 4.0092498620086e-07 0.00021 4.0093498620086e-07 0 4.0093498620086e-07 0 4.0094498620086e-07 0.00021 4.0095498620086003e-07 0 4.011154247756795e-07 0 4.011254247756795e-07 0.00021 4.011354247756795e-07 0 4.0120700982353703e-07 0 4.0121700982353704e-07 0.00021 4.0122700982353705e-07 0 4.0124065779343457e-07 0 4.012506577934346e-07 0.00021 4.012606577934346e-07 0 4.013841728717679e-07 0 4.013941728717679e-07 0.00021 4.014041728717679e-07 0 4.0156025534737083e-07 0 4.0157025534737085e-07 0.00021 4.0158025534737086e-07 0 4.0176060383435645e-07 0 4.0177060383435646e-07 0.00021 4.0178060383435647e-07 0 4.019631867919201e-07 0 4.019731867919201e-07 0.00021 4.0198318679192013e-07 0 4.01996000846414e-07 0 4.02006000846414e-07 0.00021 4.02016000846414e-07 0 4.02016000846414e-07 0 4.0202600084641403e-07 0.00021 4.0203600084641405e-07 0 4.0203600084641405e-07 0 4.0204600084641406e-07 0.00021 4.0205600084641407e-07 0 4.020789097935487e-07 0 4.0208890979354873e-07 0.00021 4.0209890979354874e-07 0 4.02195034610146e-07 0 4.0220503461014603e-07 0.00021 4.0221503461014605e-07 0 4.022248123373853e-07 0 4.022348123373853e-07 0.00021 4.022448123373853e-07 0 4.0225207599218994e-07 0 4.0226207599218995e-07 0.00021 4.0227207599218996e-07 0 4.0236975538251164e-07 0 4.0237975538251165e-07 0.00021 4.0238975538251166e-07 0 4.0239471801411655e-07 0 4.0240471801411656e-07 0.00021 4.024147180141166e-07 0 4.024546825656817e-07 0 4.024646825656817e-07 0.00021 4.024746825656817e-07 0 4.024944398357252e-07 0 4.0250443983572524e-07 0.00021 4.0251443983572525e-07 0 4.0251747360027766e-07 0 4.025274736002777e-07 0.00021 4.025374736002777e-07 0 4.025374736002777e-07 0 4.025474736002777e-07 0.00021 4.025574736002777e-07 0 4.025574736002777e-07 0 4.025674736002777e-07 0.00021 4.0257747360027773e-07 0 4.0260486904377683e-07 0 4.0261486904377684e-07 0.00021 4.0262486904377685e-07 0 4.0262486904377685e-07 0 4.0263486904377687e-07 0.00021 4.026448690437769e-07 0 4.027241155765327e-07 0 4.027341155765327e-07 0.00021 4.0274411557653273e-07 0 4.027872315714591e-07 0 4.0279723157145914e-07 0.00021 4.0280723157145915e-07 0 4.0282228598012817e-07 0 4.028322859801282e-07 0.00021 4.028422859801282e-07 0 4.028710186837685e-07 0 4.028810186837685e-07 0.00021 4.0289101868376853e-07 0 4.029030109170535e-07 0 4.029130109170535e-07 0.00021 4.0292301091705353e-07 0 4.031243964829135e-07 0 4.031343964829135e-07 0.00021 4.031443964829135e-07 0 4.0314916756801056e-07 0 4.0315916756801057e-07 0.00021 4.031691675680106e-07 0 4.032077838249274e-07 0 4.0321778382492744e-07 0.00021 4.0322778382492745e-07 0 4.032304557686226e-07 0 4.032404557686226e-07 0.00021 4.032504557686226e-07 0 4.032778573197731e-07 0 4.032878573197731e-07 0.00021 4.032978573197731e-07 0 4.032978573197731e-07 0 4.0330785731977313e-07 0.00021 4.0331785731977314e-07 0 4.033681492014274e-07 0 4.033781492014274e-07 0.00021 4.033881492014274e-07 0 4.0354238692656495e-07 0 4.0355238692656496e-07 0.00021 4.0356238692656497e-07 0 4.0359396542319403e-07 0 4.0360396542319404e-07 0.00021 4.0361396542319405e-07 0 4.0362195245598e-07 0 4.0363195245598e-07 0.00021 4.0364195245598004e-07 0 4.038103780509272e-07 0 4.038203780509272e-07 0.00021 4.038303780509272e-07 0 4.038548268655591e-07 0 4.038648268655591e-07 0.00021 4.038748268655591e-07 0 4.0400956989371955e-07 0 4.0401956989371956e-07 0.00021 4.040295698937196e-07 0 4.040295698937196e-07 0 4.040395698937196e-07 0.00021 4.040495698937196e-07 0 4.040495698937196e-07 0 4.040595698937196e-07 0.00021 4.040695698937196e-07 0 4.040695698937196e-07 0 4.0407956989371963e-07 0.00021 4.0408956989371964e-07 0 4.0424187249130334e-07 0 4.0425187249130335e-07 0.00021 4.0426187249130337e-07 0 4.0427733590115236e-07 0 4.0428733590115237e-07 0.00021 4.042973359011524e-07 0 4.044133519997639e-07 0 4.044233519997639e-07 0.00021 4.044333519997639e-07 0 4.046118785798011e-07 0 4.046218785798011e-07 0.00021 4.046318785798011e-07 0 4.047122792341981e-07 0 4.047222792341981e-07 0.00021 4.047322792341981e-07 0 4.047322792341981e-07 0 4.047422792341981e-07 0.00021 4.0475227923419813e-07 0 4.0484890610603553e-07 0 4.0485890610603554e-07 0.00021 4.0486890610603556e-07 0 4.049432942134308e-07 0 4.0495329421343083e-07 0.00021 4.0496329421343084e-07 0 4.0500424831043407e-07 0 4.050142483104341e-07 0.00021 4.050242483104341e-07 0 4.0503685804867233e-07 0 4.0504685804867234e-07 0.00021 4.0505685804867235e-07 0 4.0505685804867235e-07 0 4.0506685804867236e-07 0.00021 4.050768580486724e-07 0 4.050768580486724e-07 0 4.050868580486724e-07 0.00021 4.050968580486724e-07 0 4.0519362697499926e-07 0 4.0520362697499927e-07 0.00021 4.052136269749993e-07 0 4.052358017426983e-07 0 4.052458017426983e-07 0.00021 4.052558017426983e-07 0 4.0533165140761613e-07 0 4.0534165140761614e-07 0.00021 4.0535165140761615e-07 0 4.053611555393211e-07 0 4.053711555393211e-07 0.00021 4.053811555393211e-07 0 4.0547458817277144e-07 0 4.0548458817277145e-07 0.00021 4.0549458817277146e-07 0 4.0553440561255093e-07 0 4.0554440561255094e-07 0.00021 4.0555440561255095e-07 0 4.05606514051125e-07 0 4.05616514051125e-07 0.00021 4.05626514051125e-07 0 4.0563625610906777e-07 0 4.056462561090678e-07 0.00021 4.056562561090678e-07 0 4.056793065580274e-07 0 4.056893065580274e-07 0.00021 4.0569930655802743e-07 0 4.057024581704928e-07 0 4.057124581704928e-07 0.00021 4.0572245817049284e-07 0 4.0572245817049284e-07 0 4.0573245817049285e-07 0.00021 4.0574245817049286e-07 0 4.0583315255979214e-07 0 4.0584315255979215e-07 0.00021 4.0585315255979216e-07 0 4.058695370491372e-07 0 4.058795370491372e-07 0.00021 4.0588953704913723e-07 0 4.0592107718143114e-07 0 4.0593107718143115e-07 0.00021 4.0594107718143116e-07 0 4.05941904400344e-07 0 4.05951904400344e-07 0.00021 4.05961904400344e-07 0 4.05961904400344e-07 0 4.0597190440034403e-07 0.00021 4.0598190440034405e-07 0 4.060048194120626e-07 0 4.060148194120626e-07 0.00021 4.060248194120626e-07 0 4.0604305591414503e-07 0 4.0605305591414504e-07 0.00021 4.0606305591414505e-07 0 4.0606305591414505e-07 0 4.0607305591414506e-07 0.00021 4.0608305591414507e-07 0 4.061088353698123e-07 0 4.061188353698123e-07 0.00021 4.061288353698123e-07 0 4.06129088961188e-07 0 4.0613908896118804e-07 0.00021 4.0614908896118805e-07 0 4.0618391482542663e-07 0 4.0619391482542664e-07 0.00021 4.0620391482542665e-07 0 4.062496346542731e-07 0 4.062596346542731e-07 0.00021 4.062696346542731e-07 0 4.06354693225816e-07 0 4.06364693225816e-07 0.00021 4.06374693225816e-07 0 4.064466779685957e-07 0 4.064566779685957e-07 0.00021 4.064666779685957e-07 0 4.064666779685957e-07 0 4.064766779685957e-07 0.00021 4.064866779685957e-07 0 4.065230480291601e-07 0 4.0653304802916014e-07 0.00021 4.0654304802916015e-07 0 4.0664581492467756e-07 0 4.0665581492467757e-07 0.00021 4.066658149246776e-07 0 4.068229761234126e-07 0 4.068329761234126e-07 0.00021 4.068429761234126e-07 0 4.0684954945731846e-07 0 4.0685954945731847e-07 0.00021 4.068695494573185e-07 0 4.0695257269456e-07 0 4.0696257269456003e-07 0.00021 4.0697257269456004e-07 0 4.0697257269456004e-07 0 4.0698257269456005e-07 0.00021 4.0699257269456006e-07 0 4.070055740921632e-07 0 4.070155740921632e-07 0.00021 4.070255740921632e-07 0 4.070660843879982e-07 0 4.070760843879982e-07 0.00021 4.070860843879982e-07 0 4.072399834343779e-07 0 4.072499834343779e-07 0.00021 4.072599834343779e-07 0 4.072972562063415e-07 0 4.073072562063415e-07 0.00021 4.0731725620634154e-07 0 4.0731725620634154e-07 0 4.0732725620634155e-07 0.00021 4.0733725620634156e-07 0 4.073741360447627e-07 0 4.0738413604476273e-07 0.00021 4.0739413604476275e-07 0 4.074731105315624e-07 0 4.074831105315624e-07 0.00021 4.074931105315624e-07 0 4.074931105315624e-07 0 4.0750311053156243e-07 0.00021 4.0751311053156244e-07 0 4.0751762479883513e-07 0 4.0752762479883514e-07 0.00021 4.0753762479883515e-07 0 4.0771481552318317e-07 0 4.077248155231832e-07 0.00021 4.077348155231832e-07 0 4.07764361375792e-07 0 4.07774361375792e-07 0.00021 4.07784361375792e-07 0 4.078837073774432e-07 0 4.078937073774432e-07 0.00021 4.079037073774432e-07 0 4.079124046205025e-07 0 4.079224046205025e-07 0.00021 4.079324046205025e-07 0 4.079324046205025e-07 0 4.0794240462050253e-07 0.00021 4.0795240462050254e-07 0 4.080146337033018e-07 0 4.0802463370330183e-07 0.00021 4.0803463370330184e-07 0 4.080607981955059e-07 0 4.080707981955059e-07 0.00021 4.080807981955059e-07 0 4.080877284380875e-07 0 4.0809772843808753e-07 0.00021 4.0810772843808754e-07 0 4.081279017422257e-07 0 4.081379017422257e-07 0.00021 4.081479017422257e-07 0 4.081758239755866e-07 0 4.081858239755866e-07 0.00021 4.081958239755866e-07 0 4.082353131174027e-07 0 4.082453131174027e-07 0.00021 4.082553131174027e-07 0 4.0834283318925307e-07 0 4.083528331892531e-07 0.00021 4.083628331892531e-07 0 4.083628331892531e-07 0 4.083728331892531e-07 0.00021 4.083828331892531e-07 0 4.0845932557460204e-07 0 4.0846932557460205e-07 0.00021 4.0847932557460206e-07 0 4.0852874672047386e-07 0 4.0853874672047387e-07 0.00021 4.085487467204739e-07 0 4.0867461134055147e-07 0 4.086846113405515e-07 0.00021 4.086946113405515e-07 0 4.086946113405515e-07 0 4.087046113405515e-07 0.00021 4.087146113405515e-07 0 4.0893477382143847e-07 0 4.089447738214385e-07 0.00021 4.089547738214385e-07 0 4.0910673504662557e-07 0 4.091167350466256e-07 0.00021 4.091267350466256e-07 0 4.091267350466256e-07 0 4.091367350466256e-07 0.00021 4.091467350466256e-07 0 4.093236855477613e-07 0 4.0933368554776133e-07 0.00021 4.0934368554776134e-07 0 4.0940404938322436e-07 0 4.0941404938322437e-07 0.00021 4.094240493832244e-07 0 4.094969148783998e-07 0 4.095069148783998e-07 0.00021 4.095169148783998e-07 0 4.0975394461400004e-07 0 4.0976394461400005e-07 0.00021 4.0977394461400006e-07 0 4.09844605910268e-07 0 4.09854605910268e-07 0.00021 4.09864605910268e-07 0 4.0987301435974556e-07 0 4.098830143597456e-07 0.00021 4.098930143597456e-07 0 4.0989351971289536e-07 0 4.0990351971289537e-07 0.00021 4.099135197128954e-07 0 4.099135197128954e-07 0 4.099235197128954e-07 0.00021 4.099335197128954e-07 0 4.101555575528806e-07 0 4.101655575528806e-07 0.00021 4.101755575528806e-07 0 4.102658635225336e-07 0 4.102758635225336e-07 0.00021 4.102858635225336e-07 0 4.104463107201094e-07 0 4.104563107201094e-07 0.00021 4.104663107201094e-07 0 4.1048858399924616e-07 0 4.1049858399924617e-07 0.00021 4.105085839992462e-07 0 4.105571533743489e-07 0 4.105671533743489e-07 0.00021 4.105771533743489e-07 0 4.105771533743489e-07 0 4.1058715337434893e-07 0.00021 4.1059715337434894e-07 0 4.1063250413572924e-07 0 4.1064250413572925e-07 0.00021 4.1065250413572927e-07 0 4.108109271384346e-07 0 4.108209271384346e-07 0.00021 4.108309271384346e-07 0 4.1086824051854795e-07 0 4.1087824051854796e-07 0.00021 4.10888240518548e-07 0 4.111205298887014e-07 0 4.111305298887014e-07 0.00021 4.1114052988870144e-07 0 4.1123752588033086e-07 0 4.1124752588033087e-07 0.00021 4.112575258803309e-07 0 4.112586399428742e-07 0 4.112686399428742e-07 0.00021 4.112786399428742e-07 0 4.1132628272291803e-07 0 4.1133628272291805e-07 0.00021 4.1134628272291806e-07 0 4.1136313765069484e-07 0 4.1137313765069485e-07 0.00021 4.1138313765069486e-07 0 4.114638071927958e-07 0 4.1147380719279583e-07 0.00021 4.1148380719279584e-07 0 4.11594614519306e-07 0 4.11604614519306e-07 0.00021 4.11614614519306e-07 0 4.11691706004995e-07 0 4.11701706004995e-07 0.00021 4.11711706004995e-07 0 4.117477554985749e-07 0 4.117577554985749e-07 0.00021 4.117677554985749e-07 0 4.118582548911209e-07 0 4.118682548911209e-07 0.00021 4.1187825489112093e-07 0 4.1187825489112093e-07 0 4.1188825489112094e-07 0.00021 4.1189825489112095e-07 0 4.119253627675351e-07 0 4.119353627675351e-07 0.00021 4.1194536276753514e-07 0 4.120153832810105e-07 0 4.1202538328101054e-07 0.00021 4.1203538328101055e-07 0 4.1203538328101055e-07 0 4.1204538328101056e-07 0.00021 4.1205538328101057e-07 0 4.120636974568956e-07 0 4.1207369745689563e-07 0.00021 4.1208369745689565e-07 0 4.1217081980921877e-07 0 4.121808198092188e-07 0.00021 4.121908198092188e-07 0 4.12352593063038e-07 0 4.12362593063038e-07 0.00021 4.12372593063038e-07 0 4.125063202925545e-07 0 4.125163202925545e-07 0.00021 4.1252632029255453e-07 0 4.1260507525995083e-07 0 4.1261507525995084e-07 0.00021 4.1262507525995085e-07 0 4.126708048122641e-07 0 4.126808048122641e-07 0.00021 4.1269080481226413e-07 0 4.127528529196983e-07 0 4.1276285291969834e-07 0.00021 4.1277285291969835e-07 0 4.1278518086998004e-07 0 4.1279518086998005e-07 0.00021 4.1280518086998006e-07 0 4.128484622565317e-07 0 4.128584622565317e-07 0.00021 4.128684622565317e-07 0 4.130196224932012e-07 0 4.1302962249320123e-07 0.00021 4.1303962249320124e-07 0 4.130630633441997e-07 0 4.130730633441997e-07 0.00021 4.130830633441997e-07 0 4.131443144886125e-07 0 4.131543144886125e-07 0.00021 4.131643144886125e-07 0 4.1338753618078556e-07 0 4.1339753618078557e-07 0.00021 4.134075361807856e-07 0 4.13515961785301e-07 0 4.13525961785301e-07 0.00021 4.13535961785301e-07 0 4.13589296023189e-07 0 4.13599296023189e-07 0.00021 4.13609296023189e-07 0 4.13609296023189e-07 0 4.13619296023189e-07 0.00021 4.1362929602318903e-07 0 4.1362929602318903e-07 0 4.1363929602318904e-07 0.00021 4.1364929602318905e-07 0 4.1364929602318905e-07 0 4.1365929602318906e-07 0.00021 4.136692960231891e-07 0 4.137753300939894e-07 0 4.137853300939894e-07 0.00021 4.1379533009398944e-07 0 4.138006141492578e-07 0 4.138106141492578e-07 0.00021 4.1382061414925783e-07 0 4.138241717460094e-07 0 4.1383417174600943e-07 0.00021 4.1384417174600944e-07 0 4.1384867962122475e-07 0 4.1385867962122476e-07 0.00021 4.138686796212248e-07 0 4.1387202272418444e-07 0 4.1388202272418445e-07 0.00021 4.1389202272418446e-07 0 4.139750463567376e-07 0 4.139850463567376e-07 0.00021 4.139950463567376e-07 0 4.1405710725822247e-07 0 4.140671072582225e-07 0.00021 4.140771072582225e-07 0 4.1438797453506897e-07 0 4.14397974535069e-07 0.00021 4.14407974535069e-07 0 4.1447614334864107e-07 0 4.144861433486411e-07 0.00021 4.144961433486411e-07 0 4.146152601838353e-07 0 4.1462526018383533e-07 0.00021 4.1463526018383534e-07 0 4.146881940435524e-07 0 4.146981940435524e-07 0.00021 4.147081940435524e-07 0 4.147125670113839e-07 0 4.147225670113839e-07 0.00021 4.147325670113839e-07 0 4.147325670113839e-07 0 4.147425670113839e-07 0.00021 4.1475256701138394e-07 0 4.1481203996827473e-07 0 4.1482203996827474e-07 0.00021 4.1483203996827476e-07 0 4.150488381015592e-07 0 4.1505883810155923e-07 0.00021 4.1506883810155924e-07 0 4.1506883810155924e-07 0 4.1507883810155925e-07 0.00021 4.1508883810155926e-07 0 4.1509443102774475e-07 0 4.1510443102774476e-07 0.00021 4.1511443102774477e-07 0 4.1511443102774477e-07 0 4.151244310277448e-07 0.00021 4.151344310277448e-07 0 4.151477526232323e-07 0 4.151577526232323e-07 0.00021 4.151677526232323e-07 0 4.1522768914282884e-07 0 4.1523768914282885e-07 0.00021 4.1524768914282886e-07 0 4.152980057475038e-07 0 4.153080057475038e-07 0.00021 4.1531800574750383e-07 0 4.1531800574750383e-07 0 4.1532800574750384e-07 0.00021 4.1533800574750385e-07 0 4.153397168385364e-07 0 4.153497168385364e-07 0.00021 4.153597168385364e-07 0 4.154263968425014e-07 0 4.154363968425014e-07 0.00021 4.154463968425014e-07 0 4.1547016491305166e-07 0 4.1548016491305167e-07 0.00021 4.154901649130517e-07 0 4.154901649130517e-07 0 4.155001649130517e-07 0.00021 4.155101649130517e-07 0 4.1553210091688544e-07 0 4.1554210091688545e-07 0.00021 4.1555210091688546e-07 0 4.15719294112139e-07 0 4.15729294112139e-07 0.00021 4.1573929411213903e-07 0 4.158458987077802e-07 0 4.158558987077802e-07 0.00021 4.1586589870778023e-07 0 4.1591439461506406e-07 0 4.1592439461506407e-07 0.00021 4.159343946150641e-07 0 4.15936152195025e-07 0 4.1594615219502503e-07 0.00021 4.1595615219502504e-07 0 4.159737792381757e-07 0 4.159837792381757e-07 0.00021 4.159937792381757e-07 0 4.16116261324759e-07 0 4.16126261324759e-07 0.00021 4.16136261324759e-07 0 4.1626361666142673e-07 0 4.1627361666142674e-07 0.00021 4.1628361666142675e-07 0 4.1639557403551607e-07 0 4.164055740355161e-07 0.00021 4.164155740355161e-07 0 4.1674194513895875e-07 0 4.1675194513895876e-07 0.00021 4.1676194513895877e-07 0 4.1682612435339906e-07 0 4.168361243533991e-07 0.00021 4.168461243533991e-07 0 4.1692664590289236e-07 0 4.1693664590289237e-07 0.00021 4.169466459028924e-07 0 4.169500896951432e-07 0 4.169600896951432e-07 0.00021 4.169700896951432e-07 0 4.1700914246565807e-07 0 4.170191424656581e-07 0.00021 4.170291424656581e-07 0 4.1704789392817116e-07 0 4.1705789392817117e-07 0.00021 4.170678939281712e-07 0 4.170936123570607e-07 0 4.171036123570607e-07 0.00021 4.1711361235706074e-07 0 4.172733241737075e-07 0 4.1728332417370753e-07 0.00021 4.1729332417370755e-07 0 4.1729332417370755e-07 0 4.1730332417370756e-07 0.00021 4.1731332417370757e-07 0 4.173488862098242e-07 0 4.173588862098242e-07 0.00021 4.173688862098242e-07 0 4.1748136356874903e-07 0 4.1749136356874904e-07 0.00021 4.1750136356874905e-07 0 4.1750136356874905e-07 0 4.1751136356874907e-07 0.00021 4.175213635687491e-07 0 4.175636128536059e-07 0 4.175736128536059e-07 0.00021 4.175836128536059e-07 0 4.1758630240188966e-07 0 4.1759630240188967e-07 0.00021 4.176063024018897e-07 0 4.176074049656648e-07 0 4.176174049656648e-07 0.00021 4.176274049656648e-07 0 4.176530186926985e-07 0 4.176630186926985e-07 0.00021 4.176730186926985e-07 0 4.1776136479496173e-07 0 4.1777136479496174e-07 0.00021 4.1778136479496175e-07 0 4.1781745864532387e-07 0 4.178274586453239e-07 0.00021 4.178374586453239e-07 0 4.178374586453239e-07 0 4.178474586453239e-07 0.00021 4.178574586453239e-07 0 4.1810015415052977e-07 0 4.181101541505298e-07 0.00021 4.181201541505298e-07 0 4.181443932472139e-07 0 4.181543932472139e-07 0.00021 4.181643932472139e-07 0 4.1854901588340076e-07 0 4.1855901588340077e-07 0.00021 4.185690158834008e-07 0 4.1857863366056134e-07 0 4.1858863366056135e-07 0.00021 4.1859863366056136e-07 0 4.1861555378023925e-07 0 4.1862555378023926e-07 0.00021 4.186355537802393e-07 0 4.1868765525991515e-07 0 4.1869765525991516e-07 0.00021 4.1870765525991517e-07 0 4.18763114898607e-07 0 4.18773114898607e-07 0.00021 4.18783114898607e-07 0 4.1882995523048634e-07 0 4.1883995523048635e-07 0.00021 4.1884995523048636e-07 0 4.1884995523048636e-07 0 4.188599552304864e-07 0.00021 4.188699552304864e-07 0 4.1888605842563253e-07 0 4.1889605842563254e-07 0.00021 4.1890605842563255e-07 0 4.190235199975666e-07 0 4.190335199975666e-07 0.00021 4.190435199975666e-07 0 4.1910157973063347e-07 0 4.191115797306335e-07 0.00021 4.191215797306335e-07 0 4.1918526056760424e-07 0 4.1919526056760425e-07 0.00021 4.1920526056760426e-07 0 4.1921770332406977e-07 0 4.192277033240698e-07 0.00021 4.192377033240698e-07 0 4.192690392541827e-07 0 4.192790392541827e-07 0.00021 4.1928903925418273e-07 0 4.1931186725586066e-07 0 4.1932186725586067e-07 0.00021 4.193318672558607e-07 0 4.194324318202712e-07 0 4.194424318202712e-07 0.00021 4.194524318202712e-07 0 4.1964089756436835e-07 0 4.1965089756436837e-07 0.00021 4.196608975643684e-07 0 4.196608975643684e-07 0 4.196708975643684e-07 0.00021 4.196808975643684e-07 0 4.1976560609269373e-07 0 4.1977560609269374e-07 0.00021 4.1978560609269375e-07 0 4.1992088168126207e-07 0 4.199308816812621e-07 0.00021 4.199408816812621e-07 0 4.2022020958528447e-07 0 4.202302095852845e-07 0.00021 4.202402095852845e-07 0 4.203406567485848e-07 0 4.203506567485848e-07 0.00021 4.2036065674858483e-07 0 4.203756234990814e-07 0 4.203856234990814e-07 0.00021 4.2039562349908143e-07 0 4.2039562349908143e-07 0 4.2040562349908144e-07 0.00021 4.2041562349908145e-07 0 4.2043983078164967e-07 0 4.204498307816497e-07 0.00021 4.204598307816497e-07 0 4.205192164419221e-07 0 4.205292164419221e-07 0.00021 4.205392164419221e-07 0 4.206071866016153e-07 0 4.206171866016153e-07 0.00021 4.206271866016153e-07 0 4.206271866016153e-07 0 4.206371866016153e-07 0.00021 4.206471866016153e-07 0 4.206471866016153e-07 0 4.2065718660161533e-07 0.00021 4.2066718660161535e-07 0 4.2066718660161535e-07 0 4.2067718660161536e-07 0.00021 4.2068718660161537e-07 0 4.2070710578565593e-07 0 4.2071710578565594e-07 0.00021 4.2072710578565595e-07 0 4.2072710578565595e-07 0 4.2073710578565596e-07 0.00021 4.2074710578565597e-07 0 4.2074710578565597e-07 0 4.20757105785656e-07 0.00021 4.20767105785656e-07 0 4.208896642706264e-07 0 4.208996642706264e-07 0.00021 4.209096642706264e-07 0 4.209096642706264e-07 0 4.2091966427062643e-07 0.00021 4.2092966427062644e-07 0 4.2094509436098047e-07 0 4.209550943609805e-07 0.00021 4.209650943609805e-07 0 4.2098391597186497e-07 0 4.20993915971865e-07 0.00021 4.21003915971865e-07 0 4.210572756536644e-07 0 4.210672756536644e-07 0.00021 4.210772756536644e-07 0 4.2115191736023337e-07 0 4.211619173602334e-07 0.00021 4.211719173602334e-07 0 4.212248285571354e-07 0 4.212348285571354e-07 0.00021 4.212448285571354e-07 0 4.212448285571354e-07 0 4.212548285571354e-07 0.00021 4.2126482855713544e-07 0 4.2130787919061655e-07 0 4.2131787919061656e-07 0.00021 4.2132787919061657e-07 0 4.214031232675445e-07 0 4.2141312326754453e-07 0.00021 4.2142312326754454e-07 0 4.2148373694918786e-07 0 4.2149373694918787e-07 0.00021 4.215037369491879e-07 0 4.2166911691004877e-07 0 4.216791169100488e-07 0.00021 4.216891169100488e-07 0 4.216916158457454e-07 0 4.217016158457454e-07 0.00021 4.217116158457454e-07 0 4.2171267867404395e-07 0 4.2172267867404396e-07 0.00021 4.2173267867404397e-07 0 4.2173267867404397e-07 0 4.21742678674044e-07 0.00021 4.21752678674044e-07 0 4.218836347076221e-07 0 4.218936347076221e-07 0.00021 4.219036347076221e-07 0 4.2209486367890326e-07 0 4.2210486367890327e-07 0.00021 4.221148636789033e-07 0 4.221148636789033e-07 0 4.221248636789033e-07 0.00021 4.221348636789033e-07 0 4.221399549262358e-07 0 4.221499549262358e-07 0.00021 4.2215995492623583e-07 0 4.222247450243411e-07 0 4.2223474502434113e-07 0.00021 4.2224474502434114e-07 0 4.223470982930653e-07 0 4.223570982930653e-07 0.00021 4.223670982930653e-07 0 4.224395064261527e-07 0 4.224495064261527e-07 0.00021 4.224595064261527e-07 0 4.224718305902759e-07 0 4.224818305902759e-07 0.00021 4.224918305902759e-07 0 4.224918305902759e-07 0 4.225018305902759e-07 0.00021 4.2251183059027594e-07 0 4.225813644346937e-07 0 4.225913644346937e-07 0.00021 4.226013644346937e-07 0 4.226238367843483e-07 0 4.226338367843483e-07 0.00021 4.226438367843483e-07 0 4.227780004336061e-07 0 4.227880004336061e-07 0.00021 4.227980004336061e-07 0 4.2297391008915586e-07 0 4.2298391008915587e-07 0.00021 4.229939100891559e-07 0 4.230756730731396e-07 0 4.230856730731396e-07 0.00021 4.230956730731396e-07 0 4.230956730731396e-07 0 4.231056730731396e-07 0.00021 4.231156730731396e-07 0 4.231211180852615e-07 0 4.231311180852615e-07 0.00021 4.2314111808526154e-07 0 4.2316147548745866e-07 0 4.231714754874587e-07 0.00021 4.231814754874587e-07 0 4.231814754874587e-07 0 4.231914754874587e-07 0.00021 4.232014754874587e-07 0 4.2323047872675474e-07 0 4.2324047872675476e-07 0.00021 4.2325047872675477e-07 0 4.233643929777346e-07 0 4.233743929777346e-07 0.00021 4.233843929777346e-07 0 4.2353481309584487e-07 0 4.235448130958449e-07 0.00021 4.235548130958449e-07 0 4.2357906870792726e-07 0 4.2358906870792727e-07 0.00021 4.235990687079273e-07 0 4.2360931841281636e-07 0 4.236193184128164e-07 0.00021 4.236293184128164e-07 0 4.236602520021076e-07 0 4.236702520021076e-07 0.00021 4.2368025200210764e-07 0 4.237162077629303e-07 0 4.237262077629303e-07 0.00021 4.237362077629303e-07 0 4.237362077629303e-07 0 4.2374620776293033e-07 0.00021 4.2375620776293034e-07 0 4.2375859698261716e-07 0 4.2376859698261717e-07 0.00021 4.237785969826172e-07 0 4.2384640859269327e-07 0 4.238564085926933e-07 0.00021 4.238664085926933e-07 0 4.2395899967759567e-07 0 4.239689996775957e-07 0.00021 4.239789996775957e-07 0 4.2401312644509973e-07 0 4.2402312644509974e-07 0.00021 4.2403312644509975e-07 0 4.243340912052802e-07 0 4.243440912052802e-07 0.00021 4.243540912052802e-07 0 4.2435532196371654e-07 0 4.2436532196371655e-07 0.00021 4.2437532196371657e-07 0 4.2439802338216437e-07 0 4.244080233821644e-07 0.00021 4.244180233821644e-07 0 4.244193933046748e-07 0 4.244293933046748e-07 0.00021 4.244393933046748e-07 0 4.244393933046748e-07 0 4.2444939330467483e-07 0.00021 4.2445939330467484e-07 0 4.2447021104702374e-07 0 4.2448021104702375e-07 0.00021 4.2449021104702376e-07 0 4.244930322245092e-07 0 4.245030322245092e-07 0.00021 4.2451303222450923e-07 0 4.246764579931791e-07 0 4.246864579931791e-07 0.00021 4.246964579931791e-07 0 4.2471615996319557e-07 0 4.247261599631956e-07 0.00021 4.247361599631956e-07 0 4.247533936930003e-07 0 4.247633936930003e-07 0.00021 4.247733936930003e-07 0 4.247733936930003e-07 0 4.247833936930003e-07 0.00021 4.2479339369300033e-07 0 4.2487792245691e-07 0 4.2488792245691003e-07 0.00021 4.2489792245691004e-07 0 4.2491654005553113e-07 0 4.2492654005553114e-07 0.00021 4.2493654005553115e-07 0 4.2514630998025246e-07 0 4.2515630998025247e-07 0.00021 4.251663099802525e-07 0 4.251663099802525e-07 0 4.251763099802525e-07 0.00021 4.251863099802525e-07 0 4.2523478060049324e-07 0 4.2524478060049325e-07 0.00021 4.2525478060049326e-07 0 4.2525478060049326e-07 0 4.252647806004933e-07 0.00021 4.252747806004933e-07 0 4.253351812576763e-07 0 4.253451812576763e-07 0.00021 4.253551812576763e-07 0 4.257191467841716e-07 0 4.2572914678417163e-07 0.00021 4.2573914678417164e-07 0 4.2573914678417164e-07 0 4.2574914678417165e-07 0.00021 4.2575914678417166e-07 0 4.257846224720189e-07 0 4.257946224720189e-07 0.00021 4.258046224720189e-07 0 4.260167102610507e-07 0 4.260267102610507e-07 0.00021 4.2603671026105074e-07 0 4.261466248962968e-07 0 4.261566248962968e-07 0.00021 4.261666248962968e-07 0 4.2626446351538085e-07 0 4.2627446351538086e-07 0.00021 4.2628446351538087e-07 0 4.264667775317223e-07 0 4.264767775317223e-07 0.00021 4.264867775317223e-07 0 4.265134594611559e-07 0 4.265234594611559e-07 0.00021 4.265334594611559e-07 0 4.2659225048064516e-07 0 4.2660225048064517e-07 0.00021 4.266122504806452e-07 0 4.266303179496643e-07 0 4.2664031794966433e-07 0.00021 4.2665031794966434e-07 0 4.2667267993780346e-07 0 4.2668267993780347e-07 0.00021 4.266926799378035e-07 0 4.2672627408662505e-07 0 4.2673627408662506e-07 0.00021 4.2674627408662507e-07 0 4.2676794931755146e-07 0 4.2677794931755147e-07 0.00021 4.267879493175515e-07 0 4.267879493175515e-07 0 4.267979493175515e-07 0.00021 4.268079493175515e-07 0 4.268079493175515e-07 0 4.268179493175515e-07 0.00021 4.2682794931755153e-07 0 4.2692425788278774e-07 0 4.2693425788278775e-07 0.00021 4.2694425788278776e-07 0 4.2694425788278776e-07 0 4.269542578827878e-07 0.00021 4.269642578827878e-07 0 4.269642578827878e-07 0 4.269742578827878e-07 0.00021 4.269842578827878e-07 0 4.2708150516150826e-07 0 4.2709150516150827e-07 0.00021 4.271015051615083e-07 0 4.271015051615083e-07 0 4.271115051615083e-07 0.00021 4.271215051615083e-07 0 4.2727079459232644e-07 0 4.2728079459232645e-07 0.00021 4.2729079459232647e-07 0 4.2729549153815605e-07 0 4.2730549153815606e-07 0.00021 4.273154915381561e-07 0 4.2736807368680893e-07 0 4.2737807368680894e-07 0.00021 4.2738807368680895e-07 0 4.2743159477001136e-07 0 4.274415947700114e-07 0.00021 4.274515947700114e-07 0 4.2758052101925486e-07 0 4.275905210192549e-07 0.00021 4.276005210192549e-07 0 4.2767038901595487e-07 0 4.276803890159549e-07 0.00021 4.276903890159549e-07 0 4.2782636494253383e-07 0 4.2783636494253384e-07 0.00021 4.2784636494253385e-07 0 4.2794379889146567e-07 0 4.279537988914657e-07 0.00021 4.279637988914657e-07 0 4.280460619273752e-07 0 4.2805606192737523e-07 0.00021 4.2806606192737524e-07 0 4.2813429213975055e-07 0 4.2814429213975056e-07 0.00021 4.281542921397506e-07 0 4.281867674956943e-07 0 4.2819676749569433e-07 0.00021 4.2820676749569434e-07 0 4.282346921633159e-07 0 4.282446921633159e-07 0.00021 4.282546921633159e-07 0 4.284099390973742e-07 0 4.2841993909737423e-07 0.00021 4.2842993909737424e-07 0 4.2843482198692255e-07 0 4.2844482198692256e-07 0.00021 4.284548219869226e-07 0 4.284617890801573e-07 0 4.284717890801573e-07 0.00021 4.2848178908015734e-07 0 4.2853568148571273e-07 0 4.2854568148571274e-07 0.00021 4.2855568148571275e-07 0 4.28658255128995e-07 0 4.2866825512899503e-07 0.00021 4.2867825512899504e-07 0 4.287118049843912e-07 0 4.287218049843912e-07 0.00021 4.2873180498439123e-07 0 4.2873180498439123e-07 0 4.2874180498439124e-07 0.00021 4.2875180498439125e-07 0 4.2875180498439125e-07 0 4.2876180498439127e-07 0.00021 4.287718049843913e-07 0 4.287718049843913e-07 0 4.287818049843913e-07 0.00021 4.287918049843913e-07 0 4.288703440840054e-07 0 4.2888034408400544e-07 0.00021 4.2889034408400545e-07 0 4.289673801260353e-07 0 4.289773801260353e-07 0.00021 4.2898738012603533e-07 0 4.290092702926845e-07 0 4.290192702926845e-07 0.00021 4.2902927029268453e-07 0 4.290308344883912e-07 0 4.290408344883912e-07 0.00021 4.290508344883912e-07 0 4.290508344883912e-07 0 4.290608344883912e-07 0.00021 4.2907083448839123e-07 0 4.290859706905178e-07 0 4.290959706905178e-07 0.00021 4.2910597069051783e-07 0 4.2910597069051783e-07 0 4.2911597069051784e-07 0.00021 4.2912597069051785e-07 0 4.2918344568088975e-07 0 4.2919344568088976e-07 0.00021 4.2920344568088977e-07 0 4.292616987503235e-07 0 4.292716987503235e-07 0.00021 4.292816987503235e-07 0 4.292816987503235e-07 0 4.292916987503235e-07 0.00021 4.293016987503235e-07 0 4.293016987503235e-07 0 4.2931169875032353e-07 0.00021 4.2932169875032354e-07 0 4.2932169875032354e-07 0 4.2933169875032356e-07 0.00021 4.2934169875032357e-07 0 4.2935435368672564e-07 0 4.2936435368672565e-07 0.00021 4.2937435368672566e-07 0 4.2942820982069643e-07 0 4.2943820982069644e-07 0.00021 4.2944820982069646e-07 0 4.295606416378348e-07 0 4.295706416378348e-07 0.00021 4.295806416378348e-07 0 4.296019453332404e-07 0 4.296119453332404e-07 0.00021 4.296219453332404e-07 0 4.2964494376106785e-07 0 4.2965494376106786e-07 0.00021 4.2966494376106787e-07 0 4.2970946650329043e-07 0 4.2971946650329044e-07 0.00021 4.2972946650329045e-07 0 4.298041719083394e-07 0 4.298141719083394e-07 0.00021 4.298241719083394e-07 0 4.298241719083394e-07 0 4.298341719083394e-07 0.00021 4.298441719083394e-07 0 4.2985051124041797e-07 0 4.29860511240418e-07 0.00021 4.29870511240418e-07 0 4.29870511240418e-07 0 4.29880511240418e-07 0.00021 4.29890511240418e-07 0 4.29890511240418e-07 0 4.29900511240418e-07 0.00021 4.2991051124041804e-07 0 4.2994653410074883e-07 0 4.2995653410074885e-07 0.00021 4.2996653410074886e-07 0 4.300209535581412e-07 0 4.300309535581412e-07 0.00021 4.300409535581412e-07 0 4.3011090125662067e-07 0 4.301209012566207e-07 0.00021 4.301309012566207e-07 0 4.302339275284038e-07 0 4.302439275284038e-07 0.00021 4.302539275284038e-07 0 4.302539275284038e-07 0 4.302639275284038e-07 0.00021 4.3027392752840383e-07 0 4.3027392752840383e-07 0 4.3028392752840384e-07 0.00021 4.3029392752840385e-07 0 4.3029392752840385e-07 0 4.3030392752840386e-07 0.00021 4.3031392752840387e-07 0 4.3031392752840387e-07 0 4.303239275284039e-07 0.00021 4.303339275284039e-07 0 4.303339275284039e-07 0 4.303439275284039e-07 0.00021 4.303539275284039e-07 0 4.303963605297577e-07 0 4.3040636052975773e-07 0.00021 4.3041636052975774e-07 0 4.304458685797575e-07 0 4.304558685797575e-07 0.00021 4.3046586857975753e-07 0 4.3046586857975753e-07 0 4.3047586857975754e-07 0.00021 4.3048586857975756e-07 0 4.3048586857975756e-07 0 4.3049586857975757e-07 0.00021 4.305058685797576e-07 0 4.305058685797576e-07 0 4.305158685797576e-07 0.00021 4.305258685797576e-07 0 4.305258685797576e-07 0 4.305358685797576e-07 0.00021 4.305458685797576e-07 0 4.305458685797576e-07 0 4.3055586857975764e-07 0.00021 4.3056586857975765e-07 0 4.3086513125194483e-07 0 4.3087513125194484e-07 0.00021 4.3088513125194485e-07 0 4.3103316205957765e-07 0 4.3104316205957766e-07 0.00021 4.3105316205957767e-07 0 4.311323720811124e-07 0 4.311423720811124e-07 0.00021 4.311523720811124e-07 0 4.312023957467884e-07 0 4.312123957467884e-07 0.00021 4.312223957467884e-07 0 4.31499629071683e-07 0 4.3150962907168303e-07 0.00021 4.3151962907168304e-07 0 4.3151962907168304e-07 0 4.3152962907168305e-07 0.00021 4.3153962907168306e-07 0 4.3155283155200975e-07 0 4.3156283155200976e-07 0.00021 4.315728315520098e-07 0 4.316685158345112e-07 0 4.3167851583451123e-07 0.00021 4.3168851583451124e-07 0 4.317073736117501e-07 0 4.317173736117501e-07 0.00021 4.3172737361175013e-07 0 4.3186337691063164e-07 0 4.3187337691063165e-07 0.00021 4.3188337691063167e-07 0 4.3189288637876844e-07 0 4.3190288637876845e-07 0.00021 4.3191288637876846e-07 0 4.3191288637876846e-07 0 4.3192288637876847e-07 0.00021 4.319328863787685e-07 0 4.3196005289971595e-07 0 4.3197005289971596e-07 0.00021 4.3198005289971597e-07 0 4.319892790048313e-07 0 4.319992790048313e-07 0.00021 4.320092790048313e-07 0 4.3218972454795203e-07 0 4.3219972454795204e-07 0.00021 4.3220972454795205e-07 0 4.323082468273443e-07 0 4.323182468273443e-07 0.00021 4.323282468273443e-07 0 4.3234423348206114e-07 0 4.3235423348206115e-07 0.00021 4.3236423348206116e-07 0 4.3243433248492065e-07 0 4.3244433248492066e-07 0.00021 4.324543324849207e-07 0 4.3250105754267766e-07 0 4.3251105754267767e-07 0.00021 4.325210575426777e-07 0 4.325748931196002e-07 0 4.325848931196002e-07 0.00021 4.325948931196002e-07 0 4.3266354044684163e-07 0 4.3267354044684164e-07 0.00021 4.3268354044684165e-07 0 4.3268354044684165e-07 0 4.3269354044684167e-07 0.00021 4.327035404468417e-07 0 4.327035404468417e-07 0 4.327135404468417e-07 0.00021 4.327235404468417e-07 0 4.3275749904760235e-07 0 4.3276749904760236e-07 0.00021 4.3277749904760237e-07 0 4.328294960353138e-07 0 4.3283949603531384e-07 0.00021 4.3284949603531385e-07 0 4.3301712161364533e-07 0 4.3302712161364535e-07 0.00021 4.3303712161364536e-07 0 4.330470298747908e-07 0 4.330570298747908e-07 0.00021 4.330670298747908e-07 0 4.3314591237081533e-07 0 4.3315591237081534e-07 0.00021 4.3316591237081536e-07 0 4.3330028720495437e-07 0 4.333102872049544e-07 0.00021 4.333202872049544e-07 0 4.333202872049544e-07 0 4.333302872049544e-07 0.00021 4.333402872049544e-07 0 4.333402872049544e-07 0 4.333502872049544e-07 0.00021 4.3336028720495444e-07 0 4.3336626950946055e-07 0 4.3337626950946056e-07 0.00021 4.333862695094606e-07 0 4.3339014187642417e-07 0 4.334001418764242e-07 0.00021 4.334101418764242e-07 0 4.334393715332656e-07 0 4.3344937153326563e-07 0.00021 4.3345937153326565e-07 0 4.335199955293895e-07 0 4.3352999552938953e-07 0.00021 4.3353999552938954e-07 0 4.3353999552938954e-07 0 4.3354999552938955e-07 0.00021 4.3355999552938956e-07 0 4.3355999552938956e-07 0 4.335699955293896e-07 0.00021 4.335799955293896e-07 0 4.335799955293896e-07 0 4.335899955293896e-07 0.00021 4.335999955293896e-07 0 4.335999955293896e-07 0 4.336099955293896e-07 0.00021 4.3361999552938963e-07 0 4.3361999552938963e-07 0 4.3362999552938964e-07 0.00021 4.3363999552938966e-07 0 4.3365460092346923e-07 0 4.3366460092346924e-07 0.00021 4.3367460092346926e-07 0 4.337339566035522e-07 0 4.3374395660355224e-07 0.00021 4.3375395660355225e-07 0 4.3375395660355225e-07 0 4.3376395660355226e-07 0.00021 4.3377395660355227e-07 0 4.3386107515934074e-07 0 4.3387107515934076e-07 0.00021 4.3388107515934077e-07 0 4.3388107515934077e-07 0 4.338910751593408e-07 0.00021 4.339010751593408e-07 0 4.3390409997882363e-07 0 4.3391409997882364e-07 0.00021 4.3392409997882365e-07 0 4.339564329720158e-07 0 4.339664329720158e-07 0.00021 4.3397643297201583e-07 0 4.340035278896727e-07 0 4.3401352788967273e-07 0.00021 4.3402352788967275e-07 0 4.3410028795924023e-07 0 4.3411028795924025e-07 0.00021 4.3412028795924026e-07 0 4.3412858980963036e-07 0 4.3413858980963037e-07 0.00021 4.341485898096304e-07 0 4.3417751720887036e-07 0 4.341875172088704e-07 0.00021 4.341975172088704e-07 0 4.3428987761485776e-07 0 4.3429987761485777e-07 0.00021 4.343098776148578e-07 0 4.343098776148578e-07 0 4.343198776148578e-07 0.00021 4.343298776148578e-07 0 4.3436198876385907e-07 0 4.343719887638591e-07 0.00021 4.343819887638591e-07 0 4.344392546464761e-07 0 4.344492546464761e-07 0.00021 4.344592546464761e-07 0 4.3446442014787515e-07 0 4.3447442014787516e-07 0.00021 4.344844201478752e-07 0 4.3454252636926997e-07 0 4.3455252636927e-07 0.00021 4.3456252636927e-07 0 4.3479326189022555e-07 0 4.3480326189022557e-07 0.00021 4.348132618902256e-07 0 4.348132618902256e-07 0 4.348232618902256e-07 0.00021 4.348332618902256e-07 0 4.348661833471468e-07 0 4.3487618334714683e-07 0.00021 4.3488618334714684e-07 0 4.3490177858475687e-07 0 4.349117785847569e-07 0.00021 4.349217785847569e-07 0 4.350009425648998e-07 0 4.3501094256489983e-07 0.00021 4.3502094256489984e-07 0 4.350753557308967e-07 0 4.3508535573089673e-07 0.00021 4.3509535573089675e-07 0 4.351370604686176e-07 0 4.351470604686176e-07 0.00021 4.351570604686176e-07 0 4.353241871283118e-07 0 4.353341871283118e-07 0.00021 4.353441871283118e-07 0 4.3536660357519914e-07 0 4.3537660357519915e-07 0.00021 4.3538660357519916e-07 0 4.356750847974349e-07 0 4.356850847974349e-07 0.00021 4.356950847974349e-07 0 4.357259293405038e-07 0 4.357359293405038e-07 0.00021 4.3574592934050383e-07 0 4.358647797491865e-07 0 4.3587477974918653e-07 0.00021 4.3588477974918654e-07 0 4.360008329428597e-07 0 4.360108329428597e-07 0.00021 4.360208329428597e-07 0 4.360208329428597e-07 0 4.360308329428597e-07 0.00021 4.360408329428597e-07 0 4.3604758572813723e-07 0 4.3605758572813724e-07 0.00021 4.3606758572813725e-07 0 4.362572137999101e-07 0 4.362672137999101e-07 0.00021 4.362772137999101e-07 0 4.362772137999101e-07 0 4.362872137999101e-07 0.00021 4.3629721379991013e-07 0 4.3631589633809746e-07 0 4.3632589633809747e-07 0.00021 4.363358963380975e-07 0 4.3636275241960445e-07 0 4.3637275241960446e-07 0.00021 4.363827524196045e-07 0 4.3639749175472157e-07 0 4.364074917547216e-07 0.00021 4.364174917547216e-07 0 4.3644072703740884e-07 0 4.3645072703740885e-07 0.00021 4.3646072703740886e-07 0 4.3656300193368836e-07 0 4.3657300193368837e-07 0.00021 4.365830019336884e-07 0 4.366155747545829e-07 0 4.366255747545829e-07 0.00021 4.366355747545829e-07 0 4.366510741068405e-07 0 4.366610741068405e-07 0.00021 4.3667107410684054e-07 0 4.366840926089123e-07 0 4.366940926089123e-07 0.00021 4.367040926089123e-07 0 4.367883625955397e-07 0 4.367983625955397e-07 0.00021 4.368083625955397e-07 0 4.368083625955397e-07 0 4.368183625955397e-07 0.00021 4.368283625955397e-07 0 4.370325299794532e-07 0 4.370425299794532e-07 0.00021 4.3705252997945324e-07 0 4.3705252997945324e-07 0 4.3706252997945325e-07 0.00021 4.3707252997945326e-07 0 4.3707252997945326e-07 0 4.3708252997945327e-07 0.00021 4.370925299794533e-07 0 4.371902674358253e-07 0 4.3720026743582533e-07 0.00021 4.3721026743582534e-07 0 4.372542290499129e-07 0 4.372642290499129e-07 0.00021 4.3727422904991294e-07 0 4.3731511533430026e-07 0 4.3732511533430027e-07 0.00021 4.373351153343003e-07 0 4.373351153343003e-07 0 4.373451153343003e-07 0.00021 4.373551153343003e-07 0 4.3744887444270133e-07 0 4.3745887444270134e-07 0.00021 4.3746887444270135e-07 0 4.3747067992718385e-07 0 4.3748067992718386e-07 0.00021 4.3749067992718387e-07 0 4.3749067992718387e-07 0 4.375006799271839e-07 0.00021 4.375106799271839e-07 0 4.3782586789832046e-07 0 4.3783586789832047e-07 0.00021 4.378458678983205e-07 0 4.3786716059393803e-07 0 4.3787716059393804e-07 0.00021 4.3788716059393805e-07 0 4.3795667267045584e-07 0 4.3796667267045585e-07 0.00021 4.3797667267045586e-07 0 4.3824227161972966e-07 0 4.3825227161972967e-07 0.00021 4.382622716197297e-07 0 4.3835890452111946e-07 0 4.3836890452111947e-07 0.00021 4.383789045211195e-07 0 4.383924966651375e-07 0 4.384024966651375e-07 0.00021 4.384124966651375e-07 0 4.385212237118045e-07 0 4.385312237118045e-07 0.00021 4.385412237118045e-07 0 4.385412237118045e-07 0 4.385512237118045e-07 0.00021 4.3856122371180453e-07 0 4.3865997131133843e-07 0 4.3866997131133844e-07 0.00021 4.3867997131133846e-07 0 4.387425690379153e-07 0 4.387525690379153e-07 0.00021 4.387625690379153e-07 0 4.389759727990874e-07 0 4.3898597279908743e-07 0.00021 4.3899597279908744e-07 0 4.390335106168664e-07 0 4.3904351061686643e-07 0.00021 4.3905351061686644e-07 0 4.392103320009572e-07 0 4.392203320009572e-07 0.00021 4.3923033200095724e-07 0 4.3940835339622946e-07 0 4.394183533962295e-07 0.00021 4.394283533962295e-07 0 4.395325320958597e-07 0 4.3954253209585973e-07 0.00021 4.3955253209585974e-07 0 4.3955253209585974e-07 0 4.3956253209585975e-07 0.00021 4.3957253209585976e-07 0 4.3957253209585976e-07 0 4.3958253209585977e-07 0.00021 4.395925320958598e-07 0 4.395925320958598e-07 0 4.396025320958598e-07 0.00021 4.396125320958598e-07 0 4.3964783579685586e-07 0 4.3965783579685587e-07 0.00021 4.396678357968559e-07 0 4.3969965155175896e-07 0 4.3970965155175897e-07 0.00021 4.39719651551759e-07 0 4.3978318144976087e-07 0 4.397931814497609e-07 0.00021 4.398031814497609e-07 0 4.3981368584345216e-07 0 4.3982368584345217e-07 0.00021 4.398336858434522e-07 0 4.3991005326964326e-07 0 4.3992005326964327e-07 0.00021 4.399300532696433e-07 0 4.400914021085271e-07 0 4.4010140210852714e-07 0.00021 4.4011140210852715e-07 0 4.401143867768152e-07 0 4.401243867768152e-07 0.00021 4.401343867768152e-07 0 4.402349315980689e-07 0 4.402449315980689e-07 0.00021 4.4025493159806893e-07 0 4.4025493159806893e-07 0 4.4026493159806894e-07 0.00021 4.4027493159806895e-07 0 4.403181787815925e-07 0 4.403281787815925e-07 0.00021 4.403381787815925e-07 0 4.403857553717126e-07 0 4.4039575537171263e-07 0.00021 4.4040575537171264e-07 0 4.4044892135278304e-07 0 4.4045892135278305e-07 0.00021 4.4046892135278306e-07 0 4.4046892135278306e-07 0 4.4047892135278307e-07 0.00021 4.404889213527831e-07 0 4.40489285414187e-07 0 4.40499285414187e-07 0.00021 4.40509285414187e-07 0 4.405617286960169e-07 0 4.4057172869601693e-07 0.00021 4.4058172869601694e-07 0 4.406129092306903e-07 0 4.406229092306903e-07 0.00021 4.4063290923069034e-07 0 4.4063290923069034e-07 0 4.4064290923069035e-07 0.00021 4.4065290923069036e-07 0 4.4065290923069036e-07 0 4.4066290923069037e-07 0.00021 4.406729092306904e-07 0 4.408948717859441e-07 0 4.409048717859441e-07 0.00021 4.409148717859441e-07 0 4.409148717859441e-07 0 4.4092487178594413e-07 0.00021 4.4093487178594414e-07 0 4.4111473344907074e-07 0 4.4112473344907075e-07 0.00021 4.4113473344907077e-07 0 4.412276839875151e-07 0 4.412376839875151e-07 0.00021 4.4124768398751513e-07 0 4.4124768398751513e-07 0 4.4125768398751514e-07 0.00021 4.4126768398751515e-07 0 4.41303624281357e-07 0 4.41313624281357e-07 0.00021 4.4132362428135703e-07 0 4.4132362428135703e-07 0 4.4133362428135704e-07 0.00021 4.4134362428135705e-07 0 4.4134362428135705e-07 0 4.4135362428135706e-07 0.00021 4.413636242813571e-07 0 4.4138107655376053e-07 0 4.4139107655376054e-07 0.00021 4.4140107655376056e-07 0 4.415746390387744e-07 0 4.415846390387744e-07 0.00021 4.4159463903877443e-07 0 4.417179516347561e-07 0 4.417279516347561e-07 0.00021 4.4173795163475613e-07 0 4.4187762166805503e-07 0 4.4188762166805504e-07 0.00021 4.4189762166805505e-07 0 4.4207260963022383e-07 0 4.4208260963022384e-07 0.00021 4.4209260963022385e-07 0 4.4214328646723806e-07 0 4.4215328646723807e-07 0.00021 4.421632864672381e-07 0 4.421632864672381e-07 0 4.421732864672381e-07 0.00021 4.421832864672381e-07 0 4.424353025227372e-07 0 4.424453025227372e-07 0.00021 4.4245530252273724e-07 0 4.4245530252273724e-07 0 4.4246530252273725e-07 0.00021 4.4247530252273726e-07 0 4.4247530252273726e-07 0 4.4248530252273727e-07 0.00021 4.424953025227373e-07 0 4.424953025227373e-07 0 4.425053025227373e-07 0.00021 4.425153025227373e-07 0 4.42583967410749e-07 0 4.42593967410749e-07 0.00021 4.4260396741074904e-07 0 4.427711677872628e-07 0 4.427811677872628e-07 0.00021 4.427911677872628e-07 0 4.427911677872628e-07 0 4.4280116778726283e-07 0.00021 4.4281116778726284e-07 0 4.4288851311675383e-07 0 4.4289851311675384e-07 0.00021 4.4290851311675385e-07 0 4.429188269785428e-07 0 4.429288269785428e-07 0.00021 4.429388269785428e-07 0 4.429388269785428e-07 0 4.429488269785428e-07 0.00021 4.429588269785428e-07 0 4.4312094462686663e-07 0 4.4313094462686665e-07 0.00021 4.4314094462686666e-07 0 4.4314094462686666e-07 0 4.4315094462686667e-07 0.00021 4.431609446268667e-07 0 4.431609446268667e-07 0 4.431709446268667e-07 0.00021 4.431809446268667e-07 0 4.431922295585796e-07 0 4.432022295585796e-07 0.00021 4.4321222955857963e-07 0 4.432234568995982e-07 0 4.432334568995982e-07 0.00021 4.432434568995982e-07 0 4.434198212426661e-07 0 4.4342982124266613e-07 0.00021 4.4343982124266614e-07 0 4.43513853537244e-07 0 4.4352385353724403e-07 0.00021 4.4353385353724404e-07 0 4.435369227742107e-07 0 4.435469227742107e-07 0.00021 4.435569227742107e-07 0 4.43678071199361e-07 0 4.43688071199361e-07 0.00021 4.4369807119936104e-07 0 4.4375123039686035e-07 0 4.4376123039686036e-07 0.00021 4.4377123039686037e-07 0 4.438815706510408e-07 0 4.438915706510408e-07 0.00021 4.4390157065104083e-07 0 4.4390157065104083e-07 0 4.4391157065104084e-07 0.00021 4.4392157065104085e-07 0 4.44021974574341e-07 0 4.44031974574341e-07 0.00021 4.44041974574341e-07 0 4.440785738630945e-07 0 4.440885738630945e-07 0.00021 4.440985738630945e-07 0 4.4412446339476825e-07 0 4.4413446339476827e-07 0.00021 4.441444633947683e-07 0 4.442202029218672e-07 0 4.442302029218672e-07 0.00021 4.442402029218672e-07 0 4.442402029218672e-07 0 4.442502029218672e-07 0.00021 4.442602029218672e-07 0 4.4431924580156063e-07 0 4.4432924580156064e-07 0.00021 4.4433924580156065e-07 0 4.4444332362445266e-07 0 4.4445332362445267e-07 0.00021 4.444633236244527e-07 0 4.4452195369236357e-07 0 4.445319536923636e-07 0.00021 4.445419536923636e-07 0 4.445721134360601e-07 0 4.445821134360601e-07 0.00021 4.445921134360601e-07 0 4.4460109072466843e-07 0 4.4461109072466844e-07 0.00021 4.4462109072466845e-07 0 4.4462109072466845e-07 0 4.4463109072466847e-07 0.00021 4.446410907246685e-07 0 4.4469414851463515e-07 0 4.4470414851463516e-07 0.00021 4.4471414851463517e-07 0 4.4473367708457585e-07 0 4.4474367708457586e-07 0.00021 4.447536770845759e-07 0 4.447542379262516e-07 0 4.4476423792625164e-07 0.00021 4.4477423792625165e-07 0 4.44949510609689e-07 0 4.44959510609689e-07 0.00021 4.4496951060968904e-07 0 4.451866974871091e-07 0 4.451966974871091e-07 0.00021 4.452066974871091e-07 0 4.4526915925130015e-07 0 4.4527915925130016e-07 0.00021 4.452891592513002e-07 0 4.453722076198518e-07 0 4.453822076198518e-07 0.00021 4.4539220761985183e-07 0 4.455441350427017e-07 0 4.455541350427017e-07 0.00021 4.4556413504270173e-07 0 4.456558677659393e-07 0 4.456658677659393e-07 0.00021 4.4567586776593933e-07 0 4.457579307299685e-07 0 4.457679307299685e-07 0.00021 4.457779307299685e-07 0 4.4585220928907684e-07 0 4.4586220928907685e-07 0.00021 4.4587220928907686e-07 0 4.459059607491546e-07 0 4.459159607491546e-07 0.00021 4.459259607491546e-07 0 4.4623726408249596e-07 0 4.4624726408249597e-07 0.00021 4.46257264082496e-07 0 4.4634673896163205e-07 0 4.4635673896163207e-07 0.00021 4.463667389616321e-07 0 4.463667389616321e-07 0 4.463767389616321e-07 0.00021 4.463867389616321e-07 0 4.463867389616321e-07 0 4.463967389616321e-07 0.00021 4.464067389616321e-07 0 4.4654142990420314e-07 0 4.4655142990420315e-07 0.00021 4.4656142990420316e-07 0 4.4657302860364426e-07 0 4.4658302860364427e-07 0.00021 4.465930286036443e-07 0 4.4660366214489254e-07 0 4.4661366214489255e-07 0.00021 4.4662366214489256e-07 0 4.4665990563883445e-07 0 4.4666990563883446e-07 0.00021 4.4667990563883447e-07 0 4.4667990563883447e-07 0 4.466899056388345e-07 0.00021 4.466999056388345e-07 0 4.467829143883442e-07 0 4.467929143883442e-07 0.00021 4.468029143883442e-07 0 4.468029143883442e-07 0 4.468129143883442e-07 0.00021 4.4682291438834423e-07 0 4.4682291438834423e-07 0 4.4683291438834425e-07 0.00021 4.4684291438834426e-07 0 4.4697860682161123e-07 0 4.4698860682161125e-07 0.00021 4.4699860682161126e-07 0 4.4713116435306524e-07 0 4.4714116435306526e-07 0.00021 4.4715116435306527e-07 0 4.471847925738043e-07 0 4.471947925738043e-07 0.00021 4.472047925738043e-07 0 4.4734091100518924e-07 0 4.4735091100518926e-07 0.00021 4.4736091100518927e-07 0 4.4736091100518927e-07 0 4.473709110051893e-07 0.00021 4.473809110051893e-07 0 4.4738337844778063e-07 0 4.4739337844778064e-07 0.00021 4.4740337844778065e-07 0 4.474522434527934e-07 0 4.474622434527934e-07 0.00021 4.4747224345279343e-07 0 4.4765486338737726e-07 0 4.4766486338737727e-07 0.00021 4.476748633873773e-07 0 4.4769193152155357e-07 0 4.477019315215536e-07 0.00021 4.477119315215536e-07 0 4.477119315215536e-07 0 4.477219315215536e-07 0.00021 4.477319315215536e-07 0 4.477602989720245e-07 0 4.4777029897202453e-07 0.00021 4.4778029897202454e-07 0 4.4778029897202454e-07 0 4.4779029897202455e-07 0.00021 4.4780029897202457e-07 0 4.478142413661196e-07 0 4.478242413661196e-07 0.00021 4.478342413661196e-07 0 4.479050888559789e-07 0 4.479150888559789e-07 0.00021 4.479250888559789e-07 0 4.479250888559789e-07 0 4.4793508885597893e-07 0.00021 4.4794508885597895e-07 0 4.480690874680189e-07 0 4.480790874680189e-07 0.00021 4.480890874680189e-07 0 4.481117071209106e-07 0 4.4812170712091063e-07 0.00021 4.4813170712091065e-07 0 4.481537469583805e-07 0 4.481637469583805e-07 0.00021 4.481737469583805e-07 0 4.4823114207760145e-07 0 4.4824114207760146e-07 0.00021 4.4825114207760147e-07 0 4.484551641509802e-07 0 4.484651641509802e-07 0.00021 4.484751641509802e-07 0 4.486509497273738e-07 0 4.486609497273738e-07 0.00021 4.4867094972737383e-07 0 4.4874772291772424e-07 0 4.4875772291772425e-07 0.00021 4.4876772291772426e-07 0 4.4883811880891624e-07 0 4.4884811880891625e-07 0.00021 4.4885811880891627e-07 0 4.489172233085721e-07 0 4.489272233085721e-07 0.00021 4.489372233085721e-07 0 4.489375104590311e-07 0 4.489475104590311e-07 0.00021 4.489575104590311e-07 0 4.489843302631295e-07 0 4.489943302631295e-07 0.00021 4.490043302631295e-07 0 4.490421401821497e-07 0 4.490521401821497e-07 0.00021 4.4906214018214973e-07 0 4.490639709415941e-07 0 4.490739709415941e-07 0.00021 4.490839709415941e-07 0 4.491437364733339e-07 0 4.491537364733339e-07 0.00021 4.491637364733339e-07 0 4.4932858238725304e-07 0 4.4933858238725305e-07 0.00021 4.4934858238725306e-07 0 4.4968631878444307e-07 0 4.496963187844431e-07 0.00021 4.497063187844431e-07 0 4.497063187844431e-07 0 4.497163187844431e-07 0.00021 4.497263187844431e-07 0 4.497263187844431e-07 0 4.4973631878444313e-07 0.00021 4.4974631878444314e-07 0 4.4974631878444314e-07 0 4.4975631878444315e-07 0.00021 4.4976631878444316e-07 0 4.4976631878444316e-07 0 4.497763187844432e-07 0.00021 4.497863187844432e-07 0 4.4985114179879006e-07 0 4.4986114179879007e-07 0.00021 4.498711417987901e-07 0 4.498845368032842e-07 0 4.4989453680328423e-07 0.00021 4.4990453680328424e-07 0 4.5007059741075174e-07 0 4.5008059741075175e-07 0.00021 4.5009059741075176e-07 0 4.5010391777862705e-07 0 4.5011391777862706e-07 0.00021 4.501239177786271e-07 0 4.501239177786271e-07 0 4.501339177786271e-07 0.00021 4.501439177786271e-07 0 4.5039610762911754e-07 0 4.5040610762911756e-07 0.00021 4.5041610762911757e-07 0 4.5041610762911757e-07 0 4.504261076291176e-07 0.00021 4.504361076291176e-07 0 4.5047619290536e-07 0 4.5048619290536e-07 0.00021 4.5049619290536003e-07 0 4.505180994101553e-07 0 4.505280994101553e-07 0.00021 4.505380994101553e-07 0 4.505649840971785e-07 0 4.505749840971785e-07 0.00021 4.5058498409717853e-07 0 4.5062866632735053e-07 0 4.5063866632735054e-07 0.00021 4.5064866632735055e-07 0 4.5077614602694905e-07 0 4.5078614602694907e-07 0.00021 4.507961460269491e-07 0 4.508083225668105e-07 0 4.5081832256681053e-07 0.00021 4.5082832256681054e-07 0 4.508662663491655e-07 0 4.508762663491655e-07 0.00021 4.508862663491655e-07 0 4.508862663491655e-07 0 4.508962663491655e-07 0.00021 4.509062663491655e-07 0 4.509062663491655e-07 0 4.5091626634916553e-07 0.00021 4.5092626634916555e-07 0 4.5103143207820654e-07 0 4.5104143207820655e-07 0.00021 4.5105143207820656e-07 0 4.5105768987009696e-07 0 4.51067689870097e-07 0.00021 4.51077689870097e-07 0 4.5109349730797724e-07 0 4.5110349730797725e-07 0.00021 4.5111349730797726e-07 0 4.511317751857549e-07 0 4.511417751857549e-07 0.00021 4.511517751857549e-07 0 4.511604415534818e-07 0 4.511704415534818e-07 0.00021 4.5118044155348183e-07 0 4.511921817824478e-07 0 4.5120218178244784e-07 0.00021 4.5121218178244785e-07 0 4.5121218178244785e-07 0 4.5122218178244786e-07 0.00021 4.5123218178244787e-07 0 4.5130891756982e-07 0 4.5131891756982e-07 0.00021 4.5132891756982e-07 0 4.513478072025654e-07 0 4.513578072025654e-07 0.00021 4.513678072025654e-07 0 4.513678072025654e-07 0 4.5137780720256544e-07 0.00021 4.5138780720256545e-07 0 4.5138780720256545e-07 0 4.5139780720256546e-07 0.00021 4.5140780720256547e-07 0 4.5140780720256547e-07 0 4.514178072025655e-07 0.00021 4.514278072025655e-07 0 4.5144260582772414e-07 0 4.5145260582772415e-07 0.00021 4.5146260582772416e-07 0 4.514744116641428e-07 0 4.514844116641428e-07 0.00021 4.514944116641428e-07 0 4.5152477306922336e-07 0 4.5153477306922337e-07 0.00021 4.515447730692234e-07 0 4.5156535403938316e-07 0 4.5157535403938317e-07 0.00021 4.515853540393832e-07 0 4.517727368053933e-07 0 4.517827368053933e-07 0.00021 4.517927368053933e-07 0 4.518047579928203e-07 0 4.518147579928203e-07 0.00021 4.518247579928203e-07 0 4.5186803722512797e-07 0 4.51878037225128e-07 0.00021 4.51888037225128e-07 0 4.5198376989525185e-07 0 4.5199376989525186e-07 0.00021 4.5200376989525187e-07 0 4.5200376989525187e-07 0 4.520137698952519e-07 0.00021 4.520237698952519e-07 0 4.5203439708111835e-07 0 4.5204439708111837e-07 0.00021 4.520543970811184e-07 0 4.520543970811184e-07 0 4.520643970811184e-07 0.00021 4.520743970811184e-07 0 4.520743970811184e-07 0 4.520843970811184e-07 0.00021 4.520943970811184e-07 0 4.521193031160746e-07 0 4.521293031160746e-07 0.00021 4.521393031160746e-07 0 4.5232835235560416e-07 0 4.5233835235560417e-07 0.00021 4.523483523556042e-07 0 4.5257041195586195e-07 0 4.5258041195586197e-07 0.00021 4.52590411955862e-07 0 4.5268029669683e-07 0 4.5269029669683e-07 0.00021 4.5270029669683e-07 0 4.52844684485735e-07 0 4.52854684485735e-07 0.00021 4.52864684485735e-07 0 4.529077215034098e-07 0 4.529177215034098e-07 0.00021 4.529277215034098e-07 0 4.529277215034098e-07 0 4.529377215034098e-07 0.00021 4.529477215034098e-07 0 4.529477215034098e-07 0 4.5295772150340983e-07 0.00021 4.5296772150340984e-07 0 4.5306965512195987e-07 0 4.530796551219599e-07 0.00021 4.530896551219599e-07 0 4.531252383650788e-07 0 4.531352383650788e-07 0.00021 4.531452383650788e-07 0 4.531745400553092e-07 0 4.5318454005530923e-07 0.00021 4.5319454005530924e-07 0 4.532316309227636e-07 0 4.532416309227636e-07 0.00021 4.532516309227636e-07 0 4.5329707762641247e-07 0 4.533070776264125e-07 0.00021 4.533170776264125e-07 0 4.5337870778858754e-07 0 4.5338870778858755e-07 0.00021 4.5339870778858756e-07 0 4.5339870778858756e-07 0 4.5340870778858757e-07 0.00021 4.534187077885876e-07 0 4.534187077885876e-07 0 4.534287077885876e-07 0.00021 4.534387077885876e-07 0 4.5353477474445897e-07 0 4.53544774744459e-07 0.00021 4.53554774744459e-07 0 4.53556305860773e-07 0 4.5356630586077303e-07 0.00021 4.5357630586077305e-07 0 4.5377103027409917e-07 0 4.537810302740992e-07 0.00021 4.537910302740992e-07 0 4.5389216271960976e-07 0 4.5390216271960977e-07 0.00021 4.539121627196098e-07 0 4.5394108351916874e-07 0 4.5395108351916875e-07 0.00021 4.5396108351916876e-07 0 4.5403881656123186e-07 0 4.5404881656123187e-07 0.00021 4.540588165612319e-07 0 4.540788941419988e-07 0 4.540888941419988e-07 0.00021 4.540988941419988e-07 0 4.541591868571422e-07 0 4.541691868571422e-07 0.00021 4.541791868571422e-07 0 4.541816988701375e-07 0 4.541916988701375e-07 0.00021 4.542016988701375e-07 0 4.542233387910008e-07 0 4.542333387910008e-07 0.00021 4.542433387910008e-07 0 4.542433387910008e-07 0 4.5425333879100084e-07 0.00021 4.5426333879100085e-07 0 4.542898071743321e-07 0 4.542998071743321e-07 0.00021 4.543098071743321e-07 0 4.543373859406026e-07 0 4.543473859406026e-07 0.00021 4.543573859406026e-07 0 4.543573859406026e-07 0 4.543673859406026e-07 0.00021 4.543773859406026e-07 0 4.543792300804881e-07 0 4.5438923008048813e-07 0.00021 4.5439923008048815e-07 0 4.544120564025392e-07 0 4.5442205640253924e-07 0.00021 4.5443205640253925e-07 0 4.5453346710780084e-07 0 4.5454346710780085e-07 0.00021 4.5455346710780086e-07 0 4.545712262232663e-07 0 4.5458122622326633e-07 0.00021 4.5459122622326634e-07 0 4.5461151767453396e-07 0 4.54621517674534e-07 0.00021 4.54631517674534e-07 0 4.547922293322248e-07 0 4.548022293322248e-07 0.00021 4.548122293322248e-07 0 4.548122293322248e-07 0 4.5482222933222483e-07 0.00021 4.5483222933222484e-07 0 4.5483222933222484e-07 0 4.5484222933222485e-07 0.00021 4.5485222933222486e-07 0 4.5490931197655755e-07 0 4.5491931197655756e-07 0.00021 4.5492931197655757e-07 0 4.550082457516111e-07 0 4.5501824575161113e-07 0.00021 4.5502824575161114e-07 0 4.550412707004507e-07 0 4.550512707004507e-07 0.00021 4.550612707004507e-07 0 4.552237199502409e-07 0 4.552337199502409e-07 0.00021 4.5524371995024093e-07 0 4.5524371995024093e-07 0 4.5525371995024094e-07 0.00021 4.5526371995024095e-07 0 4.552894638612749e-07 0 4.552994638612749e-07 0.00021 4.5530946386127494e-07 0 4.5544150201422126e-07 0 4.554515020142213e-07 0.00021 4.554615020142213e-07 0 4.555008124840977e-07 0 4.555108124840977e-07 0.00021 4.555208124840977e-07 0 4.5554134437497605e-07 0 4.5555134437497606e-07 0.00021 4.555613443749761e-07 0 4.5565700505718413e-07 0 4.5566700505718414e-07 0.00021 4.5567700505718415e-07 0 4.557033093206852e-07 0 4.557133093206852e-07 0.00021 4.5572330932068524e-07 0 4.557348656421626e-07 0 4.557448656421626e-07 0.00021 4.5575486564216263e-07 0 4.5600883080661376e-07 0 4.5601883080661377e-07 0.00021 4.560288308066138e-07 0 4.560288308066138e-07 0 4.560388308066138e-07 0.00021 4.560488308066138e-07 0 4.560488308066138e-07 0 4.560588308066138e-07 0.00021 4.5606883080661383e-07 0 4.561011454861284e-07 0 4.561111454861284e-07 0.00021 4.561211454861284e-07 0 4.5612840073773337e-07 0 4.561384007377334e-07 0.00021 4.561484007377334e-07 0 4.5632167885644655e-07 0 4.5633167885644656e-07 0.00021 4.563416788564466e-07 0 4.5647459465954723e-07 0 4.5648459465954724e-07 0.00021 4.5649459465954726e-07 0 4.5657701052734274e-07 0 4.5658701052734275e-07 0.00021 4.5659701052734276e-07 0 4.5659701052734276e-07 0 4.5660701052734277e-07 0.00021 4.566170105273428e-07 0 4.567341404027114e-07 0 4.567441404027114e-07 0.00021 4.5675414040271143e-07 0 4.5675414040271143e-07 0 4.5676414040271144e-07 0.00021 4.5677414040271145e-07 0 4.5684359936363737e-07 0 4.568535993636374e-07 0.00021 4.568635993636374e-07 0 4.5687610220628894e-07 0 4.5688610220628895e-07 0.00021 4.5689610220628896e-07 0 4.5689610220628896e-07 0 4.5690610220628897e-07 0.00021 4.56916102206289e-07 0 4.56916102206289e-07 0 4.56926102206289e-07 0.00021 4.56936102206289e-07 0 4.56936102206289e-07 0 4.56946102206289e-07 0.00021 4.5695610220628903e-07 0 4.5696823626333e-07 0 4.5697823626333e-07 0.00021 4.5698823626333e-07 0 4.5698823626333e-07 0 4.5699823626333003e-07 0.00021 4.5700823626333004e-07 0 4.5717282496692986e-07 0 4.571828249669299e-07 0.00021 4.571928249669299e-07 0 4.5724753101466784e-07 0 4.5725753101466785e-07 0.00021 4.5726753101466787e-07 0 4.5726753101466787e-07 0 4.572775310146679e-07 0.00021 4.572875310146679e-07 0 4.572875310146679e-07 0 4.572975310146679e-07 0.00021 4.573075310146679e-07 0 4.5732055457309637e-07 0 4.573305545730964e-07 0.00021 4.573405545730964e-07 0 4.573429989185325e-07 0 4.573529989185325e-07 0.00021 4.573629989185325e-07 0 4.5741287657500887e-07 0 4.574228765750089e-07 0.00021 4.574328765750089e-07 0 4.574330997507633e-07 0 4.5744309975076333e-07 0.00021 4.5745309975076334e-07 0 4.5745309975076334e-07 0 4.5746309975076335e-07 0.00021 4.5747309975076336e-07 0 4.5759545155758324e-07 0 4.5760545155758326e-07 0.00021 4.5761545155758327e-07 0 4.576377875405034e-07 0 4.576477875405034e-07 0.00021 4.576577875405034e-07 0 4.576577875405034e-07 0 4.5766778754050344e-07 0.00021 4.5767778754050345e-07 0 4.5767778754050345e-07 0 4.5768778754050346e-07 0.00021 4.5769778754050347e-07 0 4.5769778754050347e-07 0 4.577077875405035e-07 0.00021 4.577177875405035e-07 0 4.577325362137819e-07 0 4.577425362137819e-07 0.00021 4.577525362137819e-07 0 4.5778748088736865e-07 0 4.5779748088736866e-07 0.00021 4.5780748088736867e-07 0 4.5786033494421075e-07 0 4.5787033494421076e-07 0.00021 4.578803349442108e-07 0 4.578832780328683e-07 0 4.5789327803286833e-07 0.00021 4.5790327803286834e-07 0 4.5790327803286834e-07 0 4.5791327803286835e-07 0.00021 4.5792327803286837e-07 0 4.579551262996636e-07 0 4.579651262996636e-07 0.00021 4.579751262996636e-07 0 4.580901454812631e-07 0 4.581001454812631e-07 0.00021 4.581101454812631e-07 0 4.5813451800852985e-07 0 4.5814451800852986e-07 0.00021 4.581545180085299e-07 0 4.581804740271759e-07 0 4.581904740271759e-07 0.00021 4.582004740271759e-07 0 4.5820496950736436e-07 0 4.5821496950736437e-07 0.00021 4.582249695073644e-07 0 4.583934857773613e-07 0 4.5840348577736133e-07 0.00021 4.5841348577736134e-07 0 4.585545848214337e-07 0 4.585645848214337e-07 0.00021 4.585745848214337e-07 0 4.586785354335174e-07 0 4.586885354335174e-07 0.00021 4.586985354335174e-07 0 4.586985354335174e-07 0 4.5870853543351743e-07 0.00021 4.5871853543351744e-07 0 4.5871853543351744e-07 0 4.5872853543351746e-07 0.00021 4.5873853543351747e-07 0 4.5873853543351747e-07 0 4.587485354335175e-07 0.00021 4.587585354335175e-07 0 4.587585354335175e-07 0 4.587685354335175e-07 0.00021 4.587785354335175e-07 0 4.590685413882136e-07 0 4.5907854138821363e-07 0.00021 4.5908854138821364e-07 0 4.5915021165552113e-07 0 4.5916021165552114e-07 0.00021 4.5917021165552115e-07 0 4.5927190351539486e-07 0 4.5928190351539487e-07 0.00021 4.592919035153949e-07 0 4.592995178155724e-07 0 4.593095178155724e-07 0.00021 4.593195178155724e-07 0 4.593241046063851e-07 0 4.593341046063851e-07 0.00021 4.593441046063851e-07 0 4.594688674515425e-07 0 4.594788674515425e-07 0.00021 4.5948886745154253e-07 0 4.5949022768329917e-07 0 4.595002276832992e-07 0.00021 4.595102276832992e-07 0 4.595102276832992e-07 0 4.595202276832992e-07 0.00021 4.595302276832992e-07 0 4.595302276832992e-07 0 4.5954022768329923e-07 0.00021 4.5955022768329924e-07 0 4.5955022768329924e-07 0 4.5956022768329925e-07 0.00021 4.5957022768329926e-07 0 4.5957022768329926e-07 0 4.595802276832993e-07 0.00021 4.595902276832993e-07 0 4.596461634598058e-07 0 4.5965616345980583e-07 0.00021 4.5966616345980584e-07 0 4.5971326262875283e-07 0 4.5972326262875284e-07 0.00021 4.5973326262875285e-07 0 4.5973326262875285e-07 0 4.5974326262875286e-07 0.00021 4.5975326262875287e-07 0 4.598065761348612e-07 0 4.598165761348612e-07 0.00021 4.5982657613486123e-07 0 4.5982657613486123e-07 0 4.5983657613486124e-07 0.00021 4.5984657613486125e-07 0 4.5991998521995995e-07 0 4.5992998521995997e-07 0.00021 4.5993998521996e-07 0 4.60271309477411e-07 0 4.6028130947741104e-07 0.00021 4.6029130947741105e-07 0 4.6029130947741105e-07 0 4.6030130947741106e-07 0.00021 4.6031130947741107e-07 0 4.6031130947741107e-07 0 4.603213094774111e-07 0.00021 4.603313094774111e-07 0 4.6050871509035055e-07 0 4.6051871509035056e-07 0.00021 4.605287150903506e-07 0 4.6059267025043087e-07 0 4.606026702504309e-07 0.00021 4.606126702504309e-07 0 4.608239881852696e-07 0 4.608339881852696e-07 0.00021 4.608439881852696e-07 0 4.6111235686769494e-07 0 4.6112235686769495e-07 0.00021 4.6113235686769496e-07 0 4.61298191358872e-07 0 4.61308191358872e-07 0.00021 4.6131819135887204e-07 0 4.614173801386575e-07 0 4.614273801386575e-07 0.00021 4.614373801386575e-07 0 4.614398734363829e-07 0 4.614498734363829e-07 0.00021 4.614598734363829e-07 0 4.615784962286879e-07 0 4.6158849622868793e-07 0.00021 4.6159849622868794e-07 0 4.6165589984425973e-07 0 4.6166589984425974e-07 0.00021 4.6167589984425975e-07 0 4.61782068492963e-07 0 4.61792068492963e-07 0.00021 4.61802068492963e-07 0 4.619710703116235e-07 0 4.619810703116235e-07 0.00021 4.619910703116235e-07 0 4.620240155233944e-07 0 4.6203401552339444e-07 0.00021 4.6204401552339445e-07 0 4.620741052596561e-07 0 4.6208410525965613e-07 0.00021 4.6209410525965614e-07 0 4.6209410525965614e-07 0 4.6210410525965615e-07 0.00021 4.6211410525965616e-07 0 4.6216137736057417e-07 0 4.621713773605742e-07 0.00021 4.621813773605742e-07 0 4.621813773605742e-07 0 4.621913773605742e-07 0.00021 4.622013773605742e-07 0 4.622063384186143e-07 0 4.622163384186143e-07 0.00021 4.622263384186143e-07 0 4.622263384186143e-07 0 4.622363384186143e-07 0.00021 4.6224633841861433e-07 0 4.6240954106547305e-07 0 4.6241954106547306e-07 0.00021 4.624295410654731e-07 0 4.624426683408053e-07 0 4.624526683408053e-07 0.00021 4.624626683408053e-07 0 4.6280281358735756e-07 0 4.6281281358735757e-07 0.00021 4.628228135873576e-07 0 4.628281077757855e-07 0 4.628381077757855e-07 0.00021 4.628481077757855e-07 0 4.628481077757855e-07 0 4.6285810777578553e-07 0.00021 4.6286810777578554e-07 0 4.6288262229041087e-07 0 4.628926222904109e-07 0.00021 4.629026222904109e-07 0 4.629104498894828e-07 0 4.629204498894828e-07 0.00021 4.629304498894828e-07 0 4.6308802120276266e-07 0 4.6309802120276267e-07 0.00021 4.631080212027627e-07 0 4.6312130866165043e-07 0 4.6313130866165044e-07 0.00021 4.6314130866165045e-07 0 4.631908830692503e-07 0 4.6320088306925034e-07 0.00021 4.6321088306925035e-07 0 4.632720008458376e-07 0 4.6328200084583763e-07 0.00021 4.6329200084583764e-07 0 4.6355019053059414e-07 0 4.6356019053059415e-07 0.00021 4.6357019053059416e-07 0 4.638535633881511e-07 0 4.6386356338815113e-07 0.00021 4.6387356338815115e-07 0 4.6403647128985237e-07 0 4.640464712898524e-07 0.00021 4.640564712898524e-07 0 4.641687200746489e-07 0 4.641787200746489e-07 0.00021 4.641887200746489e-07 0 4.642508752754982e-07 0 4.642608752754982e-07 0.00021 4.642708752754982e-07 0 4.643019901971529e-07 0 4.643119901971529e-07 0.00021 4.6432199019715294e-07 0 4.643334728668938e-07 0 4.643434728668938e-07 0.00021 4.643534728668938e-07 0 4.6440635685583116e-07 0 4.6441635685583117e-07 0.00021 4.644263568558312e-07 0 4.644694871079615e-07 0 4.6447948710796153e-07 0.00021 4.6448948710796154e-07 0 4.6448948710796154e-07 0 4.6449948710796155e-07 0.00021 4.6450948710796156e-07 0 4.6450948710796156e-07 0 4.645194871079616e-07 0.00021 4.645294871079616e-07 0 4.6458355928406027e-07 0 4.645935592840603e-07 0.00021 4.646035592840603e-07 0 4.64677011074459e-07 0 4.6468701107445904e-07 0.00021 4.6469701107445905e-07 0 4.6486541893580206e-07 0 4.6487541893580207e-07 0.00021 4.648854189358021e-07 0 4.649289848255483e-07 0 4.6493898482554833e-07 0.00021 4.6494898482554834e-07 0 4.649905019369709e-07 0 4.650005019369709e-07 0.00021 4.6501050193697093e-07 0 4.6502514888898374e-07 0 4.6503514888898375e-07 0.00021 4.6504514888898376e-07 0 4.6504799880258896e-07 0 4.6505799880258897e-07 0.00021 4.65067998802589e-07 0 4.65067998802589e-07 0 4.65077998802589e-07 0.00021 4.65087998802589e-07 0 4.65087998802589e-07 0 4.65097998802589e-07 0.00021 4.6510799880258903e-07 0 4.6511616546985244e-07 0 4.6512616546985245e-07 0.00021 4.6513616546985246e-07 0 4.6516365641391635e-07 0 4.6517365641391636e-07 0.00021 4.651836564139164e-07 0 4.6523784720146126e-07 0 4.6524784720146127e-07 0.00021 4.652578472014613e-07 0 4.653010351951864e-07 0 4.6531103519518643e-07 0.00021 4.6532103519518644e-07 0 4.654975317979865e-07 0 4.655075317979865e-07 0.00021 4.655175317979865e-07 0 4.655175317979865e-07 0 4.655275317979865e-07 0.00021 4.655375317979865e-07 0 4.655375317979865e-07 0 4.6554753179798654e-07 0.00021 4.6555753179798655e-07 0 4.6558086803085226e-07 0 4.655908680308523e-07 0.00021 4.656008680308523e-07 0 4.6576262810039306e-07 0 4.6577262810039307e-07 0.00021 4.657826281003931e-07 0 4.657826281003931e-07 0 4.657926281003931e-07 0.00021 4.658026281003931e-07 0 4.658722406131607e-07 0 4.658822406131607e-07 0.00021 4.658922406131607e-07 0 4.659045090118284e-07 0 4.659145090118284e-07 0.00021 4.659245090118284e-07 0 4.6593079416704486e-07 0 4.6594079416704487e-07 0.00021 4.659507941670449e-07 0 4.660445183780719e-07 0 4.6605451837807194e-07 0.00021 4.6606451837807195e-07 0 4.6614563779824785e-07 0 4.6615563779824786e-07 0.00021 4.6616563779824787e-07 0 4.6631198451489677e-07 0 4.663219845148968e-07 0.00021 4.663319845148968e-07 0 4.6646092993171283e-07 0 4.6647092993171285e-07 0.00021 4.6648092993171286e-07 0 4.6648092993171286e-07 0 4.6649092993171287e-07 0.00021 4.665009299317129e-07 0 4.6659342918028233e-07 0 4.6660342918028234e-07 0.00021 4.6661342918028235e-07 0 4.666295707913825e-07 0 4.666395707913825e-07 0.00021 4.666495707913825e-07 0 4.666495707913825e-07 0 4.666595707913825e-07 0.00021 4.666695707913825e-07 0 4.667186685446004e-07 0 4.667286685446004e-07 0.00021 4.667386685446004e-07 0 4.6711874604259757e-07 0 4.671287460425976e-07 0.00021 4.671387460425976e-07 0 4.67247761862905e-07 0 4.67257761862905e-07 0.00021 4.6726776186290503e-07 0 4.6726776186290503e-07 0 4.6727776186290504e-07 0.00021 4.6728776186290505e-07 0 4.6728776186290505e-07 0 4.6729776186290506e-07 0.00021 4.6730776186290507e-07 0 4.6750436422460765e-07 0 4.6751436422460766e-07 0.00021 4.6752436422460767e-07 0 4.675802614374136e-07 0 4.675902614374136e-07 0.00021 4.676002614374136e-07 0 4.6760364805963353e-07 0 4.6761364805963354e-07 0.00021 4.6762364805963355e-07 0 4.676639808947218e-07 0 4.676739808947218e-07 0.00021 4.676839808947218e-07 0 4.676839808947218e-07 0 4.676939808947218e-07 0.00021 4.677039808947218e-07 0 4.677039808947218e-07 0 4.6771398089472184e-07 0.00021 4.6772398089472185e-07 0 4.6772398089472185e-07 0 4.6773398089472186e-07 0.00021 4.6774398089472187e-07 0 4.678278795582922e-07 0 4.678378795582922e-07 0.00021 4.678478795582922e-07 0 4.678478795582922e-07 0 4.678578795582922e-07 0.00021 4.6786787955829223e-07 0 4.6787985714072234e-07 0 4.6788985714072235e-07 0.00021 4.6789985714072236e-07 0 4.6791993430724113e-07 0 4.6792993430724114e-07 0.00021 4.6793993430724116e-07 0 4.680057839628642e-07 0 4.680157839628642e-07 0.00021 4.680257839628642e-07 0 4.680257839628642e-07 0 4.6803578396286423e-07 0.00021 4.6804578396286424e-07 0 4.6827233546488694e-07 0 4.6828233546488695e-07 0.00021 4.6829233546488696e-07 0 4.6829233546488696e-07 0 4.6830233546488697e-07 0.00021 4.68312335464887e-07 0 4.6846155240695234e-07 0 4.6847155240695235e-07 0.00021 4.6848155240695236e-07 0 4.685192417715801e-07 0 4.685292417715801e-07 0.00021 4.6853924177158014e-07 0 4.6856284484758124e-07 0 4.6857284484758126e-07 0.00021 4.6858284484758127e-07 0 4.6860845845949804e-07 0 4.6861845845949805e-07 0.00021 4.6862845845949806e-07 0 4.690413139569718e-07 0 4.690513139569718e-07 0.00021 4.6906131395697183e-07 0 4.6906131395697183e-07 0 4.6907131395697184e-07 0.00021 4.6908131395697186e-07 0 4.6908131395697186e-07 0 4.6909131395697187e-07 0.00021 4.691013139569719e-07 0 4.691598558382884e-07 0 4.691698558382884e-07 0.00021 4.691798558382884e-07 0 4.6919577507475576e-07 0 4.6920577507475577e-07 0.00021 4.692157750747558e-07 0 4.6923533332527907e-07 0 4.692453333252791e-07 0.00021 4.692553333252791e-07 0 4.692553333252791e-07 0 4.692653333252791e-07 0.00021 4.692753333252791e-07 0 4.692753333252791e-07 0 4.6928533332527913e-07 0.00021 4.6929533332527914e-07 0 4.693215335392307e-07 0 4.693315335392307e-07 0.00021 4.693415335392307e-07 0 4.693415335392307e-07 0 4.693515335392307e-07 0.00021 4.693615335392307e-07 0 4.693615335392307e-07 0 4.6937153353923073e-07 0.00021 4.6938153353923074e-07 0 4.6943933467041326e-07 0 4.6944933467041327e-07 0.00021 4.694593346704133e-07 0 4.694593346704133e-07 0 4.694693346704133e-07 0.00021 4.694793346704133e-07 0 4.694793346704133e-07 0 4.694893346704133e-07 0.00021 4.694993346704133e-07 0 4.694993346704133e-07 0 4.6950933467041334e-07 0.00021 4.6951933467041335e-07 0 4.695279290915341e-07 0 4.695379290915341e-07 0.00021 4.695479290915341e-07 0 4.695479290915341e-07 0 4.695579290915341e-07 0.00021 4.6956792909153413e-07 0 4.6964674036691213e-07 0 4.6965674036691214e-07 0.00021 4.6966674036691215e-07 0 4.69678634807185e-07 0 4.69688634807185e-07 0.00021 4.69698634807185e-07 0 4.6974028615932573e-07 0 4.6975028615932575e-07 0.00021 4.6976028615932576e-07 0 4.6976028615932576e-07 0 4.6977028615932577e-07 0.00021 4.697802861593258e-07 0 4.698136347630292e-07 0 4.698236347630292e-07 0.00021 4.698336347630292e-07 0 4.698336347630292e-07 0 4.698436347630292e-07 0.00021 4.6985363476302924e-07 0 4.6988995951782935e-07 0 4.6989995951782936e-07 0.00021 4.6990995951782937e-07 0 4.7007082477263243e-07 0 4.7008082477263244e-07 0.00021 4.7009082477263245e-07 0 4.7009082477263245e-07 0 4.7010082477263246e-07 0.00021 4.701108247726325e-07 0 4.7011200170470846e-07 0 4.7012200170470847e-07 0.00021 4.701320017047085e-07 0 4.702252181673833e-07 0 4.702352181673833e-07 0.00021 4.7024521816738333e-07 0 4.702636764050591e-07 0 4.7027367640505913e-07 0.00021 4.7028367640505914e-07 0 4.7028367640505914e-07 0 4.7029367640505915e-07 0.00021 4.7030367640505917e-07 0 4.7035095297595574e-07 0 4.7036095297595575e-07 0.00021 4.7037095297595576e-07 0 4.7060601867726823e-07 0 4.7061601867726824e-07 0.00021 4.7062601867726826e-07 0 4.706649745941593e-07 0 4.706749745941593e-07 0.00021 4.7068497459415933e-07 0 4.7068497459415933e-07 0 4.7069497459415934e-07 0.00021 4.7070497459415935e-07 0 4.7070497459415935e-07 0 4.7071497459415936e-07 0.00021 4.707249745941594e-07 0 4.707249745941594e-07 0 4.707349745941594e-07 0.00021 4.707449745941594e-07 0 4.707620178044303e-07 0 4.707720178044303e-07 0.00021 4.707820178044303e-07 0 4.707820178044303e-07 0 4.707920178044303e-07 0.00021 4.7080201780443033e-07 0 4.708768147337603e-07 0 4.7088681473376033e-07 0.00021 4.7089681473376034e-07 0 4.709270594657894e-07 0 4.7093705946578943e-07 0.00021 4.7094705946578944e-07 0 4.7094705946578944e-07 0 4.7095705946578945e-07 0.00021 4.7096705946578947e-07 0 4.7096705946578947e-07 0 4.709770594657895e-07 0.00021 4.709870594657895e-07 0 4.709870594657895e-07 0 4.709970594657895e-07 0.00021 4.710070594657895e-07 0 4.710070594657895e-07 0 4.710170594657895e-07 0.00021 4.7102705946578953e-07 0 4.7102705946578953e-07 0 4.7103705946578955e-07 0.00021 4.7104705946578956e-07 0 4.710478564202755e-07 0 4.710578564202755e-07 0.00021 4.710678564202755e-07 0 4.7107157473917324e-07 0 4.7108157473917325e-07 0.00021 4.7109157473917326e-07 0 4.710941385206804e-07 0 4.711041385206804e-07 0.00021 4.7111413852068043e-07 0 4.7112045156317034e-07 0 4.7113045156317035e-07 0.00021 4.7114045156317036e-07 0 4.7114045156317036e-07 0 4.7115045156317037e-07 0.00021 4.711604515631704e-07 0 4.7127467581358444e-07 0 4.7128467581358445e-07 0.00021 4.7129467581358446e-07 0 4.7129467581358446e-07 0 4.7130467581358447e-07 0.00021 4.713146758135845e-07 0 4.713146758135845e-07 0 4.713246758135845e-07 0.00021 4.713346758135845e-07 0 4.71384100314226e-07 0 4.71394100314226e-07 0.00021 4.7140410031422603e-07 0 4.7140410031422603e-07 0 4.7141410031422604e-07 0.00021 4.7142410031422605e-07 0 4.7142410031422605e-07 0 4.7143410031422607e-07 0.00021 4.714441003142261e-07 0 4.7147185502110995e-07 0 4.7148185502110996e-07 0.00021 4.7149185502110997e-07 0 4.715263856886385e-07 0 4.715363856886385e-07 0.00021 4.715463856886385e-07 0 4.7159157242375395e-07 0 4.7160157242375396e-07 0.00021 4.7161157242375397e-07 0 4.7161157242375397e-07 0 4.71621572423754e-07 0.00021 4.71631572423754e-07 0 4.71666924686078e-07 0 4.71676924686078e-07 0.00021 4.71686924686078e-07 0 4.71686924686078e-07 0 4.7169692468607803e-07 0.00021 4.7170692468607804e-07 0 4.7174723561762683e-07 0 4.7175723561762684e-07 0.00021 4.7176723561762686e-07 0 4.717715911595522e-07 0 4.717815911595522e-07 0.00021 4.7179159115955223e-07 0 4.7201083040206e-07 0 4.7202083040206e-07 0.00021 4.7203083040206004e-07 0 4.7203804353513766e-07 0 4.7204804353513767e-07 0.00021 4.720580435351377e-07 0 4.720580435351377e-07 0 4.720680435351377e-07 0.00021 4.720780435351377e-07 0 4.7219971380578453e-07 0 4.7220971380578454e-07 0.00021 4.7221971380578455e-07 0 4.7239985705782025e-07 0 4.7240985705782026e-07 0.00021 4.7241985705782027e-07 0 4.7244310304931277e-07 0 4.724531030493128e-07 0.00021 4.724631030493128e-07 0 4.724942950184617e-07 0 4.725042950184617e-07 0.00021 4.725142950184617e-07 0 4.7262869598612295e-07 0 4.7263869598612296e-07 0.00021 4.72648695986123e-07 0 4.727004605105379e-07 0 4.727104605105379e-07 0.00021 4.7272046051053793e-07 0 4.7290779813498664e-07 0 4.7291779813498665e-07 0.00021 4.7292779813498666e-07 0 4.730352230571583e-07 0 4.730452230571583e-07 0.00021 4.730552230571583e-07 0 4.7309262567117043e-07 0 4.7310262567117045e-07 0.00021 4.7311262567117046e-07 0 4.732038905971379e-07 0 4.732138905971379e-07 0.00021 4.732238905971379e-07 0 4.7338215217320447e-07 0 4.733921521732045e-07 0.00021 4.734021521732045e-07 0 4.734021521732045e-07 0 4.734121521732045e-07 0.00021 4.734221521732045e-07 0 4.736577490501511e-07 0 4.736677490501511e-07 0.00021 4.736777490501511e-07 0 4.7384169072096644e-07 0 4.7385169072096645e-07 0.00021 4.7386169072096646e-07 0 4.7390878217003717e-07 0 4.739187821700372e-07 0.00021 4.739287821700372e-07 0 4.739287821700372e-07 0 4.739387821700372e-07 0.00021 4.739487821700372e-07 0 4.740917658453345e-07 0 4.7410176584533453e-07 0.00021 4.7411176584533454e-07 0 4.741695332342521e-07 0 4.741795332342521e-07 0.00021 4.7418953323425214e-07 0 4.742324669310042e-07 0 4.7424246693100424e-07 0.00021 4.7425246693100425e-07 0 4.7425246693100425e-07 0 4.7426246693100426e-07 0.00021 4.7427246693100427e-07 0 4.7427246693100427e-07 0 4.742824669310043e-07 0.00021 4.742924669310043e-07 0 4.742924669310043e-07 0 4.743024669310043e-07 0.00021 4.743124669310043e-07 0 4.743491004903074e-07 0 4.743591004903074e-07 0.00021 4.743691004903074e-07 0 4.746039498789312e-07 0 4.746139498789312e-07 0.00021 4.7462394987893123e-07 0 4.746337255481694e-07 0 4.746437255481694e-07 0.00021 4.7465372554816943e-07 0 4.748234405564873e-07 0 4.748334405564873e-07 0.00021 4.748434405564873e-07 0 4.748479256155474e-07 0 4.748579256155474e-07 0.00021 4.748679256155474e-07 0 4.7505591482688793e-07 0 4.7506591482688794e-07 0.00021 4.7507591482688795e-07 0 4.7511728439286794e-07 0 4.7512728439286795e-07 0.00021 4.7513728439286796e-07 0 4.7548077456981656e-07 0 4.7549077456981657e-07 0.00021 4.755007745698166e-07 0 4.7556688501939885e-07 0 4.7557688501939886e-07 0.00021 4.7558688501939887e-07 0 4.7561193452751564e-07 0 4.7562193452751565e-07 0.00021 4.7563193452751566e-07 0 4.7584048405371455e-07 0 4.7585048405371457e-07 0.00021 4.758604840537146e-07 0 4.7588203474755906e-07 0 4.7589203474755907e-07 0.00021 4.759020347475591e-07 0 4.7600410739158407e-07 0 4.760141073915841e-07 0.00021 4.760241073915841e-07 0 4.760241073915841e-07 0 4.760341073915841e-07 0.00021 4.760441073915841e-07 0 4.760441073915841e-07 0 4.760541073915841e-07 0.00021 4.7606410739158414e-07 0 4.7607346584208376e-07 0 4.7608346584208377e-07 0.00021 4.760934658420838e-07 0 4.7609717065969455e-07 0 4.7610717065969456e-07 0.00021 4.7611717065969457e-07 0 4.762376785822648e-07 0 4.7624767858226483e-07 0.00021 4.7625767858226485e-07 0 4.763030812502776e-07 0 4.763130812502776e-07 0.00021 4.763230812502776e-07 0 4.764260452126907e-07 0 4.764360452126907e-07 0.00021 4.764460452126907e-07 0 4.7644763688354113e-07 0 4.7645763688354115e-07 0.00021 4.7646763688354116e-07 0 4.765327681541912e-07 0 4.765427681541912e-07 0.00021 4.7655276815419123e-07 0 4.7664836931994296e-07 0 4.7665836931994297e-07 0.00021 4.76668369319943e-07 0 4.7668095494450624e-07 0 4.7669095494450625e-07 0.00021 4.7670095494450626e-07 0 4.7678481645260286e-07 0 4.7679481645260287e-07 0.00021 4.768048164526029e-07 0 4.76843149413378e-07 0 4.768531494133779e-07 0.00021 4.768631494133779e-07 0 4.768909792123291e-07 0 4.76900979212329e-07 0.00021 4.76910979212329e-07 0 4.769109792123291e-07 0 4.76920979212329e-07 0.00021 4.76930979212329e-07 0 4.769309792123291e-07 0 4.769409792123291e-07 0.00021 4.76950979212329e-07 0 4.769509792123291e-07 0 4.769609792123291e-07 0.00021 4.76970979212329e-07 0 4.770931086241831e-07 0 4.77103108624183e-07 0.00021 4.77113108624183e-07 0 4.772405375524255e-07 0 4.772505375524255e-07 0.00021 4.772605375524254e-07 0 4.772605375524255e-07 0 4.772705375524255e-07 0.00021 4.772805375524255e-07 0 4.773231885835072e-07 0 4.773331885835072e-07 0.00021 4.773431885835072e-07 0 4.774583063626612e-07 0 4.774683063626612e-07 0.00021 4.774783063626611e-07 0 4.774890011226507e-07 0 4.774990011226506e-07 0.00021 4.775090011226506e-07 0 4.775090011226507e-07 0 4.775190011226507e-07 0.00021 4.775290011226506e-07 0 4.775650470993597e-07 0 4.775750470993596e-07 0.00021 4.775850470993596e-07 0 4.77588750359232e-07 0 4.77598750359232e-07 0.00021 4.776087503592319e-07 0 4.777260872654713e-07 0 4.777360872654713e-07 0.00021 4.777460872654712e-07 0 4.779200033142758e-07 0 4.779300033142758e-07 0.00021 4.779400033142758e-07 0 4.78080813038994e-07 0 4.78090813038994e-07 0.00021 4.781008130389939e-07 0 4.782708674913209e-07 0 4.782808674913208e-07 0.00021 4.782908674913208e-07 0 4.783175598726466e-07 0 4.783275598726465e-07 0.00021 4.783375598726465e-07 0 4.78380760227713e-07 0 4.783907602277129e-07 0.00021 4.784007602277129e-07 0 4.78400760227713e-07 0 4.78410760227713e-07 0.00021 4.784207602277129e-07 0 4.785215185552546e-07 0 4.785315185552546e-07 0.00021 4.785415185552546e-07 0 4.786046746927994e-07 0 4.786146746927994e-07 0.00021 4.786246746927994e-07 0 4.787260743997076e-07 0 4.787360743997076e-07 0.00021 4.787460743997076e-07 0 4.788230073852133e-07 0 4.788330073852133e-07 0.00021 4.788430073852132e-07 0 4.788653279937492e-07 0 4.788753279937492e-07 0.00021 4.788853279937491e-07 0 4.789229832797529e-07 0 4.789329832797528e-07 0.00021 4.789429832797528e-07 0 4.789465720366873e-07 0 4.789565720366872e-07 0.00021 4.789665720366872e-07 0 4.789665720366873e-07 0 4.789765720366872e-07 0.00021 4.789865720366872e-07 0 4.789986480603545e-07 0 4.790086480603545e-07 0.00021 4.790186480603545e-07 0 4.790310883403572e-07 0 4.790410883403572e-07 0.00021 4.790510883403571e-07 0 4.7905263520004e-07 0 4.790626352000399e-07 0.00021 4.790726352000399e-07 0 4.791365530698464e-07 0 4.791465530698463e-07 0.00021 4.791565530698463e-07 0 4.79165782731443e-07 0 4.791757827314429e-07 0.00021 4.791857827314429e-07 0 4.792592115367401e-07 0 4.7926921153674e-07 0.00021 4.7927921153674e-07 0 4.793371579946814e-07 0 4.793471579946813e-07 0.00021 4.793571579946813e-07 0 4.793571579946814e-07 0 4.793671579946814e-07 0.00021 4.793771579946813e-07 0 4.794068940301002e-07 0 4.794168940301002e-07 0.00021 4.794268940301001e-07 0 4.795133325400512e-07 0 4.795233325400511e-07 0.00021 4.795333325400511e-07 0 4.795517227988626e-07 0 4.795617227988626e-07 0.00021 4.795717227988626e-07 0 4.795717227988627e-07 0 4.795817227988626e-07 0.00021 4.795917227988626e-07 0 4.79668166192921e-07 0 4.79678166192921e-07 0.00021 4.79688166192921e-07 0 4.797004769177784e-07 0 4.797104769177783e-07 0.00021 4.797204769177783e-07 0 4.797307742650796e-07 0 4.797407742650795e-07 0.00021 4.797507742650795e-07 0 4.797562236740689e-07 0 4.797662236740688e-07 0.00021 4.797762236740688e-07 0 4.80014177995785e-07 0 4.800241779957849e-07 0.00021 4.800341779957849e-07 0 4.80201475501628e-07 0 4.802114755016279e-07 0.00021 4.802214755016279e-07 0 4.802405631085584e-07 0 4.802505631085584e-07 0.00021 4.802605631085584e-07 0 4.80381487774942e-07 0 4.80391487774942e-07 0.00021 4.80401487774942e-07 0 4.804014877749421e-07 0 4.80411487774942e-07 0.00021 4.80421487774942e-07 0 4.804834323133832e-07 0 4.804934323133831e-07 0.00021 4.805034323133831e-07 0 4.805866613323578e-07 0 4.805966613323578e-07 0.00021 4.806066613323578e-07 0 4.806832774058841e-07 0 4.806932774058841e-07 0.00021 4.80703277405884e-07 0 4.807540468916989e-07 0 4.807640468916988e-07 0.00021 4.807740468916988e-07 0 4.807740468916989e-07 0 4.807840468916989e-07 0.00021 4.807940468916988e-07 0 4.807940468916989e-07 0 4.808040468916989e-07 0.00021 4.808140468916988e-07 0 4.809913352386641e-07 0 4.81001335238664e-07 0.00021 4.81011335238664e-07 0 4.81053088141498e-07 0 4.81063088141498e-07 0.00021 4.81073088141498e-07 0 4.811780262418187e-07 0 4.811880262418186e-07 0.00021 4.811980262418186e-07 0 4.8123460371038e-07 0 4.812446037103799e-07 0.00021 4.812546037103799e-07 0 4.813184312355479e-07 0 4.813284312355479e-07 0.00021 4.813384312355478e-07 0 4.813425035115485e-07 0 4.813525035115484e-07 0.00021 4.813625035115484e-07 0 4.814391717978209e-07 0 4.814491717978209e-07 0.00021 4.814591717978208e-07 0 4.815045053258592e-07 0 4.815145053258591e-07 0.00021 4.815245053258591e-07 0 4.815499690094725e-07 0 4.815599690094725e-07 0.00021 4.815699690094725e-07 0 4.816214960036398e-07 0 4.816314960036398e-07 0.00021 4.816414960036397e-07 0 4.816829764195469e-07 0 4.816929764195469e-07 0.00021 4.817029764195468e-07 0 4.817029764195469e-07 0 4.817129764195469e-07 0.00021 4.817229764195469e-07 0 4.817501946318012e-07 0 4.817601946318011e-07 0.00021 4.817701946318011e-07 0 4.818857664736835e-07 0 4.818957664736835e-07 0.00021 4.819057664736834e-07 0 4.819702112443091e-07 0 4.819802112443091e-07 0.00021 4.81990211244309e-07 0 4.819902804763383e-07 0 4.820002804763383e-07 0.00021 4.820102804763382e-07 0 4.820287954140484e-07 0 4.820387954140484e-07 0.00021 4.820487954140483e-07 0 4.820688245698302e-07 0 4.820788245698301e-07 0.00021 4.820888245698301e-07 0 4.820888245698302e-07 0 4.820988245698302e-07 0.00021 4.821088245698301e-07 0 4.821088245698302e-07 0 4.821188245698302e-07 0.00021 4.821288245698302e-07 0 4.821455668282568e-07 0 4.821555668282567e-07 0.00021 4.821655668282567e-07 0 4.822105050542051e-07 0 4.822205050542051e-07 0.00021 4.822305050542051e-07 0 4.822305050542052e-07 0 4.822405050542051e-07 0.00021 4.822505050542051e-07 0 4.822505050542052e-07 0 4.822605050542051e-07 0.00021 4.822705050542051e-07 0 4.824834763166022e-07 0 4.824934763166022e-07 0.00021 4.825034763166021e-07 0 4.825655464205057e-07 0 4.825755464205057e-07 0.00021 4.825855464205056e-07 0 4.825855464205057e-07 0 4.825955464205057e-07 0.00021 4.826055464205056e-07 0 4.826857467799903e-07 0 4.826957467799903e-07 0.00021 4.827057467799902e-07 0 4.827077149248964e-07 0 4.827177149248964e-07 0.00021 4.827277149248963e-07 0 4.827758812309748e-07 0 4.827858812309748e-07 0.00021 4.827958812309747e-07 0 4.828515429610827e-07 0 4.828615429610827e-07 0.00021 4.828715429610826e-07 0 4.828715429610827e-07 0 4.828815429610827e-07 0.00021 4.828915429610826e-07 0 4.829127750403565e-07 0 4.829227750403565e-07 0.00021 4.829327750403564e-07 0 4.830517952495693e-07 0 4.830617952495692e-07 0.00021 4.830717952495692e-07 0 4.831606724740467e-07 0 4.831706724740467e-07 0.00021 4.831806724740466e-07 0 4.831806724740467e-07 0 4.831906724740467e-07 0.00021 4.832006724740466e-07 0 4.832006724740467e-07 0 4.832106724740467e-07 0.00021 4.832206724740467e-07 0 4.832206724740468e-07 0 4.832306724740467e-07 0.00021 4.832406724740467e-07 0 4.832406724740468e-07 0 4.832506724740467e-07 0.00021 4.832606724740467e-07 0 4.832606724740468e-07 0 4.832706724740468e-07 0.00021 4.832806724740467e-07 0 4.832806724740468e-07 0 4.832906724740468e-07 0.00021 4.833006724740467e-07 0 4.833757457731799e-07 0 4.833857457731799e-07 0.00021 4.833957457731799e-07 0 4.8339574577318e-07 0 4.834057457731799e-07 0.00021 4.834157457731799e-07 0 4.834488800717862e-07 0 4.834588800717862e-07 0.00021 4.834688800717861e-07 0 4.834688800717862e-07 0 4.834788800717862e-07 0.00021 4.834888800717862e-07 0 4.836194572609777e-07 0 4.836294572609777e-07 0.00021 4.836394572609776e-07 0 4.836394572609777e-07 0 4.836494572609777e-07 0.00021 4.836594572609776e-07 0 4.836594572609778e-07 0 4.836694572609777e-07 0.00021 4.836794572609777e-07 0 4.836794572609778e-07 0 4.836894572609777e-07 0.00021 4.836994572609777e-07 0 4.838051039947496e-07 0 4.838151039947495e-07 0.00021 4.838251039947495e-07 0 4.838542724250192e-07 0 4.838642724250191e-07 0.00021 4.838742724250191e-07 0 4.838742724250192e-07 0 4.838842724250192e-07 0.00021 4.838942724250191e-07 0 4.83995768092303e-07 0 4.84005768092303e-07 0.00021 4.840157680923029e-07 0 4.840990940620546e-07 0 4.841090940620546e-07 0.00021 4.841190940620546e-07 0 4.841710603910753e-07 0 4.841810603910753e-07 0.00021 4.841910603910752e-07 0 4.842916089262174e-07 0 4.843016089262174e-07 0.00021 4.843116089262173e-07 0 4.843116089262174e-07 0 4.843216089262174e-07 0.00021 4.843316089262174e-07 0 4.843899605846083e-07 0 4.843999605846083e-07 0.00021 4.844099605846083e-07 0 4.845277510416763e-07 0 4.845377510416763e-07 0.00021 4.845477510416762e-07 0 4.846116221046645e-07 0 4.846216221046644e-07 0.00021 4.846316221046644e-07 0 4.848284781556879e-07 0 4.848384781556879e-07 0.00021 4.848484781556878e-07 0 4.848638966942818e-07 0 4.848738966942817e-07 0.00021 4.848838966942817e-07 0 4.848838966942818e-07 0 4.848938966942818e-07 0.00021 4.849038966942817e-07 0 4.849080684733779e-07 0 4.849180684733778e-07 0.00021 4.849280684733778e-07 0 4.849280684733779e-07 0 4.849380684733778e-07 0.00021 4.849480684733778e-07 0 4.849480684733779e-07 0 4.849580684733779e-07 0.00021 4.849680684733778e-07 0 4.851536526325977e-07 0 4.851636526325977e-07 0.00021 4.851736526325976e-07 0 4.851736526325977e-07 0 4.851836526325977e-07 0.00021 4.851936526325976e-07 0 4.851936526325977e-07 0 4.852036526325977e-07 0.00021 4.852136526325977e-07 0 4.852136526325978e-07 0 4.852236526325977e-07 0.00021 4.852336526325977e-07 0 4.852336526325978e-07 0 4.852436526325978e-07 0.00021 4.852536526325977e-07 0 4.857278752824192e-07 0 4.857378752824191e-07 0.00021 4.857478752824191e-07 0 4.857745303739362e-07 0 4.857845303739361e-07 0.00021 4.857945303739361e-07 0 4.857945303739362e-07 0 4.858045303739361e-07 0.00021 4.858145303739361e-07 0 4.85951366204389e-07 0 4.85961366204389e-07 0.00021 4.859713662043889e-07 0 4.860151859869435e-07 0 4.860251859869435e-07 0.00021 4.860351859869434e-07 0 4.860831643698367e-07 0 4.860931643698367e-07 0.00021 4.861031643698366e-07 0 4.861031643698367e-07 0 4.861131643698367e-07 0.00021 4.861231643698367e-07 0 4.861231643698368e-07 0 4.861331643698367e-07 0.00021 4.861431643698367e-07 0 4.861431643698368e-07 0 4.861531643698368e-07 0.00021 4.861631643698367e-07 0 4.861631643698368e-07 0 4.861731643698368e-07 0.00021 4.861831643698367e-07 0 4.863735905869455e-07 0 4.863835905869454e-07 0.00021 4.863935905869454e-07 0 4.864142006989217e-07 0 4.864242006989216e-07 0.00021 4.864342006989216e-07 0 4.866261894695437e-07 0 4.866361894695436e-07 0.00021 4.866461894695436e-07 0 4.866580412947706e-07 0 4.866680412947706e-07 0.00021 4.866780412947705e-07 0 4.867122072275366e-07 0 4.867222072275366e-07 0.00021 4.867322072275365e-07 0 4.867322072275366e-07 0 4.867422072275366e-07 0.00021 4.867522072275366e-07 0 4.867522072275367e-07 0 4.867622072275366e-07 0.00021 4.867722072275366e-07 0 4.869071835935902e-07 0 4.869171835935901e-07 0.00021 4.869271835935901e-07 0 4.869273234082853e-07 0 4.869373234082853e-07 0.00021 4.869473234082852e-07 0 4.870907780419744e-07 0 4.871007780419743e-07 0.00021 4.871107780419743e-07 0 4.871107780419744e-07 0 4.871207780419743e-07 0.00021 4.871307780419743e-07 0 4.872726404401309e-07 0 4.872826404401308e-07 0.00021 4.872926404401308e-07 0 4.872926404401309e-07 0 4.873026404401308e-07 0.00021 4.873126404401308e-07 0 4.873348250032107e-07 0 4.873448250032106e-07 0.00021 4.873548250032106e-07 0 4.87415586285776e-07 0 4.874255862857759e-07 0.00021 4.874355862857759e-07 0 4.87435586285776e-07 0 4.87445586285776e-07 0.00021 4.874555862857759e-07 0 4.875302958556008e-07 0 4.875402958556007e-07 0.00021 4.875502958556007e-07 0 4.876168338886951e-07 0 4.87626833888695e-07 0.00021 4.87636833888695e-07 0 4.876623992123457e-07 0 4.876723992123457e-07 0.00021 4.876823992123457e-07 0 4.880314747260922e-07 0 4.880414747260921e-07 0.00021 4.880514747260921e-07 0 4.880514747260922e-07 0 4.880614747260921e-07 0.00021 4.880714747260921e-07 0 4.880714747260922e-07 0 4.880814747260922e-07 0.00021 4.880914747260921e-07 0 4.881161432515189e-07 0 4.881261432515188e-07 0.00021 4.881361432515188e-07 0 4.881361432515189e-07 0 4.881461432515188e-07 0.00021 4.881561432515188e-07 0 4.881573318884339e-07 0 4.881673318884338e-07 0.00021 4.881773318884338e-07 0 4.882842941738862e-07 0 4.882942941738861e-07 0.00021 4.883042941738861e-07 0 4.883042941738862e-07 0 4.883142941738861e-07 0.00021 4.883242941738861e-07 0 4.883242941738862e-07 0 4.883342941738862e-07 0.00021 4.883442941738861e-07 0 4.883442941738862e-07 0 4.883542941738862e-07 0.00021 4.883642941738861e-07 0 4.883642941738863e-07 0 4.883742941738862e-07 0.00021 4.883842941738862e-07 0 4.884425647491641e-07 0 4.884525647491641e-07 0.00021 4.88462564749164e-07 0 4.88477653666426e-07 0 4.88487653666426e-07 0.00021 4.88497653666426e-07 0 4.885020590954422e-07 0 4.885120590954422e-07 0.00021 4.885220590954421e-07 0 4.885839312179032e-07 0 4.885939312179031e-07 0.00021 4.886039312179031e-07 0 4.887417510122102e-07 0 4.887517510122102e-07 0.00021 4.887617510122101e-07 0 4.887757702891803e-07 0 4.887857702891803e-07 0.00021 4.887957702891802e-07 0 4.887957702891803e-07 0 4.888057702891803e-07 0.00021 4.888157702891802e-07 0 4.890805419120403e-07 0 4.890905419120403e-07 0.00021 4.891005419120402e-07 0 4.891012246659233e-07 0 4.891112246659233e-07 0.00021 4.891212246659232e-07 0 4.892435229679367e-07 0 4.892535229679366e-07 0.00021 4.892635229679366e-07 0 4.892905094030876e-07 0 4.893005094030876e-07 0.00021 4.893105094030875e-07 0 4.893105094030877e-07 0 4.893205094030876e-07 0.00021 4.893305094030876e-07 0 4.893305094030877e-07 0 4.893405094030876e-07 0.00021 4.893505094030876e-07 0 4.895882280118265e-07 0 4.895982280118265e-07 0.00021 4.896082280118264e-07 0 4.896570172114347e-07 0 4.896670172114346e-07 0.00021 4.896770172114346e-07 0 4.897639904357472e-07 0 4.897739904357471e-07 0.00021 4.897839904357471e-07 0 4.897839904357472e-07 0 4.897939904357472e-07 0.00021 4.898039904357471e-07 0 4.898039904357472e-07 0 4.898139904357472e-07 0.00021 4.898239904357471e-07 0 4.898239904357473e-07 0 4.898339904357472e-07 0.00021 4.898439904357472e-07 0 4.898439904357473e-07 0 4.898539904357472e-07 0.00021 4.898639904357472e-07 0 4.899276774963993e-07 0 4.899376774963993e-07 0.00021 4.899476774963992e-07 0 4.899695212893333e-07 0 4.899795212893332e-07 0.00021 4.899895212893332e-07 0 4.900279265774859e-07 0 4.900379265774859e-07 0.00021 4.900479265774859e-07 0 4.901324412883409e-07 0 4.901424412883409e-07 0.00021 4.901524412883409e-07 0 4.901562075405925e-07 0 4.901662075405924e-07 0.00021 4.901762075405924e-07 0 4.902128809140886e-07 0 4.902228809140886e-07 0.00021 4.902328809140886e-07 0 4.902598147389796e-07 0 4.902698147389796e-07 0.00021 4.902798147389795e-07 0 4.902798147389796e-07 0 4.902898147389796e-07 0.00021 4.902998147389796e-07 0 4.902998147389797e-07 0 4.903098147389796e-07 0.00021 4.903198147389796e-07 0 4.903466829030472e-07 0 4.903566829030471e-07 0.00021 4.903666829030471e-07 0 4.903830996865388e-07 0 4.903930996865388e-07 0.00021 4.904030996865387e-07 0 4.904401563269679e-07 0 4.904501563269679e-07 0.00021 4.904601563269678e-07 0 4.90460156326968e-07 0 4.904701563269679e-07 0.00021 4.904801563269679e-07 0 4.90480156326968e-07 0 4.904901563269679e-07 0.00021 4.905001563269679e-07 0 4.909838954416092e-07 0 4.909938954416091e-07 0.00021 4.910038954416091e-07 0 4.910098665694132e-07 0 4.910198665694131e-07 0.00021 4.910298665694131e-07 0 4.910448612669513e-07 0 4.910548612669512e-07 0.00021 4.910648612669512e-07 0 4.911428187799144e-07 0 4.911528187799144e-07 0.00021 4.911628187799143e-07 0 4.911628187799144e-07 0 4.911728187799144e-07 0.00021 4.911828187799144e-07 0 4.911828187799145e-07 0 4.911928187799144e-07 0.00021 4.912028187799144e-07 0 4.91230244684851e-07 0 4.91240244684851e-07 0.00021 4.912502446848509e-07 0 4.91269490949714e-07 0 4.91279490949714e-07 0.00021 4.912894909497139e-07 0 4.913455954292351e-07 0 4.91355595429235e-07 0.00021 4.91365595429235e-07 0 4.913724336146772e-07 0 4.913824336146772e-07 0.00021 4.913924336146771e-07 0 4.913924336146772e-07 0 4.914024336146772e-07 0.00021 4.914124336146772e-07 0 4.914124336146773e-07 0 4.914224336146772e-07 0.00021 4.914324336146772e-07 0 4.914324336146773e-07 0 4.914424336146772e-07 0.00021 4.914524336146772e-07 0 4.914742658844243e-07 0 4.914842658844242e-07 0.00021 4.914942658844242e-07 0 4.915380085841775e-07 0 4.915480085841775e-07 0.00021 4.915580085841775e-07 0 4.918266686842499e-07 0 4.918366686842499e-07 0.00021 4.918466686842498e-07 0 4.921202879372225e-07 0 4.921302879372225e-07 0.00021 4.921402879372224e-07 0 4.921402879372225e-07 0 4.921502879372225e-07 0.00021 4.921602879372224e-07 0 4.921602879372225e-07 0 4.921702879372225e-07 0.00021 4.921802879372225e-07 0 4.921802879372226e-07 0 4.921902879372225e-07 0.00021 4.922002879372225e-07 0 4.922002879372226e-07 0 4.922102879372225e-07 0.00021 4.922202879372225e-07 0 4.922202879372226e-07 0 4.922302879372226e-07 0.00021 4.922402879372225e-07 0 4.923217233529763e-07 0 4.923317233529762e-07 0.00021 4.923417233529762e-07 0 4.923417233529763e-07 0 4.923517233529762e-07 0.00021 4.923617233529762e-07 0 4.923617233529763e-07 0 4.923717233529763e-07 0.00021 4.923817233529762e-07 0 4.923817233529763e-07 0 4.923917233529763e-07 0.00021 4.924017233529763e-07 0 4.924017233529764e-07 0 4.924117233529763e-07 0.00021 4.924217233529763e-07 0 4.925615893178352e-07 0 4.925715893178352e-07 0.00021 4.925815893178351e-07 0 4.927529592017324e-07 0 4.927629592017324e-07 0.00021 4.927729592017324e-07 0 4.927898762822213e-07 0 4.927998762822213e-07 0.00021 4.928098762822212e-07 0 4.930555725545619e-07 0 4.930655725545618e-07 0.00021 4.930755725545618e-07 0 4.931443895022986e-07 0 4.931543895022985e-07 0.00021 4.931643895022985e-07 0 4.931787046323364e-07 0 4.931887046323363e-07 0.00021 4.931987046323363e-07 0 4.931987046323364e-07 0 4.932087046323364e-07 0.00021 4.932187046323363e-07 0 4.9342762040958e-07 0 4.934376204095799e-07 0.00021 4.934476204095799e-07 0 4.9344762040958e-07 0 4.934576204095799e-07 0.00021 4.934676204095799e-07 0 4.935216423374748e-07 0 4.935316423374748e-07 0.00021 4.935416423374747e-07 0 4.936025406220234e-07 0 4.936125406220234e-07 0.00021 4.936225406220234e-07 0 4.936225406220235e-07 0 4.936325406220234e-07 0.00021 4.936425406220234e-07 0 4.936425406220235e-07 0 4.936525406220234e-07 0.00021 4.936625406220234e-07 0 4.937270433223887e-07 0 4.937370433223886e-07 0.00021 4.937470433223886e-07 0 4.937581332792791e-07 0 4.937681332792791e-07 0.00021 4.937781332792791e-07 0 4.937781332792792e-07 0 4.937881332792791e-07 0.00021 4.937981332792791e-07 0 4.938198816471098e-07 0 4.938298816471098e-07 0.00021 4.938398816471097e-07 0 4.938398816471099e-07 0 4.938498816471098e-07 0.00021 4.938598816471098e-07 0 4.939002238221792e-07 0 4.939102238221792e-07 0.00021 4.939202238221791e-07 0 4.939202238221792e-07 0 4.939302238221792e-07 0.00021 4.939402238221792e-07 0 4.939889938468101e-07 0 4.939989938468101e-07 0.00021 4.9400899384681e-07 0 4.941040903567507e-07 0 4.941140903567506e-07 0.00021 4.941240903567506e-07 0 4.941826128568622e-07 0 4.941926128568622e-07 0.00021 4.942026128568621e-07 0 4.942345868695025e-07 0 4.942445868695024e-07 0.00021 4.942545868695024e-07 0 4.944153960243336e-07 0 4.944253960243336e-07 0.00021 4.944353960243335e-07 0 4.946230140800491e-07 0 4.946330140800491e-07 0.00021 4.94643014080049e-07 0 4.946430140800491e-07 0 4.946530140800491e-07 0.00021 4.94663014080049e-07 0 4.946737046392534e-07 0 4.946837046392534e-07 0.00021 4.946937046392534e-07 0 4.947206205793196e-07 0 4.947306205793195e-07 0.00021 4.947406205793195e-07 0 4.947406205793196e-07 0 4.947506205793195e-07 0.00021 4.947606205793195e-07 0 4.947606205793196e-07 0 4.947706205793196e-07 0.00021 4.947806205793195e-07 0 4.947806205793196e-07 0 4.947906205793196e-07 0.00021 4.948006205793195e-07 0 4.948006205793196e-07 0 4.948106205793196e-07 0.00021 4.948206205793196e-07 0 4.948206205793197e-07 0 4.948306205793196e-07 0.00021 4.948406205793196e-07 0 4.948406205793197e-07 0 4.948506205793196e-07 0.00021 4.948606205793196e-07 0 4.948620323895854e-07 0 4.948720323895854e-07 0.00021 4.948820323895853e-07 0 4.949583859872912e-07 0 4.949683859872911e-07 0.00021 4.949783859872911e-07 0 4.94979131240229e-07 0 4.94989131240229e-07 0.00021 4.94999131240229e-07 0 4.951961643540046e-07 0 4.952061643540046e-07 0.00021 4.952161643540045e-07 0 4.952458579217617e-07 0 4.952558579217617e-07 0.00021 4.952658579217617e-07 0 4.953819626232963e-07 0 4.953919626232963e-07 0.00021 4.954019626232963e-07 0 4.954195257175616e-07 0 4.954295257175615e-07 0.00021 4.954395257175615e-07 0 4.954914929435885e-07 0 4.955014929435884e-07 0.00021 4.955114929435884e-07 0 4.955114929435885e-07 0 4.955214929435884e-07 0.00021 4.955314929435884e-07 0 4.955314929435885e-07 0 4.955414929435885e-07 0.00021 4.955514929435884e-07 0 4.956865555297748e-07 0 4.956965555297747e-07 0.00021 4.957065555297747e-07 0 4.957065555297748e-07 0 4.957165555297747e-07 0.00021 4.957265555297747e-07 0 4.957393365023421e-07 0 4.957493365023421e-07 0.00021 4.957593365023421e-07 0 4.959041245990229e-07 0 4.959141245990228e-07 0.00021 4.959241245990228e-07 0 4.960423064868855e-07 0 4.960523064868854e-07 0.00021 4.960623064868854e-07 0 4.960623064868855e-07 0 4.960723064868855e-07 0.00021 4.960823064868854e-07 0 4.962296476462566e-07 0 4.962396476462565e-07 0.00021 4.962496476462565e-07 0 4.962496476462566e-07 0 4.962596476462566e-07 0.00021 4.962696476462565e-07 0 4.962696476462566e-07 0 4.962796476462566e-07 0.00021 4.962896476462565e-07 0 4.962944791652474e-07 0 4.963044791652474e-07 0.00021 4.963144791652474e-07 0 4.963207254229555e-07 0 4.963307254229555e-07 0.00021 4.963407254229555e-07 0 4.963481195405526e-07 0 4.963581195405525e-07 0.00021 4.963681195405525e-07 0 4.963831623870392e-07 0 4.963931623870392e-07 0.00021 4.964031623870392e-07 0 4.96444631131208e-07 0 4.964546311312079e-07 0.00021 4.964646311312079e-07 0 4.96464631131208e-07 0 4.96474631131208e-07 0.00021 4.964846311312079e-07 0 4.969995728009869e-07 0 4.970095728009868e-07 0.00021 4.970195728009868e-07 0 4.970267509130403e-07 0 4.970367509130403e-07 0.00021 4.970467509130402e-07 0 4.970467509130404e-07 0 4.970567509130403e-07 0.00021 4.970667509130403e-07 0 4.971808620526934e-07 0 4.971908620526934e-07 0.00021 4.972008620526933e-07 0 4.972202629897371e-07 0 4.972302629897371e-07 0.00021 4.972402629897371e-07 0 4.974583223536664e-07 0 4.974683223536664e-07 0.00021 4.974783223536664e-07 0 4.974923849047371e-07 0 4.97502384904737e-07 0.00021 4.97512384904737e-07 0 4.975250189919662e-07 0 4.975350189919662e-07 0.00021 4.975450189919661e-07 0 4.975450189919663e-07 0 4.975550189919662e-07 0.00021 4.975650189919662e-07 0 4.975650189919663e-07 0 4.975750189919662e-07 0.00021 4.975850189919662e-07 0 4.975907255893631e-07 0 4.976007255893631e-07 0.00021 4.97610725589363e-07 0 4.977504867646721e-07 0 4.977604867646721e-07 0.00021 4.97770486764672e-07 0 4.977788591660051e-07 0 4.977888591660051e-07 0.00021 4.97798859166005e-07 0 4.978692225539485e-07 0 4.978792225539485e-07 0.00021 4.978892225539484e-07 0 4.979892722728881e-07 0 4.97999272272888e-07 0.00021 4.98009272272888e-07 0 4.980153861418258e-07 0 4.980253861418257e-07 0.00021 4.980353861418257e-07 0 4.98202367106126e-07 0 4.982123671061259e-07 0.00021 4.982223671061259e-07 0 4.98233602149125e-07 0 4.98243602149125e-07 0.00021 4.982536021491249e-07 0 4.98253602149125e-07 0 4.98263602149125e-07 0.00021 4.982736021491249e-07 0 4.98273602149125e-07 0 4.98283602149125e-07 0.00021 4.98293602149125e-07 0 4.982936021491251e-07 0 4.98303602149125e-07 0.00021 4.98313602149125e-07 0 4.984320341266359e-07 0 4.984420341266358e-07 0.00021 4.984520341266358e-07 0 4.984520341266359e-07 0 4.984620341266359e-07 0.00021 4.984720341266358e-07 0 4.984720341266359e-07 0 4.984820341266359e-07 0.00021 4.984920341266359e-07 0 4.98492034126636e-07 0 4.985020341266359e-07 0.00021 4.985120341266359e-07 0 4.985370626097573e-07 0 4.985470626097572e-07 0.00021 4.985570626097572e-07 0 4.987052479277259e-07 0 4.987152479277259e-07 0.00021 4.987252479277258e-07 0 4.989931099695314e-07 0 4.990031099695313e-07 0.00021 4.990131099695313e-07 0 4.990145155896396e-07 0 4.990245155896395e-07 0.00021 4.990345155896395e-07 0 4.990371085618809e-07 0 4.990471085618809e-07 0.00021 4.990571085618809e-07 0 4.99057108561881e-07 0 4.990671085618809e-07 0.00021 4.990771085618809e-07 0 4.991018256067452e-07 0 4.991118256067452e-07 0.00021 4.991218256067451e-07 0 4.991218256067453e-07 0 4.991318256067452e-07 0.00021 4.991418256067452e-07 0 4.99293414885314e-07 0 4.99303414885314e-07 0.00021 4.99313414885314e-07 0 4.994833188538712e-07 0 4.994933188538712e-07 0.00021 4.995033188538712e-07 0 4.996169188137247e-07 0 4.996269188137246e-07 0.00021 4.996369188137246e-07 0 4.996369188137247e-07 0 4.996469188137246e-07 0.00021 4.996569188137246e-07 0 4.996569188137247e-07 0 4.996669188137247e-07 0.00021 4.996769188137246e-07 0 4.996769188137247e-07 0 4.996869188137247e-07 0.00021 4.996969188137246e-07 0 4.997149746317072e-07 0 4.997249746317071e-07 0.00021 4.997349746317071e-07 0 4.997379209674901e-07 0 4.997479209674901e-07 0.00021 4.9975792096749e-07 0 4.997877425057724e-07 0 4.997977425057724e-07 0.00021 4.998077425057724e-07 0 4.998077425057725e-07 0 4.998177425057724e-07 0.00021 4.998277425057724e-07 0 4.998415513277177e-07 0 4.998515513277177e-07 0.00021 4.998615513277176e-07 0 4.998615513277177e-07 0 4.998715513277177e-07 0.00021 4.998815513277176e-07 0 4.998815513277178e-07 0 4.998915513277177e-07 0.00021 4.999015513277177e-07 0 4.999015513277178e-07 0 4.999115513277177e-07 0.00021 4.999215513277177e-07 0 4.99936800016508e-07 0 4.999468000165079e-07 0.00021 4.999568000165079e-07 0 )
VIN2 2 0 pwl(0 0 1.331195099321976e-11 0 2.331195099321976e-11 0.00021 3.3311950993219757e-11 0 4.8269565900620835e-11 0 5.826956590062083e-11 0.00021 6.826956590062084e-11 0 6.826956590062082e-11 0 7.826956590062083e-11 0.00021 8.826956590062083e-11 0 8.826956590062082e-11 0 9.826956590062082e-11 0.00021 1.0826956590062083e-10 0 1.0826956590062083e-10 0 1.1826956590062083e-10 0.00021 1.2826956590062082e-10 0 1.2826956590062085e-10 0 1.3826956590062084e-10 0.00021 1.4826956590062083e-10 0 1.4826956590062086e-10 0 1.5826956590062085e-10 0.00021 1.6826956590062084e-10 0 1.7276934671411822e-10 0 1.827693467141182e-10 0.00021 1.927693467141182e-10 0 2.693448659967145e-10 0 2.7934486599671454e-10 0.00021 2.8934486599671455e-10 0 4.770392573261742e-10 0 4.870392573261742e-10 0.00021 4.970392573261741e-10 0 5.897167975968168e-10 0 5.997167975968168e-10 0.00021 6.097167975968167e-10 0 6.097167975968168e-10 0 6.197167975968168e-10 0.00021 6.297167975968168e-10 0 6.675584803831618e-10 0 6.775584803831618e-10 0.00021 6.875584803831617e-10 0 6.875584803831619e-10 0 6.975584803831618e-10 0.00021 7.075584803831618e-10 0 7.075584803831619e-10 0 7.175584803831619e-10 0.00021 7.275584803831618e-10 0 7.35815543810536e-10 0 7.45815543810536e-10 0.00021 7.55815543810536e-10 0 8.438124119044272e-10 0 8.538124119044272e-10 0.00021 8.638124119044271e-10 0 8.638124119044273e-10 0 8.738124119044272e-10 0.00021 8.838124119044272e-10 0 8.838124119044273e-10 0 8.938124119044273e-10 0.00021 9.038124119044272e-10 0 9.176412323026313e-10 0 9.276412323026313e-10 0.00021 9.376412323026313e-10 0 9.376412323026313e-10 0 9.476412323026313e-10 0.00021 9.576412323026313e-10 0 9.576412323026313e-10 0 9.676412323026312e-10 0.00021 9.776412323026312e-10 0 9.776412323026312e-10 0 9.876412323026312e-10 0.00021 9.976412323026311e-10 0 9.976412323026311e-10 0 1.007641232302631e-09 0.00021 1.017641232302631e-09 0 1.045004427011289e-09 0 1.055004427011289e-09 0.00021 1.065004427011289e-09 0 1.065004427011289e-09 0 1.075004427011289e-09 0.00021 1.0850044270112889e-09 0 1.0850044270112889e-09 0 1.0950044270112888e-09 0.00021 1.1050044270112888e-09 0 1.1380549367997392e-09 0 1.1480549367997392e-09 0.00021 1.1580549367997392e-09 0 1.1972051177182426e-09 0 1.2072051177182425e-09 0.00021 1.2172051177182425e-09 0 1.2172051177182425e-09 0 1.2272051177182425e-09 0.00021 1.2372051177182424e-09 0 1.2372051177182424e-09 0 1.2472051177182424e-09 0.00021 1.2572051177182424e-09 0 1.2574627630050266e-09 0 1.2674627630050266e-09 0.00021 1.2774627630050265e-09 0 1.2774627630050265e-09 0 1.2874627630050265e-09 0.00021 1.2974627630050265e-09 0 1.305223081758892e-09 0 1.315223081758892e-09 0.00021 1.325223081758892e-09 0 1.3411792718252852e-09 0 1.3511792718252852e-09 0.00021 1.3611792718252852e-09 0 1.3834251224732084e-09 0 1.3934251224732084e-09 0.00021 1.4034251224732084e-09 0 1.4838194989296562e-09 0 1.4938194989296562e-09 0.00021 1.5038194989296561e-09 0 1.5038194989296561e-09 0 1.513819498929656e-09 0.00021 1.523819498929656e-09 0 1.539344996316192e-09 0 1.549344996316192e-09 0.00021 1.559344996316192e-09 0 1.5778902830271376e-09 0 1.5878902830271375e-09 0.00021 1.5978902830271375e-09 0 1.6429662973698651e-09 0 1.652966297369865e-09 0.00021 1.662966297369865e-09 0 1.6635031650548779e-09 0 1.6735031650548778e-09 0.00021 1.6835031650548778e-09 0 1.6835031650548778e-09 0 1.6935031650548778e-09 0.00021 1.7035031650548777e-09 0 1.7075874615393622e-09 0 1.7175874615393621e-09 0.00021 1.7275874615393621e-09 0 1.7275874615393621e-09 0 1.737587461539362e-09 0.00021 1.747587461539362e-09 0 1.747587461539362e-09 0 1.757587461539362e-09 0.00021 1.767587461539362e-09 0 1.767587461539362e-09 0 1.777587461539362e-09 0.00021 1.787587461539362e-09 0 1.8023292175510689e-09 0 1.8123292175510689e-09 0.00021 1.8223292175510688e-09 0 1.8804745261537875e-09 0 1.8904745261537877e-09 0.00021 1.900474526153788e-09 0 1.9004745261537874e-09 0 1.9104745261537876e-09 0.00021 1.9204745261537878e-09 0 2.0078402436594464e-09 0 2.0178402436594466e-09 0.00021 2.0278402436594468e-09 0 2.0278402436594463e-09 0 2.0378402436594465e-09 0.00021 2.0478402436594467e-09 0 2.0478402436594463e-09 0 2.0578402436594464e-09 0.00021 2.0678402436594466e-09 0 2.067840243659446e-09 0 2.0778402436594464e-09 0.00021 2.0878402436594465e-09 0 2.087840243659446e-09 0 2.0978402436594463e-09 0.00021 2.1078402436594465e-09 0 2.107840243659446e-09 0 2.1178402436594462e-09 0.00021 2.1278402436594464e-09 0 2.127840243659446e-09 0 2.137840243659446e-09 0.00021 2.1478402436594463e-09 0 2.147840243659446e-09 0 2.157840243659446e-09 0.00021 2.1678402436594463e-09 0 2.180718569513961e-09 0 2.190718569513961e-09 0.00021 2.2007185695139614e-09 0 2.200718569513961e-09 0 2.210718569513961e-09 0.00021 2.2207185695139613e-09 0 2.220718569513961e-09 0 2.230718569513961e-09 0.00021 2.2407185695139612e-09 0 2.240718569513961e-09 0 2.250718569513961e-09 0.00021 2.260718569513961e-09 0 2.2607185695139607e-09 0 2.270718569513961e-09 0.00021 2.280718569513961e-09 0 2.2807185695139607e-09 0 2.290718569513961e-09 0.00021 2.300718569513961e-09 0 2.3007185695139606e-09 0 2.3107185695139608e-09 0.00021 2.320718569513961e-09 0 2.3207185695139605e-09 0 2.3307185695139607e-09 0.00021 2.340718569513961e-09 0 2.3407185695139605e-09 0 2.3507185695139606e-09 0.00021 2.360718569513961e-09 0 2.3607185695139604e-09 0 2.3707185695139606e-09 0.00021 2.3807185695139607e-09 0 2.3807185695139603e-09 0 2.3907185695139605e-09 0.00021 2.4007185695139607e-09 0 2.455651986623512e-09 0 2.465651986623512e-09 0.00021 2.4756519866235122e-09 0 2.485300331071302e-09 0 2.495300331071302e-09 0.00021 2.5053003310713023e-09 0 2.612072708885831e-09 0 2.6220727088858312e-09 0.00021 2.6320727088858314e-09 0 2.632072708885831e-09 0 2.642072708885831e-09 0.00021 2.6520727088858313e-09 0 2.6735382498221555e-09 0 2.6835382498221556e-09 0.00021 2.693538249822156e-09 0 2.742755077058333e-09 0 2.752755077058333e-09 0.00021 2.7627550770583332e-09 0 2.771760507216521e-09 0 2.7817605072165212e-09 0.00021 2.7917605072165214e-09 0 2.7972712990313188e-09 0 2.807271299031319e-09 0.00021 2.817271299031319e-09 0 2.8178674960706646e-09 0 2.8278674960706647e-09 0.00021 2.837867496070665e-09 0 2.8378674960706645e-09 0 2.8478674960706647e-09 0.00021 2.857867496070665e-09 0 2.973019311386042e-09 0 2.9830193113860424e-09 0.00021 2.9930193113860425e-09 0 3.0302874337447656e-09 0 3.0402874337447657e-09 0.00021 3.050287433744766e-09 0 3.0502874337447655e-09 0 3.0602874337447657e-09 0.00021 3.070287433744766e-09 0 3.1083547891192466e-09 0 3.1183547891192468e-09 0.00021 3.128354789119247e-09 0 3.1431517183768773e-09 0 3.1531517183768775e-09 0.00021 3.1631517183768777e-09 0 3.1631517183768772e-09 0 3.1731517183768774e-09 0.00021 3.1831517183768776e-09 0 3.1905473675127307e-09 0 3.200547367512731e-09 0.00021 3.210547367512731e-09 0 3.2390161607712447e-09 0 3.249016160771245e-09 0.00021 3.259016160771245e-09 0 3.2590161607712446e-09 0 3.269016160771245e-09 0.00021 3.279016160771245e-09 0 3.2790161607712446e-09 0 3.2890161607712447e-09 0.00021 3.299016160771245e-09 0 3.3504820898548387e-09 0 3.360482089854839e-09 0.00021 3.370482089854839e-09 0 3.4220461165482405e-09 0 3.4320461165482407e-09 0.00021 3.442046116548241e-09 0 3.552487261244137e-09 0 3.562487261244137e-09 0.00021 3.5724872612441373e-09 0 3.572487261244137e-09 0 3.582487261244137e-09 0.00021 3.592487261244137e-09 0 3.653143037017146e-09 0 3.6631430370171463e-09 0.00021 3.6731430370171465e-09 0 3.743804416031541e-09 0 3.753804416031541e-09 0.00021 3.763804416031541e-09 0 3.853018038269692e-09 0 3.863018038269692e-09 0.00021 3.8730180382696915e-09 0 3.928056394567699e-09 0 3.938056394567699e-09 0.00021 3.948056394567699e-09 0 3.9480563945676996e-09 0 3.958056394567699e-09 0.00021 3.968056394567699e-09 0 4.0202131984972485e-09 0 4.030213198497248e-09 0.00021 4.040213198497248e-09 0 4.040213198497249e-09 0 4.0502131984972486e-09 0.00021 4.060213198497248e-09 0 4.060213198497249e-09 0 4.070213198497249e-09 0.00021 4.080213198497249e-09 0 4.1080972023117984e-09 0 4.118097202311798e-09 0.00021 4.128097202311798e-09 0 4.136839989645803e-09 0 4.146839989645802e-09 0.00021 4.156839989645802e-09 0 4.166478988190352e-09 0 4.176478988190352e-09 0.00021 4.186478988190351e-09 0 4.186478988190352e-09 0 4.196478988190352e-09 0.00021 4.206478988190352e-09 0 4.2064789881903526e-09 0 4.216478988190352e-09 0.00021 4.226478988190352e-09 0 4.323839991497819e-09 0 4.333839991497819e-09 0.00021 4.3438399914978185e-09 0 4.343839991497819e-09 0 4.353839991497819e-09 0.00021 4.363839991497819e-09 0 4.380145855836978e-09 0 4.390145855836978e-09 0.00021 4.4001458558369775e-09 0 4.400145855836978e-09 0 4.410145855836978e-09 0.00021 4.420145855836978e-09 0 4.439312219377339e-09 0 4.449312219377339e-09 0.00021 4.4593122193773385e-09 0 4.460352098860648e-09 0 4.4703520988606474e-09 0.00021 4.480352098860647e-09 0 4.4964079446641295e-09 0 4.506407944664129e-09 0.00021 4.516407944664129e-09 0 4.51640794466413e-09 0 4.52640794466413e-09 0.00021 4.536407944664129e-09 0 4.53640794466413e-09 0 4.54640794466413e-09 0.00021 4.55640794466413e-09 0 4.5564079446641306e-09 0 4.56640794466413e-09 0.00021 4.57640794466413e-09 0 4.576407944664131e-09 0 4.586407944664131e-09 0.00021 4.5964079446641304e-09 0 4.596407944664131e-09 0 4.606407944664131e-09 0.00021 4.616407944664131e-09 0 4.616407944664132e-09 0 4.626407944664131e-09 0.00021 4.636407944664131e-09 0 4.636407944664132e-09 0 4.646407944664132e-09 0.00021 4.6564079446641315e-09 0 4.656407944664132e-09 0 4.666407944664132e-09 0.00021 4.676407944664132e-09 0 4.676407944664133e-09 0 4.686407944664132e-09 0.00021 4.696407944664132e-09 0 4.696407944664133e-09 0 4.706407944664133e-09 0.00021 4.7164079446641325e-09 0 4.737733566289378e-09 0 4.7477335662893775e-09 0.00021 4.757733566289377e-09 0 4.791769953509603e-09 0 4.8017699535096025e-09 0.00021 4.811769953509602e-09 0 4.818736073857632e-09 0 4.828736073857632e-09 0.00021 4.8387360738576315e-09 0 4.889385975301591e-09 0 4.899385975301591e-09 0.00021 4.9093859753015906e-09 0 4.909385975301591e-09 0 4.919385975301591e-09 0.00021 4.929385975301591e-09 0 4.929385975301592e-09 0 4.9393859753015915e-09 0.00021 4.949385975301591e-09 0 4.949385975301592e-09 0 4.959385975301592e-09 0.00021 4.969385975301592e-09 0 5.027772057675265e-09 0 5.0377720576752645e-09 0.00021 5.047772057675264e-09 0 5.047772057675265e-09 0 5.057772057675265e-09 0.00021 5.0677720576752646e-09 0 5.104603788754145e-09 0 5.114603788754145e-09 0.00021 5.124603788754144e-09 0 5.142902339959918e-09 0 5.152902339959918e-09 0.00021 5.1629023399599174e-09 0 5.162902339959918e-09 0 5.172902339959918e-09 0.00021 5.182902339959918e-09 0 5.182902339959919e-09 0 5.192902339959918e-09 0.00021 5.202902339959918e-09 0 5.202902339959919e-09 0 5.212902339959919e-09 0.00021 5.2229023399599185e-09 0 5.222902339959919e-09 0 5.232902339959919e-09 0.00021 5.242902339959919e-09 0 5.24290233995992e-09 0 5.252902339959919e-09 0.00021 5.262902339959919e-09 0 5.2946800431613895e-09 0 5.304680043161389e-09 0.00021 5.314680043161389e-09 0 5.31468004316139e-09 0 5.32468004316139e-09 0.00021 5.334680043161389e-09 0 5.371513698561191e-09 0 5.381513698561191e-09 0.00021 5.3915136985611905e-09 0 5.403404695021882e-09 0 5.413404695021882e-09 0.00021 5.4234046950218814e-09 0 5.479298301431133e-09 0 5.489298301431133e-09 0.00021 5.4992983014311326e-09 0 5.499298301431133e-09 0 5.509298301431133e-09 0.00021 5.519298301431133e-09 0 5.528033747037853e-09 0 5.538033747037853e-09 0.00021 5.5480337470378524e-09 0 5.548033747037853e-09 0 5.558033747037853e-09 0.00021 5.568033747037853e-09 0 5.568033747037854e-09 0 5.578033747037853e-09 0.00021 5.588033747037853e-09 0 5.644562541900624e-09 0 5.654562541900624e-09 0.00021 5.664562541900624e-09 0 5.679035293938804e-09 0 5.689035293938804e-09 0.00021 5.699035293938803e-09 0 5.802825241047729e-09 0 5.812825241047729e-09 0.00021 5.822825241047729e-09 0 5.8228252410477294e-09 0 5.832825241047729e-09 0.00021 5.842825241047729e-09 0 5.947404961726856e-09 0 5.957404961726856e-09 0.00021 5.967404961726856e-09 0 5.967404961726857e-09 0 5.977404961726856e-09 0.00021 5.987404961726856e-09 0 6.029767461377614e-09 0 6.039767461377614e-09 0.00021 6.049767461377614e-09 0 6.054013164144637e-09 0 6.064013164144637e-09 0.00021 6.074013164144637e-09 0 6.0813843656567465e-09 0 6.091384365656746e-09 0.00021 6.101384365656746e-09 0 6.1050968056524495e-09 0 6.115096805652449e-09 0.00021 6.125096805652449e-09 0 6.126917828580249e-09 0 6.136917828580249e-09 0.00021 6.146917828580249e-09 0 6.224179900063381e-09 0 6.234179900063381e-09 0.00021 6.244179900063381e-09 0 6.265353656704337e-09 0 6.275353656704337e-09 0.00021 6.285353656704337e-09 0 6.285353656704338e-09 0 6.2953536567043374e-09 0.00021 6.305353656704337e-09 0 6.305353656704338e-09 0 6.315353656704338e-09 0.00021 6.3253536567043375e-09 0 6.325353656704338e-09 0 6.335353656704338e-09 0.00021 6.345353656704338e-09 0 6.3839081574744925e-09 0 6.393908157474492e-09 0.00021 6.403908157474492e-09 0 6.47370360743595e-09 0 6.483703607435949e-09 0.00021 6.493703607435949e-09 0 6.497168001986666e-09 0 6.507168001986666e-09 0.00021 6.517168001986666e-09 0 6.530137174434616e-09 0 6.540137174434616e-09 0.00021 6.550137174434616e-09 0 6.5971639842014116e-09 0 6.607163984201411e-09 0.00021 6.617163984201411e-09 0 6.657672960825695e-09 0 6.6676729608256945e-09 0.00021 6.677672960825694e-09 0 6.688542044499582e-09 0 6.698542044499582e-09 0.00021 6.708542044499582e-09 0 6.708542044499583e-09 0 6.718542044499582e-09 0.00021 6.728542044499582e-09 0 6.728542044499583e-09 0 6.738542044499583e-09 0.00021 6.7485420444995825e-09 0 6.809513727721244e-09 0 6.819513727721244e-09 0.00021 6.829513727721244e-09 0 6.866872992454656e-09 0 6.8768729924546555e-09 0.00021 6.886872992454655e-09 0 6.886872992454656e-09 0 6.896872992454656e-09 0.00021 6.906872992454656e-09 0 6.9068729924546564e-09 0 6.916872992454656e-09 0.00021 6.926872992454656e-09 0 7.03252077751472e-09 0 7.04252077751472e-09 0.00021 7.0525207775147194e-09 0 7.05252077751472e-09 0 7.06252077751472e-09 0.00021 7.07252077751472e-09 0 7.095046060571727e-09 0 7.105046060571727e-09 0.00021 7.1150460605717265e-09 0 7.118050989906636e-09 0 7.128050989906635e-09 0.00021 7.138050989906635e-09 0 7.138658778277175e-09 0 7.148658778277175e-09 0.00021 7.158658778277174e-09 0 7.158658778277175e-09 0 7.168658778277175e-09 0.00021 7.178658778277175e-09 0 7.1786587782771756e-09 0 7.188658778277175e-09 0.00021 7.198658778277175e-09 0 7.255702186384635e-09 0 7.265702186384635e-09 0.00021 7.275702186384635e-09 0 7.294171333561896e-09 0 7.304171333561896e-09 0.00021 7.314171333561896e-09 0 7.3141713335618965e-09 0 7.324171333561896e-09 0.00021 7.334171333561896e-09 0 7.334171333561897e-09 0 7.344171333561897e-09 0.00021 7.354171333561896e-09 0 7.3742974166876005e-09 0 7.3842974166876e-09 0.00021 7.3942974166876e-09 0 7.405125053941346e-09 0 7.415125053941346e-09 0.00021 7.425125053941346e-09 0 7.448123832431032e-09 0 7.458123832431031e-09 0.00021 7.468123832431031e-09 0 7.472717533552743e-09 0 7.482717533552743e-09 0.00021 7.492717533552742e-09 0 7.516059572263865e-09 0 7.526059572263865e-09 0.00021 7.536059572263864e-09 0 7.536059572263864e-09 0 7.546059572263864e-09 0.00021 7.556059572263864e-09 0 7.556059572263864e-09 0 7.566059572263864e-09 0.00021 7.576059572263863e-09 0 7.5960700636428e-09 0 7.6060700636428e-09 0.00021 7.6160700636428e-09 0 7.654132254633798e-09 0 7.664132254633798e-09 0.00021 7.674132254633798e-09 0 7.674132254633798e-09 0 7.684132254633797e-09 0.00021 7.694132254633797e-09 0 7.700514803011523e-09 0 7.710514803011523e-09 0.00021 7.720514803011522e-09 0 7.733002547242898e-09 0 7.743002547242898e-09 0.00021 7.753002547242898e-09 0 7.757153626484066e-09 0 7.767153626484065e-09 0.00021 7.777153626484065e-09 0 7.798111921889453e-09 0 7.808111921889453e-09 0.00021 7.818111921889452e-09 0 7.818111921889452e-09 0 7.828111921889452e-09 0.00021 7.838111921889452e-09 0 7.844601319961437e-09 0 7.854601319961437e-09 0.00021 7.864601319961436e-09 0 7.864601319961436e-09 0 7.874601319961436e-09 0.00021 7.884601319961436e-09 0 7.884601319961436e-09 0 7.894601319961436e-09 0.00021 7.904601319961435e-09 0 7.904601319961435e-09 0 7.914601319961435e-09 0.00021 7.924601319961435e-09 0 7.924601319961435e-09 0 7.934601319961435e-09 0.00021 7.944601319961434e-09 0 7.944601319961434e-09 0 7.954601319961434e-09 0.00021 7.964601319961434e-09 0 8.059409913306388e-09 0 8.069409913306387e-09 0.00021 8.079409913306387e-09 0 8.11970344385573e-09 0 8.12970344385573e-09 0.00021 8.13970344385573e-09 0 8.13970344385573e-09 0 8.14970344385573e-09 0.00021 8.15970344385573e-09 0 8.15970344385573e-09 0 8.16970344385573e-09 0.00021 8.179703443855729e-09 0 8.179703443855729e-09 0 8.189703443855729e-09 0.00021 8.199703443855728e-09 0 8.199703443855728e-09 0 8.209703443855728e-09 0.00021 8.219703443855728e-09 0 8.245277358932684e-09 0 8.255277358932684e-09 0.00021 8.265277358932684e-09 0 8.27204301428716e-09 0 8.28204301428716e-09 0.00021 8.292043014287159e-09 0 8.292043014287159e-09 0 8.302043014287159e-09 0.00021 8.312043014287159e-09 0 8.312043014287159e-09 0 8.322043014287158e-09 0.00021 8.332043014287158e-09 0 8.332043014287158e-09 0 8.342043014287158e-09 0.00021 8.352043014287158e-09 0 8.352043014287158e-09 0 8.362043014287157e-09 0.00021 8.372043014287157e-09 0 8.372043014287157e-09 0 8.382043014287157e-09 0.00021 8.392043014287157e-09 0 8.392043014287157e-09 0 8.402043014287156e-09 0.00021 8.412043014287156e-09 0 8.412043014287156e-09 0 8.422043014287156e-09 0.00021 8.432043014287156e-09 0 8.432043014287156e-09 0 8.442043014287155e-09 0.00021 8.452043014287155e-09 0 8.452043014287155e-09 0 8.462043014287155e-09 0.00021 8.472043014287155e-09 0 8.472043014287155e-09 0 8.482043014287154e-09 0.00021 8.492043014287154e-09 0 8.492043014287154e-09 0 8.502043014287154e-09 0.00021 8.512043014287154e-09 0 8.512043014287154e-09 0 8.522043014287153e-09 0.00021 8.532043014287153e-09 0 8.563983592198002e-09 0 8.573983592198002e-09 0.00021 8.583983592198002e-09 0 8.583983592198002e-09 0 8.593983592198001e-09 0.00021 8.603983592198001e-09 0 8.62325458638725e-09 0 8.63325458638725e-09 0.00021 8.64325458638725e-09 0 8.784778343906485e-09 0 8.794778343906485e-09 0.00021 8.804778343906484e-09 0 8.812133677609921e-09 0 8.82213367760992e-09 0.00021 8.83213367760992e-09 0 8.883669934911665e-09 0 8.893669934911665e-09 0.00021 8.903669934911664e-09 0 8.947297299803614e-09 0 8.957297299803613e-09 0.00021 8.967297299803613e-09 0 9.044654511997676e-09 0 9.054654511997675e-09 0.00021 9.064654511997675e-09 0 9.109853684834664e-09 0 9.119853684834664e-09 0.00021 9.129853684834664e-09 0 9.129853684834664e-09 0 9.139853684834663e-09 0.00021 9.149853684834663e-09 0 9.170467767170875e-09 0 9.180467767170874e-09 0.00021 9.190467767170874e-09 0 9.197912485419576e-09 0 9.207912485419576e-09 0.00021 9.217912485419576e-09 0 9.22183033819065e-09 0 9.23183033819065e-09 0.00021 9.241830338190649e-09 0 9.292247677004395e-09 0 9.302247677004395e-09 0.00021 9.312247677004394e-09 0 9.363284117114142e-09 0 9.373284117114142e-09 0.00021 9.383284117114142e-09 0 9.383284117114142e-09 0 9.393284117114142e-09 0.00021 9.403284117114141e-09 0 9.403284117114141e-09 0 9.413284117114141e-09 0.00021 9.423284117114141e-09 0 9.485024203852959e-09 0 9.495024203852959e-09 0.00021 9.505024203852959e-09 0 9.518414350720355e-09 0 9.528414350720355e-09 0.00021 9.538414350720355e-09 0 9.538414350720355e-09 0 9.548414350720355e-09 0.00021 9.558414350720354e-09 0 9.76368954376352e-09 0 9.77368954376352e-09 0.00021 9.78368954376352e-09 0 9.78368954376352e-09 0 9.793689543763519e-09 0.00021 9.803689543763519e-09 0 9.803689543763519e-09 0 9.813689543763519e-09 0.00021 9.823689543763518e-09 0 9.823689543763518e-09 0 9.833689543763518e-09 0.00021 9.843689543763518e-09 0 9.843689543763518e-09 0 9.853689543763518e-09 0.00021 9.863689543763517e-09 0 9.863689543763517e-09 0 9.873689543763517e-09 0.00021 9.883689543763517e-09 0 9.883689543763517e-09 0 9.893689543763517e-09 0.00021 9.903689543763516e-09 0 9.903689543763516e-09 0 9.913689543763516e-09 0.00021 9.923689543763516e-09 0 9.923689543763516e-09 0 9.933689543763516e-09 0.00021 9.943689543763515e-09 0 9.971642992324861e-09 0 9.98164299232486e-09 0.00021 9.99164299232486e-09 0 9.99164299232486e-09 0 1.000164299232486e-08 0.00021 1.001164299232486e-08 0 1.0040677139197535e-08 0 1.0050677139197535e-08 0.00021 1.0060677139197534e-08 0 1.0162700856650603e-08 0 1.0172700856650603e-08 0.00021 1.0182700856650602e-08 0 1.020593996973417e-08 0 1.021593996973417e-08 0.00021 1.022593996973417e-08 0 1.0292654144977827e-08 0 1.0302654144977827e-08 0.00021 1.0312654144977827e-08 0 1.03290926582698e-08 0 1.0339092658269799e-08 0.00021 1.0349092658269799e-08 0 1.0379105749110213e-08 0 1.0389105749110213e-08 0.00021 1.0399105749110213e-08 0 1.0454995012717014e-08 0 1.0464995012717013e-08 0.00021 1.0474995012717013e-08 0 1.0519486312102863e-08 0 1.0529486312102862e-08 0.00021 1.0539486312102862e-08 0 1.0565956744579565e-08 0 1.0575956744579565e-08 0.00021 1.0585956744579565e-08 0 1.0616737915537407e-08 0 1.0626737915537407e-08 0.00021 1.0636737915537407e-08 0 1.0655824786773097e-08 0 1.0665824786773097e-08 0.00021 1.0675824786773097e-08 0 1.0746992643052022e-08 0 1.0756992643052022e-08 0.00021 1.0766992643052022e-08 0 1.0770612661932693e-08 0 1.0780612661932693e-08 0.00021 1.0790612661932693e-08 0 1.0790612661932693e-08 0 1.0800612661932692e-08 0.00021 1.0810612661932692e-08 0 1.0816313058522192e-08 0 1.0826313058522192e-08 0.00021 1.0836313058522192e-08 0 1.0891164650648202e-08 0 1.0901164650648202e-08 0.00021 1.0911164650648201e-08 0 1.0911164650648201e-08 0 1.0921164650648201e-08 0.00021 1.0931164650648201e-08 0 1.0931164650648201e-08 0 1.09411646506482e-08 0.00021 1.09511646506482e-08 0 1.09511646506482e-08 0 1.09611646506482e-08 0.00021 1.09711646506482e-08 0 1.09711646506482e-08 0 1.09811646506482e-08 0.00021 1.09911646506482e-08 0 1.09911646506482e-08 0 1.10011646506482e-08 0.00021 1.1011164650648199e-08 0 1.1011729098219192e-08 0 1.1021729098219192e-08 0.00021 1.1031729098219191e-08 0 1.1060222438937389e-08 0 1.1070222438937389e-08 0.00021 1.1080222438937389e-08 0 1.1080222438937389e-08 0 1.1090222438937388e-08 0.00021 1.1100222438937388e-08 0 1.1124782517840925e-08 0 1.1134782517840925e-08 0.00021 1.1144782517840924e-08 0 1.1169189950765272e-08 0 1.1179189950765272e-08 0.00021 1.1189189950765271e-08 0 1.1236814089980757e-08 0 1.1246814089980757e-08 0.00021 1.1256814089980756e-08 0 1.1346546440699642e-08 0 1.1356546440699642e-08 0.00021 1.1366546440699641e-08 0 1.1366546440699641e-08 0 1.1376546440699641e-08 0.00021 1.1386546440699641e-08 0 1.1386546440699641e-08 0 1.139654644069964e-08 0.00021 1.140654644069964e-08 0 1.140654644069964e-08 0 1.141654644069964e-08 0.00021 1.142654644069964e-08 0 1.1440651781249999e-08 0 1.1450651781249999e-08 0.00021 1.1460651781249998e-08 0 1.1474543043600988e-08 0 1.1484543043600988e-08 0.00021 1.1494543043600987e-08 0 1.1537605570820837e-08 0 1.1547605570820837e-08 0.00021 1.1557605570820837e-08 0 1.1557605570820837e-08 0 1.1567605570820836e-08 0.00021 1.1577605570820836e-08 0 1.1823378387035366e-08 0 1.1833378387035366e-08 0.00021 1.1843378387035365e-08 0 1.1843378387035365e-08 0 1.1853378387035365e-08 0.00021 1.1863378387035365e-08 0 1.1863378387035365e-08 0 1.1873378387035365e-08 0.00021 1.1883378387035364e-08 0 1.1887117124520272e-08 0 1.1897117124520272e-08 0.00021 1.1907117124520272e-08 0 1.1907117124520272e-08 0 1.1917117124520271e-08 0.00021 1.1927117124520271e-08 0 1.195049250925836e-08 0 1.196049250925836e-08 0.00021 1.197049250925836e-08 0 1.197049250925836e-08 0 1.198049250925836e-08 0.00021 1.199049250925836e-08 0 1.199049250925836e-08 0 1.200049250925836e-08 0.00021 1.2010492509258359e-08 0 1.2034130121413966e-08 0 1.2044130121413966e-08 0.00021 1.2054130121413966e-08 0 1.208337697766449e-08 0 1.209337697766449e-08 0.00021 1.210337697766449e-08 0 1.210337697766449e-08 0 1.2113376977664489e-08 0.00021 1.2123376977664489e-08 0 1.2123376977664489e-08 0 1.2133376977664489e-08 0.00021 1.2143376977664488e-08 0 1.2143376977664488e-08 0 1.2153376977664488e-08 0.00021 1.2163376977664488e-08 0 1.216412073005588e-08 0 1.217412073005588e-08 0.00021 1.218412073005588e-08 0 1.218412073005588e-08 0 1.2194120730055879e-08 0.00021 1.2204120730055879e-08 0 1.220594022590661e-08 0 1.221594022590661e-08 0.00021 1.2225940225906609e-08 0 1.2225940225906609e-08 0 1.2235940225906609e-08 0.00021 1.2245940225906609e-08 0 1.2245940225906609e-08 0 1.2255940225906608e-08 0.00021 1.2265940225906608e-08 0 1.23013364681668e-08 0 1.23113364681668e-08 0.00021 1.23213364681668e-08 0 1.23213364681668e-08 0 1.2331336468166799e-08 0.00021 1.2341336468166799e-08 0 1.2341336468166799e-08 0 1.2351336468166798e-08 0.00021 1.2361336468166798e-08 0 1.2361336468166798e-08 0 1.2371336468166798e-08 0.00021 1.2381336468166798e-08 0 1.2381336468166798e-08 0 1.2391336468166797e-08 0.00021 1.2401336468166797e-08 0 1.2401336468166797e-08 0 1.2411336468166797e-08 0.00021 1.2421336468166797e-08 0 1.2421336468166797e-08 0 1.2431336468166797e-08 0.00021 1.2441336468166796e-08 0 1.2441336468166796e-08 0 1.2451336468166796e-08 0.00021 1.2461336468166796e-08 0 1.2461336468166796e-08 0 1.2471336468166796e-08 0.00021 1.2481336468166795e-08 0 1.2481336468166795e-08 0 1.2491336468166795e-08 0.00021 1.2501336468166795e-08 0 1.2501336468166795e-08 0 1.2511336468166795e-08 0.00021 1.2521336468166794e-08 0 1.2521336468166794e-08 0 1.2531336468166794e-08 0.00021 1.2541336468166794e-08 0 1.2590962446026301e-08 0 1.26009624460263e-08 0.00021 1.26109624460263e-08 0 1.26109624460263e-08 0 1.26209624460263e-08 0.00021 1.26309624460263e-08 0 1.26309624460263e-08 0 1.26409624460263e-08 0.00021 1.26509624460263e-08 0 1.2698212843779577e-08 0 1.2708212843779577e-08 0.00021 1.2718212843779576e-08 0 1.2718212843779576e-08 0 1.2728212843779576e-08 0.00021 1.2738212843779576e-08 0 1.2767370476249251e-08 0 1.277737047624925e-08 0.00021 1.278737047624925e-08 0 1.2853915787204323e-08 0 1.2863915787204323e-08 0.00021 1.2873915787204323e-08 0 1.2873915787204323e-08 0 1.2883915787204323e-08 0.00021 1.2893915787204322e-08 0 1.2965942423433891e-08 0 1.297594242343389e-08 0.00021 1.298594242343389e-08 0 1.298594242343389e-08 0 1.299594242343389e-08 0.00021 1.300594242343389e-08 0 1.300594242343389e-08 0 1.301594242343389e-08 0.00021 1.302594242343389e-08 0 1.302594242343389e-08 0 1.303594242343389e-08 0.00021 1.3045942423433889e-08 0 1.3045942423433889e-08 0 1.3055942423433889e-08 0.00021 1.3065942423433889e-08 0 1.3065942423433889e-08 0 1.3075942423433888e-08 0.00021 1.3085942423433888e-08 0 1.3124012161166197e-08 0 1.3134012161166197e-08 0.00021 1.3144012161166197e-08 0 1.3151751768361843e-08 0 1.3161751768361843e-08 0.00021 1.3171751768361843e-08 0 1.3188881553200445e-08 0 1.3198881553200445e-08 0.00021 1.3208881553200445e-08 0 1.3234799856342555e-08 0 1.3244799856342555e-08 0.00021 1.3254799856342555e-08 0 1.3266422682016801e-08 0 1.32764226820168e-08 0.00021 1.32864226820168e-08 0 1.32864226820168e-08 0 1.32964226820168e-08 0.00021 1.33064226820168e-08 0 1.33064226820168e-08 0 1.33164226820168e-08 0.00021 1.33264226820168e-08 0 1.33264226820168e-08 0 1.33364226820168e-08 0.00021 1.3346422682016799e-08 0 1.3346422682016799e-08 0 1.3356422682016799e-08 0.00021 1.3366422682016798e-08 0 1.3366422682016798e-08 0 1.3376422682016798e-08 0.00021 1.3386422682016798e-08 0 1.3386700343847547e-08 0 1.3396700343847547e-08 0.00021 1.3406700343847547e-08 0 1.3406700343847547e-08 0 1.3416700343847546e-08 0.00021 1.3426700343847546e-08 0 1.3426700343847546e-08 0 1.3436700343847546e-08 0.00021 1.3446700343847546e-08 0 1.3446700343847546e-08 0 1.3456700343847545e-08 0.00021 1.3466700343847545e-08 0 1.3466700343847545e-08 0 1.3476700343847545e-08 0.00021 1.3486700343847545e-08 0 1.3486700343847545e-08 0 1.3496700343847544e-08 0.00021 1.3506700343847544e-08 0 1.3506700343847544e-08 0 1.3516700343847544e-08 0.00021 1.3526700343847544e-08 0 1.3596878809252095e-08 0 1.3606878809252095e-08 0.00021 1.3616878809252094e-08 0 1.3616878809252094e-08 0 1.3626878809252094e-08 0.00021 1.3636878809252094e-08 0 1.3642465805406527e-08 0 1.3652465805406527e-08 0.00021 1.3662465805406527e-08 0 1.3662465805406527e-08 0 1.3672465805406526e-08 0.00021 1.3682465805406526e-08 0 1.3682465805406526e-08 0 1.3692465805406526e-08 0.00021 1.3702465805406526e-08 0 1.3702465805406526e-08 0 1.3712465805406525e-08 0.00021 1.3722465805406525e-08 0 1.3722465805406525e-08 0 1.3732465805406525e-08 0.00021 1.3742465805406525e-08 0 1.3757321242730175e-08 0 1.3767321242730175e-08 0.00021 1.3777321242730175e-08 0 1.3777321242730175e-08 0 1.3787321242730175e-08 0.00021 1.3797321242730174e-08 0 1.3850610973996225e-08 0 1.3860610973996225e-08 0.00021 1.3870610973996225e-08 0 1.3901318047929697e-08 0 1.3911318047929697e-08 0.00021 1.3921318047929697e-08 0 1.3921318047929697e-08 0 1.3931318047929696e-08 0.00021 1.3941318047929696e-08 0 1.3941318047929696e-08 0 1.3951318047929696e-08 0.00021 1.3961318047929696e-08 0 1.3978133972645047e-08 0 1.3988133972645047e-08 0.00021 1.3998133972645047e-08 0 1.4000053371154665e-08 0 1.4010053371154665e-08 0.00021 1.4020053371154665e-08 0 1.4065264932573407e-08 0 1.4075264932573407e-08 0.00021 1.4085264932573407e-08 0 1.4150635907472308e-08 0 1.4160635907472308e-08 0.00021 1.4170635907472308e-08 0 1.4170635907472308e-08 0 1.4180635907472307e-08 0.00021 1.4190635907472307e-08 0 1.4193464595171251e-08 0 1.4203464595171251e-08 0.00021 1.4213464595171251e-08 0 1.4261519588497024e-08 0 1.4271519588497024e-08 0.00021 1.4281519588497024e-08 0 1.4288130004539586e-08 0 1.4298130004539586e-08 0.00021 1.4308130004539585e-08 0 1.4323086266292626e-08 0 1.4333086266292626e-08 0.00021 1.4343086266292626e-08 0 1.4343086266292626e-08 0 1.4353086266292626e-08 0.00021 1.4363086266292625e-08 0 1.4379130376960267e-08 0 1.4389130376960266e-08 0.00021 1.4399130376960266e-08 0 1.4473548714946008e-08 0 1.4483548714946008e-08 0.00021 1.4493548714946008e-08 0 1.4493548714946008e-08 0 1.4503548714946008e-08 0.00021 1.4513548714946007e-08 0 1.460720902572754e-08 0 1.461720902572754e-08 0.00021 1.462720902572754e-08 0 1.462720902572754e-08 0 1.463720902572754e-08 0.00021 1.464720902572754e-08 0 1.464720902572754e-08 0 1.465720902572754e-08 0.00021 1.466720902572754e-08 0 1.466720902572754e-08 0 1.4677209025727539e-08 0.00021 1.4687209025727539e-08 0 1.478685189407542e-08 0 1.4796851894075419e-08 0.00021 1.4806851894075419e-08 0 1.4814515045294675e-08 0 1.4824515045294675e-08 0.00021 1.4834515045294674e-08 0 1.4837220804534761e-08 0 1.4847220804534761e-08 0.00021 1.485722080453476e-08 0 1.485722080453476e-08 0 1.486722080453476e-08 0.00021 1.487722080453476e-08 0 1.487722080453476e-08 0 1.488722080453476e-08 0.00021 1.489722080453476e-08 0 1.495601509799912e-08 0 1.4966015097999123e-08 0.00021 1.4976015097999124e-08 0 1.498250985342327e-08 0 1.499250985342327e-08 0.00021 1.5002509853423273e-08 0 1.500250985342327e-08 0 1.501250985342327e-08 0.00021 1.5022509853423272e-08 0 1.512978213237637e-08 0 1.5139782132376372e-08 0.00021 1.5149782132376374e-08 0 1.5184519339673224e-08 0 1.5194519339673225e-08 0.00021 1.5204519339673227e-08 0 1.5249377168383672e-08 0 1.5259377168383674e-08 0.00021 1.5269377168383675e-08 0 1.534149267758707e-08 0 1.535149267758707e-08 0.00021 1.5361492677587072e-08 0 1.5402629543035327e-08 0 1.541262954303533e-08 0.00021 1.542262954303533e-08 0 1.5438620909004185e-08 0 1.5448620909004187e-08 0.00021 1.5458620909004188e-08 0 1.546474756141355e-08 0 1.547474756141355e-08 0.00021 1.548474756141355e-08 0 1.5484747561413548e-08 0 1.549474756141355e-08 0.00021 1.550474756141355e-08 0 1.5677236110676334e-08 0 1.5687236110676335e-08 0.00021 1.5697236110676336e-08 0 1.5697236110676333e-08 0 1.5707236110676335e-08 0.00021 1.5717236110676336e-08 0 1.5725244399954332e-08 0 1.5735244399954333e-08 0.00021 1.5745244399954335e-08 0 1.574524439995433e-08 0 1.5755244399954333e-08 0.00021 1.5765244399954334e-08 0 1.576524439995433e-08 0 1.5775244399954332e-08 0.00021 1.5785244399954334e-08 0 1.580459717206036e-08 0 1.581459717206036e-08 0.00021 1.5824597172060362e-08 0 1.582459717206036e-08 0 1.583459717206036e-08 0.00021 1.584459717206036e-08 0 1.585395642372905e-08 0 1.586395642372905e-08 0.00021 1.5873956423729052e-08 0 1.5886691868396997e-08 0 1.5896691868396998e-08 0.00021 1.5906691868397e-08 0 1.5925987132610485e-08 0 1.5935987132610486e-08 0.00021 1.5945987132610487e-08 0 1.5954463198425982e-08 0 1.5964463198425983e-08 0.00021 1.5974463198425985e-08 0 1.599685512978695e-08 0 1.600685512978695e-08 0.00021 1.601685512978695e-08 0 1.6016855129786948e-08 0 1.602685512978695e-08 0.00021 1.603685512978695e-08 0 1.610835222001835e-08 0 1.6118352220018352e-08 0.00021 1.6128352220018353e-08 0 1.6131981613298082e-08 0 1.6141981613298084e-08 0.00021 1.6151981613298085e-08 0 1.6151981613298082e-08 0 1.6161981613298083e-08 0.00021 1.6171981613298085e-08 0 1.617198161329808e-08 0 1.6181981613298083e-08 0.00021 1.6191981613298084e-08 0 1.619198161329808e-08 0 1.6201981613298082e-08 0.00021 1.6211981613298084e-08 0 1.621198161329808e-08 0 1.6221981613298082e-08 0.00021 1.6231981613298083e-08 0 1.623198161329808e-08 0 1.624198161329808e-08 0.00021 1.6251981613298083e-08 0 1.626216548309e-08 0 1.6272165483090003e-08 0.00021 1.6282165483090004e-08 0 1.6331748037477336e-08 0 1.6341748037477337e-08 0.00021 1.635174803747734e-08 0 1.637049259209594e-08 0 1.6380492592095942e-08 0.00021 1.6390492592095943e-08 0 1.6402515650579926e-08 0 1.6412515650579928e-08 0.00021 1.642251565057993e-08 0 1.6427548247430174e-08 0 1.6437548247430175e-08 0.00021 1.6447548247430177e-08 0 1.6478704524033036e-08 0 1.6488704524033038e-08 0.00021 1.649870452403304e-08 0 1.6498704524033036e-08 0 1.6508704524033037e-08 0.00021 1.651870452403304e-08 0 1.6518704524033035e-08 0 1.6528704524033037e-08 0.00021 1.6538704524033038e-08 0 1.6538704524033035e-08 0 1.6548704524033036e-08 0.00021 1.6558704524033038e-08 0 1.6558704524033034e-08 0 1.6568704524033036e-08 0.00021 1.6578704524033037e-08 0 1.6578704524033034e-08 0 1.6588704524033035e-08 0.00021 1.6598704524033037e-08 0 1.6598704524033033e-08 0 1.6608704524033035e-08 0.00021 1.6618704524033036e-08 0 1.6618704524033033e-08 0 1.6628704524033034e-08 0.00021 1.6638704524033036e-08 0 1.6638704524033032e-08 0 1.6648704524033034e-08 0.00021 1.6658704524033035e-08 0 1.6658704524033032e-08 0 1.6668704524033033e-08 0.00021 1.6678704524033035e-08 0 1.667870452403303e-08 0 1.6688704524033033e-08 0.00021 1.6698704524033034e-08 0 1.669870452403303e-08 0 1.6708704524033032e-08 0.00021 1.6718704524033034e-08 0 1.671870452403303e-08 0 1.6728704524033032e-08 0.00021 1.6738704524033033e-08 0 1.6767103275139588e-08 0 1.677710327513959e-08 0.00021 1.678710327513959e-08 0 1.6787103275139588e-08 0 1.679710327513959e-08 0.00021 1.680710327513959e-08 0 1.6807103275139587e-08 0 1.681710327513959e-08 0.00021 1.682710327513959e-08 0 1.6827103275139587e-08 0 1.6837103275139588e-08 0.00021 1.684710327513959e-08 0 1.6868293343714816e-08 0 1.6878293343714818e-08 0.00021 1.688829334371482e-08 0 1.6948863862895655e-08 0 1.6958863862895657e-08 0.00021 1.6968863862895658e-08 0 1.6968863862895655e-08 0 1.6978863862895656e-08 0.00021 1.6988863862895658e-08 0 1.6988863862895654e-08 0 1.6998863862895656e-08 0.00021 1.7008863862895657e-08 0 1.7008863862895654e-08 0 1.7018863862895655e-08 0.00021 1.7028863862895657e-08 0 1.7060639741402e-08 0 1.7070639741402e-08 0.00021 1.7080639741402003e-08 0 1.7080639741402e-08 0 1.7090639741402e-08 0.00021 1.7100639741402002e-08 0 1.7100639741402e-08 0 1.7110639741402e-08 0.00021 1.7120639741402002e-08 0 1.7124009590032134e-08 0 1.7134009590032136e-08 0.00021 1.7144009590032137e-08 0 1.7144009590032134e-08 0 1.7154009590032135e-08 0.00021 1.7164009590032137e-08 0 1.7164009590032133e-08 0 1.7174009590032135e-08 0.00021 1.7184009590032136e-08 0 1.7187904091712754e-08 0 1.7197904091712756e-08 0.00021 1.7207904091712757e-08 0 1.7308054025177544e-08 0 1.7318054025177545e-08 0.00021 1.7328054025177547e-08 0 1.7358465566451627e-08 0 1.736846556645163e-08 0.00021 1.737846556645163e-08 0 1.7378465566451627e-08 0 1.738846556645163e-08 0.00021 1.739846556645163e-08 0 1.7398465566451626e-08 0 1.7408465566451628e-08 0.00021 1.741846556645163e-08 0 1.7458332763348527e-08 0 1.746833276334853e-08 0.00021 1.747833276334853e-08 0 1.7486864216073657e-08 0 1.749686421607366e-08 0.00021 1.750686421607366e-08 0 1.7526214542231724e-08 0 1.7536214542231726e-08 0.00021 1.7546214542231727e-08 0 1.7565125373858134e-08 0 1.7575125373858135e-08 0.00021 1.7585125373858137e-08 0 1.7606505698159867e-08 0 1.761650569815987e-08 0.00021 1.762650569815987e-08 0 1.7626505698159866e-08 0 1.7636505698159868e-08 0.00021 1.764650569815987e-08 0 1.7646505698159866e-08 0 1.7656505698159867e-08 0.00021 1.766650569815987e-08 0 1.7680537756776828e-08 0 1.769053775677683e-08 0.00021 1.770053775677683e-08 0 1.7700857347245853e-08 0 1.7710857347245855e-08 0.00021 1.7720857347245856e-08 0 1.774872303827672e-08 0 1.7758723038276722e-08 0.00021 1.7768723038276724e-08 0 1.780012502115836e-08 0 1.7810125021158362e-08 0.00021 1.7820125021158364e-08 0 1.782972465755383e-08 0 1.7839724657553832e-08 0.00021 1.7849724657553833e-08 0 1.7864640476941253e-08 0 1.7874640476941254e-08 0.00021 1.7884640476941256e-08 0 1.7884640476941252e-08 0 1.7894640476941254e-08 0.00021 1.7904640476941255e-08 0 1.7904640476941252e-08 0 1.7914640476941253e-08 0.00021 1.7924640476941255e-08 0 1.792464047694125e-08 0 1.7934640476941253e-08 0.00021 1.7944640476941254e-08 0 1.794464047694125e-08 0 1.7954640476941252e-08 0.00021 1.7964640476941254e-08 0 1.7999203914077418e-08 0 1.800920391407742e-08 0.00021 1.801920391407742e-08 0 1.8067362419407492e-08 0 1.8077362419407494e-08 0.00021 1.8087362419407495e-08 0 1.8128401305794548e-08 0 1.813840130579455e-08 0.00021 1.814840130579455e-08 0 1.8148401305794548e-08 0 1.815840130579455e-08 0.00021 1.816840130579455e-08 0 1.8219407224488798e-08 0 1.82294072244888e-08 0.00021 1.82394072244888e-08 0 1.8244144611163518e-08 0 1.825414461116352e-08 0.00021 1.826414461116352e-08 0 1.8264144611163517e-08 0 1.827414461116352e-08 0.00021 1.828414461116352e-08 0 1.8284144611163517e-08 0 1.829414461116352e-08 0.00021 1.830414461116352e-08 0 1.8324147859126476e-08 0 1.8334147859126478e-08 0.00021 1.834414785912648e-08 0 1.8344147859126476e-08 0 1.8354147859126477e-08 0.00021 1.836414785912648e-08 0 1.8364147859126475e-08 0 1.8374147859126477e-08 0.00021 1.8384147859126478e-08 0 1.8384147859126475e-08 0 1.8394147859126476e-08 0.00021 1.8404147859126478e-08 0 1.8476735897238743e-08 0 1.8486735897238744e-08 0.00021 1.8496735897238746e-08 0 1.850756343233844e-08 0 1.851756343233844e-08 0.00021 1.8527563432338443e-08 0 1.854459298662597e-08 0 1.855459298662597e-08 0.00021 1.8564592986625972e-08 0 1.856459298662597e-08 0 1.857459298662597e-08 0.00021 1.8584592986625972e-08 0 1.858459298662597e-08 0 1.859459298662597e-08 0.00021 1.860459298662597e-08 0 1.8609850230335487e-08 0 1.8619850230335488e-08 0.00021 1.862985023033549e-08 0 1.8657171081245456e-08 0 1.8667171081245457e-08 0.00021 1.867717108124546e-08 0 1.8677171081245455e-08 0 1.8687171081245457e-08 0.00021 1.8697171081245458e-08 0 1.8757515888621804e-08 0 1.8767515888621806e-08 0.00021 1.8777515888621807e-08 0 1.87818952150713e-08 0 1.87918952150713e-08 0.00021 1.8801895215071302e-08 0 1.88018952150713e-08 0 1.88118952150713e-08 0.00021 1.88218952150713e-08 0 1.8821895215071298e-08 0 1.88318952150713e-08 0.00021 1.88418952150713e-08 0 1.8841895215071298e-08 0 1.88518952150713e-08 0.00021 1.88618952150713e-08 0 1.8861895215071297e-08 0 1.88718952150713e-08 0.00021 1.88818952150713e-08 0 1.8881895215071297e-08 0 1.8891895215071298e-08 0.00021 1.89018952150713e-08 0 1.8901895215071296e-08 0 1.8911895215071297e-08 0.00021 1.89218952150713e-08 0 1.8921895215071296e-08 0 1.8931895215071297e-08 0.00021 1.89418952150713e-08 0 1.8941895215071295e-08 0 1.8951895215071297e-08 0.00021 1.8961895215071298e-08 0 1.8961895215071295e-08 0 1.8971895215071296e-08 0.00021 1.8981895215071297e-08 0 1.9026619796581468e-08 0 1.903661979658147e-08 0.00021 1.904661979658147e-08 0 1.9046862649489145e-08 0 1.9056862649489146e-08 0.00021 1.9066862649489148e-08 0 1.9073000917403566e-08 0 1.9083000917403567e-08 0.00021 1.909300091740357e-08 0 1.9093000917403565e-08 0 1.9103000917403567e-08 0.00021 1.9113000917403568e-08 0 1.9113000917403565e-08 0 1.9123000917403566e-08 0.00021 1.9133000917403568e-08 0 1.9133000917403564e-08 0 1.9143000917403566e-08 0.00021 1.9153000917403567e-08 0 1.9153000917403564e-08 0 1.9163000917403565e-08 0.00021 1.9173000917403567e-08 0 1.9179940994757787e-08 0 1.918994099475779e-08 0.00021 1.919994099475779e-08 0 1.9199940994757787e-08 0 1.9209940994757788e-08 0.00021 1.921994099475779e-08 0 1.925518761909716e-08 0 1.9265187619097163e-08 0.00021 1.9275187619097164e-08 0 1.927518761909716e-08 0 1.9285187619097162e-08 0.00021 1.9295187619097164e-08 0 1.929518761909716e-08 0 1.9305187619097162e-08 0.00021 1.9315187619097163e-08 0 1.931518761909716e-08 0 1.932518761909716e-08 0.00021 1.9335187619097163e-08 0 1.933518761909716e-08 0 1.934518761909716e-08 0.00021 1.9355187619097162e-08 0 1.935518761909716e-08 0 1.936518761909716e-08 0.00021 1.9375187619097162e-08 0 1.937518761909716e-08 0 1.938518761909716e-08 0.00021 1.939518761909716e-08 0 1.9395187619097158e-08 0 1.940518761909716e-08 0.00021 1.941518761909716e-08 0 1.9415187619097158e-08 0 1.942518761909716e-08 0.00021 1.943518761909716e-08 0 1.953308187567135e-08 0 1.954308187567135e-08 0.00021 1.9553081875671352e-08 0 1.955308187567135e-08 0 1.956308187567135e-08 0.00021 1.957308187567135e-08 0 1.9573081875671348e-08 0 1.958308187567135e-08 0.00021 1.959308187567135e-08 0 1.9593081875671348e-08 0 1.960308187567135e-08 0.00021 1.961308187567135e-08 0 1.9613081875671347e-08 0 1.962308187567135e-08 0.00021 1.963308187567135e-08 0 1.9662506662053177e-08 0 1.967250666205318e-08 0.00021 1.968250666205318e-08 0 1.9682506662053177e-08 0 1.969250666205318e-08 0.00021 1.970250666205318e-08 0 1.9702506662053176e-08 0 1.9712506662053178e-08 0.00021 1.972250666205318e-08 0 1.9722506662053176e-08 0 1.9732506662053177e-08 0.00021 1.974250666205318e-08 0 1.9786111247097757e-08 0 1.9796111247097758e-08 0.00021 1.980611124709776e-08 0 1.9817208654302827e-08 0 1.982720865430283e-08 0.00021 1.983720865430283e-08 0 1.986372026276164e-08 0 1.987372026276164e-08 0.00021 1.9883720262761642e-08 0 1.9893866654959928e-08 0 1.990386665495993e-08 0.00021 1.991386665495993e-08 0 1.9913866654959927e-08 0 1.992386665495993e-08 0.00021 1.993386665495993e-08 0 1.9933866654959927e-08 0 1.9943866654959928e-08 0.00021 1.995386665495993e-08 0 1.9953866654959926e-08 0 1.9963866654959928e-08 0.00021 1.997386665495993e-08 0 1.9973866654959926e-08 0 1.9983866654959927e-08 0.00021 1.999386665495993e-08 0 1.9993866654959925e-08 0 2.0003866654959927e-08 0.00021 2.0013866654959928e-08 0 2.0013866654959925e-08 0 2.0023866654959926e-08 0.00021 2.0033866654959928e-08 0 2.0033866654959924e-08 0 2.0043866654959926e-08 0.00021 2.0053866654959927e-08 0 2.0053866654959924e-08 0 2.0063866654959925e-08 0.00021 2.0073866654959927e-08 0 2.0073866654959923e-08 0 2.0083866654959925e-08 0.00021 2.0093866654959926e-08 0 2.0093866654959923e-08 0 2.0103866654959924e-08 0.00021 2.0113866654959926e-08 0 2.0113866654959923e-08 0 2.0123866654959924e-08 0.00021 2.0133866654959925e-08 0 2.0133866654959922e-08 0 2.0143866654959923e-08 0.00021 2.0153866654959925e-08 0 2.015386665495992e-08 0 2.0163866654959923e-08 0.00021 2.0173866654959924e-08 0 2.017386665495992e-08 0 2.0183866654959922e-08 0.00021 2.0193866654959924e-08 0 2.0268466437243337e-08 0 2.0278466437243338e-08 0.00021 2.028846643724334e-08 0 2.032531584553369e-08 0 2.033531584553369e-08 0.00021 2.034531584553369e-08 0 2.0350365564520223e-08 0 2.0360365564520224e-08 0.00021 2.0370365564520226e-08 0 2.0416056805891803e-08 0 2.0426056805891804e-08 0.00021 2.0436056805891806e-08 0 2.04991510968224e-08 0 2.05091510968224e-08 0.00021 2.0519151096822402e-08 0 2.057012000874613e-08 0 2.0580120008746133e-08 0.00021 2.0590120008746134e-08 0 2.059012000874613e-08 0 2.0600120008746132e-08 0.00021 2.0610120008746134e-08 0 2.062859236761612e-08 0 2.063859236761612e-08 0.00021 2.064859236761612e-08 0 2.0673649460808417e-08 0 2.068364946080842e-08 0.00021 2.069364946080842e-08 0 2.078663855867718e-08 0 2.079663855867718e-08 0.00021 2.0806638558677183e-08 0 2.080663855867718e-08 0 2.081663855867718e-08 0.00021 2.0826638558677182e-08 0 2.082663855867718e-08 0 2.083663855867718e-08 0.00021 2.0846638558677182e-08 0 2.084663855867718e-08 0 2.085663855867718e-08 0.00021 2.086663855867718e-08 0 2.0866638558677178e-08 0 2.087663855867718e-08 0.00021 2.088663855867718e-08 0 2.0901146423475105e-08 0 2.0911146423475106e-08 0.00021 2.0921146423475107e-08 0 2.093182797813179e-08 0 2.094182797813179e-08 0.00021 2.0951827978131792e-08 0 2.095329977882205e-08 0 2.0963299778822052e-08 0.00021 2.0973299778822054e-08 0 2.097329977882205e-08 0 2.0983299778822052e-08 0.00021 2.0993299778822053e-08 0 2.1013706978462147e-08 0 2.102370697846215e-08 0.00021 2.103370697846215e-08 0 2.107582314263004e-08 0 2.1085823142630042e-08 0.00021 2.1095823142630044e-08 0 2.1104903116297235e-08 0 2.1114903116297236e-08 0.00021 2.1124903116297238e-08 0 2.1168869777303038e-08 0 2.117886977730304e-08 0.00021 2.118886977730304e-08 0 2.1190891962205035e-08 0 2.1200891962205037e-08 0.00021 2.1210891962205038e-08 0 2.1210891962205035e-08 0 2.1220891962205036e-08 0.00021 2.1230891962205038e-08 0 2.1230891962205035e-08 0 2.1240891962205036e-08 0.00021 2.1250891962205037e-08 0 2.1250891962205034e-08 0 2.1260891962205035e-08 0.00021 2.1270891962205037e-08 0 2.1270891962205034e-08 0 2.1280891962205035e-08 0.00021 2.1290891962205036e-08 0 2.1290891962205033e-08 0 2.1300891962205034e-08 0.00021 2.1310891962205036e-08 0 2.1407502775580797e-08 0 2.14175027755808e-08 0.00021 2.14275027755808e-08 0 2.1427670107547134e-08 0 2.1437670107547135e-08 0.00021 2.1447670107547137e-08 0 2.1447670107547133e-08 0 2.1457670107547135e-08 0.00021 2.1467670107547136e-08 0 2.1471099556666373e-08 0 2.1481099556666374e-08 0.00021 2.1491099556666376e-08 0 2.1491099556666372e-08 0 2.1501099556666374e-08 0.00021 2.1511099556666375e-08 0 2.1511099556666372e-08 0 2.1521099556666373e-08 0.00021 2.1531099556666375e-08 0 2.153109955666637e-08 0 2.1541099556666373e-08 0.00021 2.1551099556666374e-08 0 2.155109955666637e-08 0 2.1561099556666372e-08 0.00021 2.1571099556666374e-08 0 2.157109955666637e-08 0 2.1581099556666372e-08 0.00021 2.1591099556666373e-08 0 2.159109955666637e-08 0 2.160109955666637e-08 0.00021 2.1611099556666373e-08 0 2.161109955666637e-08 0 2.162109955666637e-08 0.00021 2.1631099556666372e-08 0 2.163109955666637e-08 0 2.164109955666637e-08 0.00021 2.1651099556666372e-08 0 2.1696270805665682e-08 0 2.1706270805665684e-08 0.00021 2.1716270805665685e-08 0 2.1716270805665682e-08 0 2.1726270805665683e-08 0.00021 2.1736270805665685e-08 0 2.173627080566568e-08 0 2.1746270805665683e-08 0.00021 2.1756270805665684e-08 0 2.1779231592294204e-08 0 2.1789231592294206e-08 0.00021 2.1799231592294207e-08 0 2.1842395429576493e-08 0 2.1852395429576494e-08 0.00021 2.1862395429576496e-08 0 2.1888974347883598e-08 0 2.18989743478836e-08 0.00021 2.19089743478836e-08 0 2.1908974347883598e-08 0 2.19189743478836e-08 0.00021 2.19289743478836e-08 0 2.1928974347883597e-08 0 2.19389743478836e-08 0.00021 2.19489743478836e-08 0 2.1967715893483702e-08 0 2.1977715893483703e-08 0.00021 2.1987715893483705e-08 0 2.19877158934837e-08 0 2.1997715893483703e-08 0.00021 2.2007715893483704e-08 0 2.2037811328286827e-08 0 2.204781132828683e-08 0.00021 2.205781132828683e-08 0 2.2057811328286827e-08 0 2.2067811328286828e-08 0.00021 2.207781132828683e-08 0 2.2084553498636463e-08 0 2.2094553498636464e-08 0.00021 2.2104553498636466e-08 0 2.2104553498636462e-08 0 2.2114553498636464e-08 0.00021 2.2124553498636465e-08 0 2.2124553498636462e-08 0 2.2134553498636463e-08 0.00021 2.2144553498636465e-08 0 2.214455349863646e-08 0 2.2154553498636463e-08 0.00021 2.2164553498636464e-08 0 2.216455349863646e-08 0 2.2174553498636462e-08 0.00021 2.2184553498636464e-08 0 2.218455349863646e-08 0 2.2194553498636462e-08 0.00021 2.2204553498636463e-08 0 2.220455349863646e-08 0 2.221455349863646e-08 0.00021 2.2224553498636463e-08 0 2.2303243384396332e-08 0 2.2313243384396334e-08 0.00021 2.2323243384396335e-08 0 2.236432762210952e-08 0 2.2374327622109523e-08 0.00021 2.2384327622109524e-08 0 2.2396281030021817e-08 0 2.2406281030021818e-08 0.00021 2.241628103002182e-08 0 2.2416281030021816e-08 0 2.2426281030021818e-08 0.00021 2.243628103002182e-08 0 2.2450918484811272e-08 0 2.2460918484811274e-08 0.00021 2.2470918484811275e-08 0 2.2470918484811272e-08 0 2.2480918484811273e-08 0.00021 2.2490918484811275e-08 0 2.249091848481127e-08 0 2.2500918484811273e-08 0.00021 2.2510918484811274e-08 0 2.2513423905187943e-08 0 2.2523423905187945e-08 0.00021 2.2533423905187946e-08 0 2.2554350198902183e-08 0 2.2564350198902184e-08 0.00021 2.2574350198902186e-08 0 2.259098333907156e-08 0 2.260098333907156e-08 0.00021 2.261098333907156e-08 0 2.270408705831775e-08 0 2.271408705831775e-08 0.00021 2.2724087058317752e-08 0 2.280894087044682e-08 0 2.2818940870446822e-08 0.00021 2.2828940870446823e-08 0 2.282894087044682e-08 0 2.283894087044682e-08 0.00021 2.2848940870446823e-08 0 2.2890737253441547e-08 0 2.290073725344155e-08 0.00021 2.291073725344155e-08 0 2.29170378549847e-08 0 2.29270378549847e-08 0.00021 2.29370378549847e-08 0 2.2937037854984698e-08 0 2.29470378549847e-08 0.00021 2.29570378549847e-08 0 2.2957037854984698e-08 0 2.29670378549847e-08 0.00021 2.29770378549847e-08 0 2.2977604164674844e-08 0 2.2987604164674845e-08 0.00021 2.2997604164674846e-08 0 2.2997604164674843e-08 0 2.3007604164674844e-08 0.00021 2.3017604164674846e-08 0 2.3087557838691594e-08 0 2.3097557838691596e-08 0.00021 2.3107557838691597e-08 0 2.3143202376365712e-08 0 2.3153202376365713e-08 0.00021 2.3163202376365715e-08 0 2.316320237636571e-08 0 2.3173202376365713e-08 0.00021 2.3183202376365714e-08 0 2.318320237636571e-08 0 2.3193202376365712e-08 0.00021 2.3203202376365714e-08 0 2.320320237636571e-08 0 2.3213202376365712e-08 0.00021 2.3223202376365713e-08 0 2.322320237636571e-08 0 2.323320237636571e-08 0.00021 2.3243202376365713e-08 0 2.324320237636571e-08 0 2.325320237636571e-08 0.00021 2.3263202376365712e-08 0 2.326320237636571e-08 0 2.327320237636571e-08 0.00021 2.3283202376365712e-08 0 2.3402288396899836e-08 0 2.3412288396899837e-08 0.00021 2.342228839689984e-08 0 2.3422288396899835e-08 0 2.3432288396899837e-08 0.00021 2.3442288396899838e-08 0 2.3442288396899835e-08 0 2.3452288396899836e-08 0.00021 2.3462288396899837e-08 0 2.3462288396899834e-08 0 2.3472288396899836e-08 0.00021 2.3482288396899837e-08 0 2.3482288396899834e-08 0 2.3492288396899835e-08 0.00021 2.3502288396899836e-08 0 2.3502288396899833e-08 0 2.3512288396899835e-08 0.00021 2.3522288396899836e-08 0 2.3522288396899833e-08 0 2.3532288396899834e-08 0.00021 2.3542288396899836e-08 0 2.3542288396899832e-08 0 2.3552288396899834e-08 0.00021 2.3562288396899835e-08 0 2.356695693194045e-08 0 2.3576956931940452e-08 0.00021 2.3586956931940454e-08 0 2.358695693194045e-08 0 2.3596956931940452e-08 0.00021 2.3606956931940453e-08 0 2.3683599502342905e-08 0 2.3693599502342906e-08 0.00021 2.3703599502342908e-08 0 2.3703599502342904e-08 0 2.3713599502342906e-08 0.00021 2.3723599502342907e-08 0 2.3723599502342904e-08 0 2.3733599502342905e-08 0.00021 2.3743599502342907e-08 0 2.3743599502342904e-08 0 2.3753599502342905e-08 0.00021 2.3763599502342906e-08 0 2.3763599502342903e-08 0 2.3773599502342904e-08 0.00021 2.3783599502342906e-08 0 2.3783599502342903e-08 0 2.3793599502342904e-08 0.00021 2.3803599502342905e-08 0 2.3807566208263397e-08 0 2.3817566208263398e-08 0.00021 2.38275662082634e-08 0 2.3840796328863608e-08 0 2.385079632886361e-08 0.00021 2.386079632886361e-08 0 2.3860796328863608e-08 0 2.387079632886361e-08 0.00021 2.388079632886361e-08 0 2.3880796328863607e-08 0 2.389079632886361e-08 0.00021 2.390079632886361e-08 0 2.3914651186952722e-08 0 2.3924651186952724e-08 0.00021 2.3934651186952725e-08 0 2.3963557973170384e-08 0 2.3973557973170385e-08 0.00021 2.3983557973170387e-08 0 2.3983557973170383e-08 0 2.3993557973170385e-08 0.00021 2.4003557973170386e-08 0 2.4003557973170383e-08 0 2.4013557973170384e-08 0.00021 2.4023557973170386e-08 0 2.4023557973170382e-08 0 2.4033557973170384e-08 0.00021 2.4043557973170385e-08 0 2.40887760904895e-08 0 2.40987760904895e-08 0.00021 2.41087760904895e-08 0 2.4131758443703194e-08 0 2.4141758443703195e-08 0.00021 2.4151758443703197e-08 0 2.4151758443703194e-08 0 2.4161758443703195e-08 0.00021 2.4171758443703196e-08 0 2.4171758443703193e-08 0 2.4181758443703194e-08 0.00021 2.4191758443703196e-08 0 2.4191758443703193e-08 0 2.4201758443703194e-08 0.00021 2.4211758443703195e-08 0 2.422611518014632e-08 0 2.4236115180146322e-08 0.00021 2.4246115180146323e-08 0 2.428222808750745e-08 0 2.429222808750745e-08 0.00021 2.430222808750745e-08 0 2.4306741316123467e-08 0 2.4316741316123468e-08 0.00021 2.432674131612347e-08 0 2.4332225039846522e-08 0 2.4342225039846524e-08 0.00021 2.4352225039846525e-08 0 2.4352225039846522e-08 0 2.4362225039846523e-08 0.00021 2.4372225039846525e-08 0 2.437222503984652e-08 0 2.4382225039846523e-08 0.00021 2.4392225039846524e-08 0 2.4428936697366556e-08 0 2.4438936697366557e-08 0.00021 2.444893669736656e-08 0 2.4515399608044847e-08 0 2.452539960804485e-08 0.00021 2.453539960804485e-08 0 2.454912897662314e-08 0 2.455912897662314e-08 0.00021 2.4569128976623143e-08 0 2.456912897662314e-08 0 2.457912897662314e-08 0.00021 2.4589128976623142e-08 0 2.458912897662314e-08 0 2.459912897662314e-08 0.00021 2.460912897662314e-08 0 2.4609128976623138e-08 0 2.461912897662314e-08 0.00021 2.462912897662314e-08 0 2.4629128976623138e-08 0 2.463912897662314e-08 0.00021 2.464912897662314e-08 0 2.4649128976623137e-08 0 2.465912897662314e-08 0.00021 2.466912897662314e-08 0 2.472943631925136e-08 0 2.473943631925136e-08 0.00021 2.4749436319251362e-08 0 2.474943631925136e-08 0 2.475943631925136e-08 0.00021 2.476943631925136e-08 0 2.4787404446007705e-08 0 2.4797404446007706e-08 0.00021 2.4807404446007708e-08 0 2.484075743751817e-08 0 2.485075743751817e-08 0.00021 2.4860757437518172e-08 0 2.486167238789599e-08 0 2.4871672387895993e-08 0.00021 2.4881672387895994e-08 0 2.488167238789599e-08 0 2.4891672387895992e-08 0.00021 2.4901672387895994e-08 0 2.4915706686762606e-08 0 2.4925706686762607e-08 0.00021 2.493570668676261e-08 0 2.495969960925731e-08 0 2.496969960925731e-08 0.00021 2.4979699609257312e-08 0 2.5002179135713106e-08 0 2.5012179135713108e-08 0.00021 2.502217913571311e-08 0 2.5022179135713106e-08 0 2.5032179135713107e-08 0.00021 2.504217913571311e-08 0 2.505141197403321e-08 0 2.506141197403321e-08 0.00021 2.507141197403321e-08 0 2.5135580588476225e-08 0 2.5145580588476227e-08 0.00021 2.5155580588476228e-08 0 2.5193245772962273e-08 0 2.5203245772962275e-08 0.00021 2.5213245772962276e-08 0 2.5213245772962273e-08 0 2.5223245772962274e-08 0.00021 2.5233245772962276e-08 0 2.5233245772962272e-08 0 2.5243245772962274e-08 0.00021 2.5253245772962275e-08 0 2.5253245772962272e-08 0 2.5263245772962273e-08 0.00021 2.5273245772962275e-08 0 2.5278186638214907e-08 0 2.5288186638214908e-08 0.00021 2.529818663821491e-08 0 2.5298186638214906e-08 0 2.5308186638214908e-08 0.00021 2.531818663821491e-08 0 2.5318186638214906e-08 0 2.5328186638214907e-08 0.00021 2.533818663821491e-08 0 2.5338186638214905e-08 0 2.5348186638214907e-08 0.00021 2.5358186638214908e-08 0 2.5358186638214905e-08 0 2.5368186638214906e-08 0.00021 2.5378186638214908e-08 0 2.5378186638214904e-08 0 2.5388186638214906e-08 0.00021 2.5398186638214907e-08 0 2.5398186638214904e-08 0 2.5408186638214905e-08 0.00021 2.5418186638214907e-08 0 2.5435916350582037e-08 0 2.5445916350582038e-08 0.00021 2.545591635058204e-08 0 2.5455916350582036e-08 0 2.5465916350582038e-08 0.00021 2.547591635058204e-08 0 2.5498872060786632e-08 0 2.5508872060786634e-08 0.00021 2.5518872060786635e-08 0 2.5518872060786632e-08 0 2.5528872060786633e-08 0.00021 2.5538872060786635e-08 0 2.5565245572958688e-08 0 2.557524557295869e-08 0.00021 2.558524557295869e-08 0 2.5585245572958688e-08 0 2.559524557295869e-08 0.00021 2.560524557295869e-08 0 2.5665424715067852e-08 0 2.5675424715067854e-08 0.00021 2.5685424715067855e-08 0 2.5685424715067852e-08 0 2.5695424715067853e-08 0.00021 2.5705424715067855e-08 0 2.570542471506785e-08 0 2.5715424715067853e-08 0.00021 2.5725424715067854e-08 0 2.5745604755794483e-08 0 2.5755604755794484e-08 0.00021 2.5765604755794486e-08 0 2.5765604755794482e-08 0 2.5775604755794484e-08 0.00021 2.5785604755794485e-08 0 2.5785604755794482e-08 0 2.5795604755794483e-08 0.00021 2.5805604755794485e-08 0 2.580560475579448e-08 0 2.5815604755794483e-08 0.00021 2.5825604755794484e-08 0 2.582560475579448e-08 0 2.5835604755794482e-08 0.00021 2.5845604755794484e-08 0 2.584560475579448e-08 0 2.5855604755794482e-08 0.00021 2.5865604755794483e-08 0 2.586560475579448e-08 0 2.587560475579448e-08 0.00021 2.5885604755794483e-08 0 2.588560475579448e-08 0 2.589560475579448e-08 0.00021 2.5905604755794482e-08 0 2.590560475579448e-08 0 2.591560475579448e-08 0.00021 2.5925604755794482e-08 0 2.592560475579448e-08 0 2.593560475579448e-08 0.00021 2.594560475579448e-08 0 2.6060587906355788e-08 0 2.607058790635579e-08 0.00021 2.608058790635579e-08 0 2.6086086347843543e-08 0 2.6096086347843545e-08 0.00021 2.6106086347843546e-08 0 2.6108945348987988e-08 0 2.611894534898799e-08 0.00021 2.612894534898799e-08 0 2.6128945348987988e-08 0 2.613894534898799e-08 0.00021 2.614894534898799e-08 0 2.6148945348987987e-08 0 2.615894534898799e-08 0.00021 2.616894534898799e-08 0 2.6168945348987987e-08 0 2.6178945348987988e-08 0.00021 2.618894534898799e-08 0 2.6188945348987986e-08 0 2.6198945348987988e-08 0.00021 2.620894534898799e-08 0 2.6266745785116746e-08 0 2.6276745785116747e-08 0.00021 2.628674578511675e-08 0 2.643093757986743e-08 0 2.644093757986743e-08 0.00021 2.6450937579867433e-08 0 2.645312592134066e-08 0 2.646312592134066e-08 0.00021 2.647312592134066e-08 0 2.6473125921340658e-08 0 2.648312592134066e-08 0.00021 2.649312592134066e-08 0 2.6545455806558917e-08 0 2.655545580655892e-08 0.00021 2.656545580655892e-08 0 2.6621482697997535e-08 0 2.6631482697997537e-08 0.00021 2.6641482697997538e-08 0 2.6646772281979942e-08 0 2.6656772281979943e-08 0.00021 2.6666772281979945e-08 0 2.6686728191409847e-08 0 2.669672819140985e-08 0.00021 2.670672819140985e-08 0 2.6706728191409847e-08 0 2.6716728191409848e-08 0.00021 2.672672819140985e-08 0 2.6755702306024847e-08 0 2.676570230602485e-08 0.00021 2.677570230602485e-08 0 2.67971372717537e-08 0 2.68071372717537e-08 0.00021 2.68171372717537e-08 0 2.6817137271753698e-08 0 2.68271372717537e-08 0.00021 2.68371372717537e-08 0 2.6839322704623832e-08 0 2.6849322704623833e-08 0.00021 2.6859322704623835e-08 0 2.685932270462383e-08 0 2.6869322704623833e-08 0.00021 2.6879322704623834e-08 0 2.687941604125657e-08 0 2.688941604125657e-08 0.00021 2.689941604125657e-08 0 2.6899416041256568e-08 0 2.690941604125657e-08 0.00021 2.691941604125657e-08 0 2.6930637888629906e-08 0 2.6940637888629908e-08 0.00021 2.695063788862991e-08 0 2.6950637888629906e-08 0 2.6960637888629907e-08 0.00021 2.697063788862991e-08 0 2.6970637888629905e-08 0 2.6980637888629907e-08 0.00021 2.6990637888629908e-08 0 2.6990637888629905e-08 0 2.7000637888629906e-08 0.00021 2.7010637888629908e-08 0 2.7010637888629904e-08 0 2.7020637888629906e-08 0.00021 2.7030637888629907e-08 0 2.7030637888629904e-08 0 2.7040637888629905e-08 0.00021 2.7050637888629907e-08 0 2.7050637888629903e-08 0 2.7060637888629905e-08 0.00021 2.7070637888629906e-08 0 2.7070637888629903e-08 0 2.7080637888629904e-08 0.00021 2.7090637888629906e-08 0 2.7090637888629902e-08 0 2.7100637888629904e-08 0.00021 2.7110637888629905e-08 0 2.7110637888629902e-08 0 2.7120637888629903e-08 0.00021 2.7130637888629905e-08 0 2.71306378886299e-08 0 2.7140637888629903e-08 0.00021 2.7150637888629904e-08 0 2.71506378886299e-08 0 2.7160637888629902e-08 0.00021 2.7170637888629904e-08 0 2.71706378886299e-08 0 2.7180637888629902e-08 0.00021 2.7190637888629903e-08 0 2.71906378886299e-08 0 2.72006378886299e-08 0.00021 2.7210637888629903e-08 0 2.72106378886299e-08 0 2.72206378886299e-08 0.00021 2.7230637888629902e-08 0 2.72306378886299e-08 0 2.72406378886299e-08 0.00021 2.7250637888629902e-08 0 2.7466926621772525e-08 0 2.7476926621772527e-08 0.00021 2.7486926621772528e-08 0 2.7486926621772525e-08 0 2.7496926621772526e-08 0.00021 2.7506926621772528e-08 0 2.7506926621772524e-08 0 2.7516926621772526e-08 0.00021 2.7526926621772527e-08 0 2.7541423353812737e-08 0 2.7551423353812738e-08 0.00021 2.756142335381274e-08 0 2.7561423353812736e-08 0 2.7571423353812738e-08 0.00021 2.758142335381274e-08 0 2.7582489015246747e-08 0 2.759248901524675e-08 0.00021 2.760248901524675e-08 0 2.7602489015246747e-08 0 2.7612489015246748e-08 0.00021 2.762248901524675e-08 0 2.7622489015246746e-08 0 2.7632489015246748e-08 0.00021 2.764248901524675e-08 0 2.771600533556135e-08 0 2.772600533556135e-08 0.00021 2.7736005335561353e-08 0 2.7751396516836534e-08 0 2.7761396516836535e-08 0.00021 2.7771396516836537e-08 0 2.7800484741876936e-08 0 2.7810484741876938e-08 0.00021 2.782048474187694e-08 0 2.7842661661755777e-08 0 2.785266166175578e-08 0.00021 2.786266166175578e-08 0 2.7862661661755777e-08 0 2.7872661661755778e-08 0.00021 2.788266166175578e-08 0 2.7882661661755776e-08 0 2.7892661661755778e-08 0.00021 2.790266166175578e-08 0 2.7919263079659936e-08 0 2.7929263079659937e-08 0.00021 2.793926307965994e-08 0 2.794680073112855e-08 0 2.795680073112855e-08 0.00021 2.7966800731128553e-08 0 2.7967590724028233e-08 0 2.7977590724028235e-08 0.00021 2.7987590724028236e-08 0 2.7987590724028233e-08 0 2.7997590724028234e-08 0.00021 2.8007590724028236e-08 0 2.8007590724028232e-08 0 2.8017590724028234e-08 0.00021 2.8027590724028235e-08 0 2.8046513226177547e-08 0 2.8056513226177548e-08 0.00021 2.806651322617755e-08 0 2.8066513226177546e-08 0 2.8076513226177547e-08 0.00021 2.808651322617755e-08 0 2.8086513226177546e-08 0 2.8096513226177547e-08 0.00021 2.810651322617755e-08 0 2.8106513226177545e-08 0 2.8116513226177547e-08 0.00021 2.8126513226177548e-08 0 2.819696412551702e-08 0 2.8206964125517022e-08 0.00021 2.8216964125517024e-08 0 2.8221505286708186e-08 0 2.8231505286708187e-08 0.00021 2.824150528670819e-08 0 2.8278416640096327e-08 0 2.8288416640096328e-08 0.00021 2.829841664009633e-08 0 2.83232605766587e-08 0 2.83332605766587e-08 0.00021 2.83432605766587e-08 0 2.8343260576658698e-08 0 2.83532605766587e-08 0.00021 2.83632605766587e-08 0 2.8368545099802806e-08 0 2.8378545099802808e-08 0.00021 2.838854509980281e-08 0 2.8416423359938204e-08 0 2.8426423359938205e-08 0.00021 2.8436423359938207e-08 0 2.8436423359938204e-08 0 2.8446423359938205e-08 0.00021 2.8456423359938206e-08 0 2.8456423359938203e-08 0 2.8466423359938205e-08 0.00021 2.8476423359938206e-08 0 2.8476423359938203e-08 0 2.8486423359938204e-08 0.00021 2.8496423359938205e-08 0 2.8496423359938202e-08 0 2.8506423359938204e-08 0.00021 2.8516423359938205e-08 0 2.8516423359938202e-08 0 2.8526423359938203e-08 0.00021 2.8536423359938204e-08 0 2.85364233599382e-08 0 2.8546423359938203e-08 0.00021 2.8556423359938204e-08 0 2.85564233599382e-08 0 2.8566423359938202e-08 0.00021 2.8576423359938204e-08 0 2.85764233599382e-08 0 2.85864233599382e-08 0.00021 2.8596423359938203e-08 0 2.85964233599382e-08 0 2.86064233599382e-08 0.00021 2.8616423359938203e-08 0 2.86164233599382e-08 0 2.86264233599382e-08 0.00021 2.8636423359938202e-08 0 2.86364233599382e-08 0 2.86464233599382e-08 0.00021 2.86564233599382e-08 0 2.8656423359938198e-08 0 2.86664233599382e-08 0.00021 2.86764233599382e-08 0 2.8676423359938198e-08 0 2.86864233599382e-08 0.00021 2.86964233599382e-08 0 2.872461292634214e-08 0 2.8734612926342142e-08 0.00021 2.8744612926342143e-08 0 2.874461292634214e-08 0 2.875461292634214e-08 0.00021 2.8764612926342143e-08 0 2.876461292634214e-08 0 2.877461292634214e-08 0.00021 2.8784612926342142e-08 0 2.8791390376215012e-08 0 2.8801390376215013e-08 0.00021 2.8811390376215015e-08 0 2.8822600635669495e-08 0 2.8832600635669496e-08 0.00021 2.8842600635669498e-08 0 2.8865527864626377e-08 0 2.887552786462638e-08 0.00021 2.888552786462638e-08 0 2.890163388697682e-08 0 2.891163388697682e-08 0.00021 2.8921633886976822e-08 0 2.892163388697682e-08 0 2.893163388697682e-08 0.00021 2.894163388697682e-08 0 2.9028729521992274e-08 0 2.9038729521992275e-08 0.00021 2.9048729521992276e-08 0 2.9094437418570654e-08 0 2.9104437418570656e-08 0.00021 2.9114437418570657e-08 0 2.919080715260776e-08 0 2.920080715260776e-08 0.00021 2.9210807152607763e-08 0 2.9219191014545273e-08 0 2.9229191014545274e-08 0.00021 2.9239191014545276e-08 0 2.9239191014545272e-08 0 2.9249191014545274e-08 0.00021 2.9259191014545275e-08 0 2.9259191014545272e-08 0 2.9269191014545273e-08 0.00021 2.9279191014545275e-08 0 2.927919101454527e-08 0 2.9289191014545273e-08 0.00021 2.9299191014545274e-08 0 2.929919101454527e-08 0 2.9309191014545272e-08 0.00021 2.9319191014545274e-08 0 2.931919101454527e-08 0 2.9329191014545272e-08 0.00021 2.9339191014545273e-08 0 2.9381573911281926e-08 0 2.9391573911281927e-08 0.00021 2.940157391128193e-08 0 2.9401573911281925e-08 0 2.9411573911281927e-08 0.00021 2.9421573911281928e-08 0 2.9471367251021454e-08 0 2.9481367251021455e-08 0.00021 2.9491367251021457e-08 0 2.9491367251021454e-08 0 2.9501367251021455e-08 0.00021 2.9511367251021456e-08 0 2.9511367251021453e-08 0 2.9521367251021454e-08 0.00021 2.9531367251021456e-08 0 2.9531367251021453e-08 0 2.9541367251021454e-08 0.00021 2.9551367251021455e-08 0 2.9552491817622038e-08 0 2.956249181762204e-08 0.00021 2.957249181762204e-08 0 2.9579122150969285e-08 0 2.9589122150969286e-08 0.00021 2.9599122150969288e-08 0 2.960214659396061e-08 0 2.961214659396061e-08 0.00021 2.962214659396061e-08 0 2.9622146593960608e-08 0 2.963214659396061e-08 0.00021 2.964214659396061e-08 0 2.9735834709327865e-08 0 2.9745834709327867e-08 0.00021 2.9755834709327868e-08 0 2.9755834709327865e-08 0 2.9765834709327866e-08 0.00021 2.9775834709327868e-08 0 2.9775834709327864e-08 0 2.9785834709327866e-08 0.00021 2.9795834709327867e-08 0 2.9795834709327864e-08 0 2.9805834709327865e-08 0.00021 2.9815834709327863e-08 0 2.98438786361617e-08 0 2.98538786361617e-08 0.00021 2.9863878636161696e-08 0 2.9899207987190693e-08 0 2.990920798719069e-08 0.00021 2.991920798719069e-08 0 2.9919207987190696e-08 0 2.9929207987190694e-08 0.00021 2.993920798719069e-08 0 2.99392079871907e-08 0 2.99492079871907e-08 0.00021 2.9959207987190695e-08 0 2.99592079871907e-08 0 2.99692079871907e-08 0.00021 2.99792079871907e-08 0 2.9979207987190705e-08 0 2.99892079871907e-08 0.00021 2.99992079871907e-08 0 3.006554446512974e-08 0 3.007554446512974e-08 0.00021 3.0085544465129736e-08 0 3.008554446512974e-08 0 3.009554446512974e-08 0.00021 3.010554446512974e-08 0 3.0112543884628494e-08 0 3.012254388462849e-08 0.00021 3.013254388462849e-08 0 3.0154301311799525e-08 0 3.016430131179952e-08 0.00021 3.017430131179952e-08 0 3.017430131179953e-08 0 3.0184301311799526e-08 0.00021 3.0194301311799524e-08 0 3.022562991960052e-08 0 3.023562991960052e-08 0.00021 3.024562991960052e-08 0 3.027244269766359e-08 0 3.0282442697663585e-08 0.00021 3.0292442697663583e-08 0 3.029874776798851e-08 0 3.0308747767988507e-08 0.00021 3.0318747767988505e-08 0 3.031874776798851e-08 0 3.032874776798851e-08 0.00021 3.033874776798851e-08 0 3.0338747767988514e-08 0 3.034874776798851e-08 0.00021 3.035874776798851e-08 0 3.035874776798852e-08 0 3.0368747767988515e-08 0.00021 3.037874776798851e-08 0 3.0410323214167264e-08 0 3.042032321416726e-08 0.00021 3.043032321416726e-08 0 3.0434696828107786e-08 0 3.0444696828107784e-08 0.00021 3.045469682810778e-08 0 3.045469682810779e-08 0 3.046469682810779e-08 0.00021 3.0474696828107785e-08 0 3.047469682810779e-08 0 3.048469682810779e-08 0.00021 3.049469682810779e-08 0 3.051288081701813e-08 0 3.0522880817018126e-08 0.00021 3.0532880817018124e-08 0 3.055281732383358e-08 0 3.056281732383358e-08 0.00021 3.0572817323833576e-08 0 3.0598109165963743e-08 0 3.060810916596374e-08 0.00021 3.061810916596374e-08 0 3.0618109165963746e-08 0 3.0628109165963744e-08 0.00021 3.063810916596374e-08 0 3.063810916596375e-08 0 3.064810916596375e-08 0.00021 3.0658109165963745e-08 0 3.066385478924237e-08 0 3.067385478924237e-08 0.00021 3.068385478924237e-08 0 3.068465645673523e-08 0 3.069465645673523e-08 0.00021 3.0704656456735225e-08 0 3.071909496264887e-08 0 3.072909496264887e-08 0.00021 3.0739094962648867e-08 0 3.073909496264887e-08 0 3.074909496264887e-08 0.00021 3.075909496264887e-08 0 3.0759094962648876e-08 0 3.0769094962648874e-08 0.00021 3.077909496264887e-08 0 3.077909496264888e-08 0 3.078909496264888e-08 0.00021 3.0799094962648875e-08 0 3.079909496264888e-08 0 3.080909496264888e-08 0.00021 3.081909496264888e-08 0 3.082013285063405e-08 0 3.083013285063405e-08 0.00021 3.084013285063405e-08 0 3.085592097770873e-08 0 3.086592097770873e-08 0.00021 3.087592097770873e-08 0 3.0875920977708736e-08 0 3.0885920977708734e-08 0.00021 3.089592097770873e-08 0 3.089592097770874e-08 0 3.090592097770874e-08 0.00021 3.0915920977708735e-08 0 3.091592097770874e-08 0 3.092592097770874e-08 0.00021 3.093592097770874e-08 0 3.094009517858286e-08 0 3.095009517858286e-08 0.00021 3.0960095178582856e-08 0 3.1003556175238234e-08 0 3.101355617523823e-08 0.00021 3.102355617523823e-08 0 3.1051434235716396e-08 0 3.1061434235716394e-08 0.00021 3.107143423571639e-08 0 3.107287782646074e-08 0 3.108287782646074e-08 0.00021 3.109287782646074e-08 0 3.1097076478973224e-08 0 3.110707647897322e-08 0.00021 3.111707647897322e-08 0 3.112672834701988e-08 0 3.113672834701988e-08 0.00021 3.1146728347019876e-08 0 3.115792055852829e-08 0 3.116792055852829e-08 0.00021 3.117792055852829e-08 0 3.1219322040880755e-08 0 3.122932204088075e-08 0.00021 3.123932204088075e-08 0 3.12585126638462e-08 0 3.12685126638462e-08 0.00021 3.12785126638462e-08 0 3.1278512663846205e-08 0 3.1288512663846204e-08 0.00021 3.12985126638462e-08 0 3.129851266384621e-08 0 3.1308512663846206e-08 0.00021 3.1318512663846204e-08 0 3.131851266384621e-08 0 3.132851266384621e-08 0.00021 3.133851266384621e-08 0 3.135972811153147e-08 0 3.136972811153147e-08 0.00021 3.137972811153147e-08 0 3.139891167249891e-08 0 3.1408911672498905e-08 0.00021 3.14189116724989e-08 0 3.141891167249891e-08 0 3.142891167249891e-08 0.00021 3.1438911672498906e-08 0 3.144868868837298e-08 0 3.145868868837298e-08 0.00021 3.146868868837298e-08 0 3.1468688688372984e-08 0 3.147868868837298e-08 0.00021 3.148868868837298e-08 0 3.148868868837299e-08 0 3.1498688688372985e-08 0.00021 3.1508688688372983e-08 0 3.1548784072458504e-08 0 3.15587840724585e-08 0.00021 3.15687840724585e-08 0 3.156878407245851e-08 0 3.1578784072458505e-08 0.00021 3.1588784072458504e-08 0 3.159792474300042e-08 0 3.160792474300042e-08 0.00021 3.1617924743000415e-08 0 3.16745246547241e-08 0 3.16845246547241e-08 0.00021 3.1694524654724096e-08 0 3.173659538937347e-08 0 3.174659538937347e-08 0.00021 3.1756595389373467e-08 0 3.175659538937347e-08 0 3.176659538937347e-08 0.00021 3.177659538937347e-08 0 3.186192246193396e-08 0 3.187192246193396e-08 0.00021 3.188192246193396e-08 0 3.1881922461933966e-08 0 3.1891922461933964e-08 0.00021 3.190192246193396e-08 0 3.190192246193397e-08 0 3.191192246193397e-08 0.00021 3.1921922461933965e-08 0 3.192192246193397e-08 0 3.193192246193397e-08 0.00021 3.194192246193397e-08 0 3.1941922461933975e-08 0 3.195192246193397e-08 0.00021 3.196192246193397e-08 0 3.200559224253101e-08 0 3.2015592242531006e-08 0.00021 3.2025592242531004e-08 0 3.204228585561152e-08 0 3.205228585561152e-08 0.00021 3.206228585561152e-08 0 3.207009795688508e-08 0 3.2080097956885075e-08 0.00021 3.209009795688507e-08 0 3.209009795688508e-08 0 3.210009795688508e-08 0.00021 3.2110097956885076e-08 0 3.211009795688508e-08 0 3.212009795688508e-08 0.00021 3.213009795688508e-08 0 3.2130097956885085e-08 0 3.2140097956885083e-08 0.00021 3.215009795688508e-08 0 3.215009795688509e-08 0 3.2160097956885086e-08 0.00021 3.2170097956885084e-08 0 3.2231414923209954e-08 0 3.224141492320995e-08 0.00021 3.225141492320995e-08 0 3.229828155171819e-08 0 3.2308281551718187e-08 0.00021 3.2318281551718185e-08 0 3.248514411161731e-08 0 3.249514411161731e-08 0.00021 3.250514411161731e-08 0 3.2505144111617315e-08 0 3.251514411161731e-08 0.00021 3.252514411161731e-08 0 3.254873460058336e-08 0 3.255873460058336e-08 0.00021 3.256873460058336e-08 0 3.2568734600583364e-08 0 3.257873460058336e-08 0.00021 3.258873460058336e-08 0 3.258873460058337e-08 0 3.2598734600583365e-08 0.00021 3.260873460058336e-08 0 3.260873460058337e-08 0 3.261873460058337e-08 0.00021 3.2628734600583366e-08 0 3.262873460058337e-08 0 3.263873460058337e-08 0.00021 3.264873460058337e-08 0 3.2648734600583376e-08 0 3.2658734600583374e-08 0.00021 3.266873460058337e-08 0 3.266873460058338e-08 0 3.2678734600583377e-08 0.00021 3.2688734600583375e-08 0 3.268873460058338e-08 0 3.269873460058338e-08 0.00021 3.270873460058338e-08 0 3.2726518252265004e-08 0 3.2736518252265e-08 0.00021 3.2746518252265e-08 0 3.274651825226501e-08 0 3.2756518252265005e-08 0.00021 3.2766518252265003e-08 0 3.2858427195653304e-08 0 3.28684271956533e-08 0.00021 3.28784271956533e-08 0 3.2885124737043965e-08 0 3.289512473704396e-08 0.00021 3.290512473704396e-08 0 3.291332174713586e-08 0 3.2923321747135856e-08 0.00021 3.2933321747135854e-08 0 3.293336478454111e-08 0 3.294336478454111e-08 0.00021 3.295336478454111e-08 0 3.2953364784541114e-08 0 3.296336478454111e-08 0.00021 3.297336478454111e-08 0 3.2987211805335647e-08 0 3.2997211805335645e-08 0.00021 3.300721180533564e-08 0 3.300721180533565e-08 0 3.301721180533565e-08 0.00021 3.3027211805335646e-08 0 3.305402318056486e-08 0 3.306402318056486e-08 0.00021 3.307402318056486e-08 0 3.3158639186823645e-08 0 3.316863918682364e-08 0.00021 3.317863918682364e-08 0 3.323637146213315e-08 0 3.324637146213315e-08 0.00021 3.325637146213315e-08 0 3.3303987341402e-08 0 3.3313987341402e-08 0.00021 3.3323987341401996e-08 0 3.33245806860946e-08 0 3.3334580686094595e-08 0.00021 3.334458068609459e-08 0 3.335125878547995e-08 0 3.336125878547995e-08 0.00021 3.337125878547995e-08 0 3.3414139354426046e-08 0 3.3424139354426044e-08 0.00021 3.343413935442604e-08 0 3.343413935442605e-08 0 3.344413935442605e-08 0.00021 3.3454139354426045e-08 0 3.345911260904093e-08 0 3.3469112609040925e-08 0.00021 3.347911260904092e-08 0 3.348972993478617e-08 0 3.349972993478617e-08 0.00021 3.3509729934786166e-08 0 3.353747540344043e-08 0 3.354747540344043e-08 0.00021 3.3557475403440426e-08 0 3.356379816038948e-08 0 3.3573798160389476e-08 0.00021 3.3583798160389474e-08 0 3.358379816038948e-08 0 3.359379816038948e-08 0.00021 3.3603798160389477e-08 0 3.360379816038948e-08 0 3.361379816038948e-08 0.00021 3.362379816038948e-08 0 3.363849464891545e-08 0 3.364849464891545e-08 0.00021 3.365849464891545e-08 0 3.368820812844604e-08 0 3.369820812844604e-08 0.00021 3.3708208128446035e-08 0 3.370820812844604e-08 0 3.371820812844604e-08 0.00021 3.372820812844604e-08 0 3.3730766556911144e-08 0 3.374076655691114e-08 0.00021 3.375076655691114e-08 0 3.3785931151179264e-08 0 3.379593115117926e-08 0.00021 3.380593115117926e-08 0 3.380918367228141e-08 0 3.381918367228141e-08 0.00021 3.382918367228141e-08 0 3.3829183672281415e-08 0 3.383918367228141e-08 0.00021 3.384918367228141e-08 0 3.3855538390985856e-08 0 3.3865538390985854e-08 0.00021 3.387553839098585e-08 0 3.388274041781999e-08 0 3.3892740417819986e-08 0.00021 3.3902740417819984e-08 0 3.390274041781999e-08 0 3.391274041781999e-08 0.00021 3.392274041781999e-08 0 3.3922740417819994e-08 0 3.393274041781999e-08 0.00021 3.394274041781999e-08 0 3.3942740417819997e-08 0 3.3952740417819995e-08 0.00021 3.396274041781999e-08 0 3.396274041782e-08 0 3.397274041782e-08 0.00021 3.3982740417819996e-08 0 3.398274041782e-08 0 3.399274041782e-08 0.00021 3.400274041782e-08 0 3.4002740417820005e-08 0 3.401274041782e-08 0.00021 3.402274041782e-08 0 3.402274041782001e-08 0 3.4032740417820006e-08 0.00021 3.4042740417820004e-08 0 3.404274041782001e-08 0 3.405274041782001e-08 0.00021 3.406274041782001e-08 0 3.4062740417820013e-08 0 3.407274041782001e-08 0.00021 3.408274041782001e-08 0 3.4082740417820016e-08 0 3.4092740417820014e-08 0.00021 3.410274041782001e-08 0 3.410274041782002e-08 0 3.411274041782002e-08 0.00021 3.4122740417820015e-08 0 3.412274041782002e-08 0 3.413274041782002e-08 0.00021 3.414274041782002e-08 0 3.4142740417820025e-08 0 3.415274041782002e-08 0.00021 3.416274041782002e-08 0 3.416274041782003e-08 0 3.4172740417820026e-08 0.00021 3.4182740417820024e-08 0 3.418274041782003e-08 0 3.419274041782003e-08 0.00021 3.4202740417820027e-08 0 3.420274041782003e-08 0 3.421274041782003e-08 0.00021 3.422274041782003e-08 0 3.4222740417820036e-08 0 3.4232740417820034e-08 0.00021 3.424274041782003e-08 0 3.424274041782004e-08 0 3.425274041782004e-08 0.00021 3.4262740417820035e-08 0 3.426274041782004e-08 0 3.427274041782004e-08 0.00021 3.428274041782004e-08 0 3.4282740417820045e-08 0 3.429274041782004e-08 0.00021 3.430274041782004e-08 0 3.430274041782005e-08 0 3.4312740417820045e-08 0.00021 3.4322740417820044e-08 0 3.432274041782005e-08 0 3.433274041782005e-08 0.00021 3.4342740417820046e-08 0 3.434274041782005e-08 0 3.435274041782005e-08 0.00021 3.436274041782005e-08 0 3.4362740417820056e-08 0 3.4372740417820054e-08 0.00021 3.438274041782005e-08 0 3.438274041782006e-08 0 3.439274041782006e-08 0.00021 3.4402740417820055e-08 0 3.440274041782006e-08 0 3.441274041782006e-08 0.00021 3.442274041782006e-08 0 3.4422740417820064e-08 0 3.443274041782006e-08 0.00021 3.444274041782006e-08 0 3.445462251449347e-08 0 3.4464622514493467e-08 0.00021 3.4474622514493465e-08 0 3.4509373773865266e-08 0 3.4519373773865265e-08 0.00021 3.452937377386526e-08 0 3.453807495246885e-08 0 3.4548074952468846e-08 0.00021 3.4558074952468844e-08 0 3.458228373451508e-08 0 3.459228373451508e-08 0.00021 3.460228373451508e-08 0 3.4602283734515084e-08 0 3.461228373451508e-08 0.00021 3.462228373451508e-08 0 3.462228373451509e-08 0 3.4632283734515085e-08 0.00021 3.4642283734515083e-08 0 3.464228373451509e-08 0 3.465228373451509e-08 0.00021 3.4662283734515086e-08 0 3.466228373451509e-08 0 3.467228373451509e-08 0.00021 3.468228373451509e-08 0 3.4682283734515096e-08 0 3.4692283734515094e-08 0.00021 3.470228373451509e-08 0 3.47022837345151e-08 0 3.4712283734515097e-08 0.00021 3.4722283734515095e-08 0 3.47222837345151e-08 0 3.47322837345151e-08 0.00021 3.47422837345151e-08 0 3.4756455726120165e-08 0 3.476645572612016e-08 0.00021 3.477645572612016e-08 0 3.477645572612017e-08 0 3.4786455726120166e-08 0.00021 3.4796455726120164e-08 0 3.485234065074994e-08 0 3.486234065074994e-08 0.00021 3.4872340650749935e-08 0 3.487834210530432e-08 0 3.488834210530432e-08 0.00021 3.4898342105304316e-08 0 3.498002687088217e-08 0 3.4990026870882165e-08 0.00021 3.500002687088216e-08 0 3.503169416221676e-08 0 3.504169416221676e-08 0.00021 3.505169416221676e-08 0 3.5051694162216766e-08 0 3.5061694162216764e-08 0.00021 3.507169416221676e-08 0 3.507169416221677e-08 0 3.5081694162216766e-08 0.00021 3.5091694162216765e-08 0 3.5096301847614686e-08 0 3.5106301847614684e-08 0.00021 3.511630184761468e-08 0 3.523098184852824e-08 0 3.524098184852824e-08 0.00021 3.525098184852824e-08 0 3.5250981848528245e-08 0 3.526098184852824e-08 0.00021 3.527098184852824e-08 0 3.527098184852825e-08 0 3.5280981848528246e-08 0.00021 3.5290981848528244e-08 0 3.529098184852825e-08 0 3.530098184852825e-08 0.00021 3.5310981848528247e-08 0 3.531098184852825e-08 0 3.532098184852825e-08 0.00021 3.533098184852825e-08 0 3.5330981848528256e-08 0 3.5340981848528254e-08 0.00021 3.535098184852825e-08 0 3.535098184852826e-08 0 3.536098184852826e-08 0.00021 3.5370981848528255e-08 0 3.537098184852826e-08 0 3.538098184852826e-08 0.00021 3.539098184852826e-08 0 3.5415047431984575e-08 0 3.542504743198457e-08 0.00021 3.543504743198457e-08 0 3.544167155756022e-08 0 3.5451671557560215e-08 0.00021 3.546167155756021e-08 0 3.546167155756022e-08 0 3.547167155756022e-08 0.00021 3.5481671557560216e-08 0 3.548167155756022e-08 0 3.549167155756022e-08 0.00021 3.550167155756022e-08 0 3.5501671557560225e-08 0 3.5511671557560223e-08 0.00021 3.552167155756022e-08 0 3.552167155756023e-08 0 3.5531671557560226e-08 0.00021 3.5541671557560224e-08 0 3.554167155756023e-08 0 3.555167155756023e-08 0.00021 3.556167155756023e-08 0 3.5561671557560234e-08 0 3.557167155756023e-08 0.00021 3.558167155756023e-08 0 3.5590823192986766e-08 0 3.5600823192986765e-08 0.00021 3.561082319298676e-08 0 3.56562131980799e-08 0 3.56662131980799e-08 0.00021 3.56762131980799e-08 0 3.5676213198079905e-08 0 3.56862131980799e-08 0.00021 3.56962131980799e-08 0 3.571594102852391e-08 0 3.572594102852391e-08 0.00021 3.573594102852391e-08 0 3.5735941028523915e-08 0 3.574594102852391e-08 0.00021 3.575594102852391e-08 0 3.577258672407495e-08 0 3.578258672407495e-08 0.00021 3.579258672407495e-08 0 3.5792586724074953e-08 0 3.580258672407495e-08 0.00021 3.581258672407495e-08 0 3.5812586724074956e-08 0 3.5822586724074954e-08 0.00021 3.583258672407495e-08 0 3.590058899781401e-08 0 3.591058899781401e-08 0.00021 3.5920588997814006e-08 0 3.592058899781401e-08 0 3.593058899781401e-08 0.00021 3.594058899781401e-08 0 3.5940588997814015e-08 0 3.595058899781401e-08 0.00021 3.596058899781401e-08 0 3.596058899781402e-08 0 3.5970588997814016e-08 0.00021 3.5980588997814014e-08 0 3.6043733196240566e-08 0 3.6053733196240564e-08 0.00021 3.606373319624056e-08 0 3.6137997696029675e-08 0 3.6147997696029673e-08 0.00021 3.615799769602967e-08 0 3.629933914746019e-08 0 3.630933914746019e-08 0.00021 3.6319339147460186e-08 0 3.6329013611147356e-08 0 3.6339013611147354e-08 0.00021 3.634901361114735e-08 0 3.634901361114736e-08 0 3.6359013611147356e-08 0.00021 3.6369013611147355e-08 0 3.638931679197919e-08 0 3.639931679197919e-08 0.00021 3.640931679197919e-08 0 3.6409316791979194e-08 0 3.641931679197919e-08 0.00021 3.642931679197919e-08 0 3.649827870558299e-08 0 3.6508278705582986e-08 0.00021 3.6518278705582984e-08 0 3.6538121952797056e-08 0 3.6548121952797054e-08 0.00021 3.655812195279705e-08 0 3.663687295566221e-08 0 3.6646872955662206e-08 0.00021 3.6656872955662204e-08 0 3.665687295566221e-08 0 3.666687295566221e-08 0.00021 3.6676872955662207e-08 0 3.667687295566221e-08 0 3.668687295566221e-08 0.00021 3.669687295566221e-08 0 3.677141163993038e-08 0 3.678141163993038e-08 0.00021 3.679141163993038e-08 0 3.6791411639930384e-08 0 3.680141163993038e-08 0.00021 3.681141163993038e-08 0 3.681141163993039e-08 0 3.6821411639930385e-08 0.00021 3.6831411639930383e-08 0 3.68925123013738e-08 0 3.69025123013738e-08 0.00021 3.69125123013738e-08 0 3.693398237502428e-08 0 3.694398237502428e-08 0.00021 3.6953982375024276e-08 0 3.697969799987299e-08 0 3.698969799987299e-08 0.00021 3.699969799987299e-08 0 3.7023345715659203e-08 0 3.70333457156592e-08 0.00021 3.70433457156592e-08 0 3.7043345715659206e-08 0 3.7053345715659204e-08 0.00021 3.70633457156592e-08 0 3.7101281682717995e-08 0 3.711128168271799e-08 0.00021 3.712128168271799e-08 0 3.714122942867844e-08 0 3.715122942867844e-08 0.00021 3.716122942867844e-08 0 3.721193158873876e-08 0 3.7221931588738755e-08 0.00021 3.7231931588738753e-08 0 3.723193158873876e-08 0 3.724193158873876e-08 0.00021 3.7251931588738756e-08 0 3.725193158873876e-08 0 3.726193158873876e-08 0.00021 3.727193158873876e-08 0 3.7271931588738766e-08 0 3.7281931588738764e-08 0.00021 3.729193158873876e-08 0 3.729193158873877e-08 0 3.7301931588738767e-08 0.00021 3.7311931588738765e-08 0 3.731193158873877e-08 0 3.732193158873877e-08 0.00021 3.733193158873877e-08 0 3.7331931588738774e-08 0 3.734193158873877e-08 0.00021 3.735193158873877e-08 0 3.735193158873878e-08 0 3.7361931588738775e-08 0.00021 3.737193158873877e-08 0 3.737193158873878e-08 0 3.738193158873878e-08 0.00021 3.7391931588738776e-08 0 3.739193158873878e-08 0 3.740193158873878e-08 0.00021 3.741193158873878e-08 0 3.7411931588738785e-08 0 3.7421931588738784e-08 0.00021 3.743193158873878e-08 0 3.743193158873879e-08 0 3.7441931588738786e-08 0.00021 3.7451931588738784e-08 0 3.745224665737752e-08 0 3.746224665737752e-08 0.00021 3.747224665737752e-08 0 3.7472246657377524e-08 0 3.748224665737752e-08 0.00021 3.749224665737752e-08 0 3.749224665737753e-08 0 3.7502246657377525e-08 0.00021 3.7512246657377523e-08 0 3.7597561784883016e-08 0 3.7607561784883014e-08 0.00021 3.761756178488301e-08 0 3.762842996480869e-08 0 3.763842996480869e-08 0.00021 3.7648429964808685e-08 0 3.764842996480869e-08 0 3.765842996480869e-08 0.00021 3.766842996480869e-08 0 3.7668429964808694e-08 0 3.767842996480869e-08 0.00021 3.768842996480869e-08 0 3.76884299648087e-08 0 3.7698429964808695e-08 0.00021 3.7708429964808693e-08 0 3.77084299648087e-08 0 3.77184299648087e-08 0.00021 3.7728429964808696e-08 0 3.77284299648087e-08 0 3.77384299648087e-08 0.00021 3.77484299648087e-08 0 3.7756058619247665e-08 0 3.7766058619247663e-08 0.00021 3.777605861924766e-08 0 3.777605861924767e-08 0 3.7786058619247666e-08 0.00021 3.7796058619247664e-08 0 3.781295386939181e-08 0 3.782295386939181e-08 0.00021 3.7832953869391805e-08 0 3.783702020303309e-08 0 3.784702020303309e-08 0.00021 3.785702020303309e-08 0 3.7857020203033095e-08 0 3.7867020203033093e-08 0.00021 3.787702020303309e-08 0 3.78770202030331e-08 0 3.7887020203033096e-08 0.00021 3.7897020203033094e-08 0 3.78970202030331e-08 0 3.79070202030331e-08 0.00021 3.79170202030331e-08 0 3.792519574409797e-08 0 3.793519574409797e-08 0.00021 3.794519574409797e-08 0 3.7989543624988754e-08 0 3.799954362498875e-08 0.00021 3.800954362498875e-08 0 3.8018485061170035e-08 0 3.802848506117003e-08 0.00021 3.803848506117003e-08 0 3.8039195737062666e-08 0 3.8049195737062664e-08 0.00021 3.805919573706266e-08 0 3.807549597360414e-08 0 3.8085495973604136e-08 0.00021 3.8095495973604135e-08 0 3.810008196065941e-08 0 3.811008196065941e-08 0.00021 3.812008196065941e-08 0 3.814103469532144e-08 0 3.815103469532144e-08 0.00021 3.8161034695321436e-08 0 3.816891838479993e-08 0 3.817891838479993e-08 0.00021 3.818891838479993e-08 0 3.819715771367498e-08 0 3.820715771367498e-08 0.00021 3.821715771367498e-08 0 3.8217157713674986e-08 0 3.8227157713674984e-08 0.00021 3.823715771367498e-08 0 3.823715771367499e-08 0 3.824715771367499e-08 0.00021 3.8257157713674985e-08 0 3.8267826669430414e-08 0 3.827782666943041e-08 0.00021 3.828782666943041e-08 0 3.830019852463499e-08 0 3.831019852463499e-08 0.00021 3.832019852463499e-08 0 3.834643386872366e-08 0 3.835643386872366e-08 0.00021 3.836643386872366e-08 0 3.8454671153642096e-08 0 3.8464671153642094e-08 0.00021 3.847467115364209e-08 0 3.850226197268048e-08 0 3.851226197268048e-08 0.00021 3.852226197268048e-08 0 3.8522261972680484e-08 0 3.853226197268048e-08 0.00021 3.854226197268048e-08 0 3.854226197268049e-08 0 3.8552261972680485e-08 0.00021 3.856226197268048e-08 0 3.856226197268049e-08 0 3.857226197268049e-08 0.00021 3.8582261972680486e-08 0 3.858226197268049e-08 0 3.859226197268049e-08 0.00021 3.860226197268049e-08 0 3.8602261972680495e-08 0 3.8612261972680494e-08 0.00021 3.862226197268049e-08 0 3.8627987621124905e-08 0 3.8637987621124903e-08 0.00021 3.86479876211249e-08 0 3.864798762112491e-08 0 3.8657987621124906e-08 0.00021 3.8667987621124904e-08 0 3.866798762112491e-08 0 3.867798762112491e-08 0.00021 3.868798762112491e-08 0 3.870058226059855e-08 0 3.871058226059855e-08 0.00021 3.8720582260598546e-08 0 3.872058226059855e-08 0 3.873058226059855e-08 0.00021 3.874058226059855e-08 0 3.8740582260598555e-08 0 3.8750582260598553e-08 0.00021 3.876058226059855e-08 0 3.876076838116155e-08 0 3.8770768381161546e-08 0.00021 3.8780768381161544e-08 0 3.878076838116155e-08 0 3.879076838116155e-08 0.00021 3.880076838116155e-08 0 3.882771015393303e-08 0 3.8837710153933025e-08 0.00021 3.884771015393302e-08 0 3.884771015393303e-08 0 3.885771015393303e-08 0.00021 3.8867710153933026e-08 0 3.886771015393303e-08 0 3.887771015393303e-08 0.00021 3.888771015393303e-08 0 3.8887710153933035e-08 0 3.8897710153933033e-08 0.00021 3.890771015393303e-08 0 3.890771015393304e-08 0 3.8917710153933036e-08 0.00021 3.8927710153933034e-08 0 3.895251743614598e-08 0 3.896251743614598e-08 0.00021 3.8972517436145976e-08 0 3.897251743614598e-08 0 3.898251743614598e-08 0.00021 3.899251743614598e-08 0 3.8992517436145985e-08 0 3.900251743614598e-08 0.00021 3.901251743614598e-08 0 3.901251743614599e-08 0 3.9022517436145986e-08 0.00021 3.9032517436145984e-08 0 3.903251743614599e-08 0 3.904251743614599e-08 0.00021 3.905251743614599e-08 0 3.9052517436145994e-08 0 3.906251743614599e-08 0.00021 3.907251743614599e-08 0 3.909466712416902e-08 0 3.9104667124169016e-08 0.00021 3.9114667124169014e-08 0 3.913203341187505e-08 0 3.9142033411875046e-08 0.00021 3.9152033411875044e-08 0 3.915203341187505e-08 0 3.916203341187505e-08 0.00021 3.917203341187505e-08 0 3.928301144795386e-08 0 3.929301144795386e-08 0.00021 3.9303011447953855e-08 0 3.9396380810061084e-08 0 3.940638081006108e-08 0.00021 3.941638081006108e-08 0 3.956366995801722e-08 0 3.957366995801722e-08 0.00021 3.9583669958017215e-08 0 3.958366995801722e-08 0 3.959366995801722e-08 0.00021 3.960366995801722e-08 0 3.9603669958017225e-08 0 3.961366995801722e-08 0.00021 3.962366995801722e-08 0 3.974773206282351e-08 0 3.9757732062823506e-08 0.00021 3.9767732062823504e-08 0 3.98085979258978e-08 0 3.98185979258978e-08 0.00021 3.9828597925897795e-08 0 3.98433788016745e-08 0 3.98533788016745e-08 0.00021 3.98633788016745e-08 0 3.9943282178116755e-08 0 3.995328217811675e-08 0.00021 3.996328217811675e-08 0 3.998757060897528e-08 0 3.999757060897528e-08 0.00021 4.0007570608975276e-08 0 4.002088583758931e-08 0 4.003088583758931e-08 0.00021 4.0040885837589305e-08 0 4.007440260832961e-08 0 4.0084402608329606e-08 0.00021 4.0094402608329604e-08 0 4.010144057960562e-08 0 4.0111440579605616e-08 0.00021 4.0121440579605614e-08 0 4.012144057960562e-08 0 4.013144057960562e-08 0.00021 4.014144057960562e-08 0 4.015482554934866e-08 0 4.016482554934866e-08 0.00021 4.017482554934866e-08 0 4.021394080796314e-08 0 4.022394080796314e-08 0.00021 4.023394080796314e-08 0 4.0380123681524295e-08 0 4.0390123681524293e-08 0.00021 4.040012368152429e-08 0 4.04001236815243e-08 0 4.0410123681524296e-08 0.00021 4.0420123681524294e-08 0 4.04201236815243e-08 0 4.04301236815243e-08 0.00021 4.04401236815243e-08 0 4.0440123681524304e-08 0 4.04501236815243e-08 0.00021 4.04601236815243e-08 0 4.047097272548815e-08 0 4.048097272548815e-08 0.00021 4.0490972725488146e-08 0 4.049097272548815e-08 0 4.050097272548815e-08 0.00021 4.051097272548815e-08 0 4.0533361301444424e-08 0 4.054336130144442e-08 0.00021 4.055336130144442e-08 0 4.0553361301444426e-08 0 4.0563361301444424e-08 0.00021 4.057336130144442e-08 0 4.059148991467662e-08 0 4.0601489914676616e-08 0.00021 4.0611489914676614e-08 0 4.061148991467662e-08 0 4.062148991467662e-08 0.00021 4.0631489914676617e-08 0 4.063148991467662e-08 0 4.064148991467662e-08 0.00021 4.065148991467662e-08 0 4.0651489914676626e-08 0 4.0661489914676624e-08 0.00021 4.067148991467662e-08 0 4.067148991467663e-08 0 4.068148991467663e-08 0.00021 4.0691489914676625e-08 0 4.071286981769656e-08 0 4.072286981769656e-08 0.00021 4.0732869817696556e-08 0 4.07513941069079e-08 0 4.0761394106907896e-08 0.00021 4.0771394106907894e-08 0 4.07713941069079e-08 0 4.07813941069079e-08 0.00021 4.07913941069079e-08 0 4.088825909061887e-08 0 4.089825909061887e-08 0.00021 4.0908259090618865e-08 0 4.090825909061887e-08 0 4.091825909061887e-08 0.00021 4.092825909061887e-08 0 4.093354268665396e-08 0 4.094354268665396e-08 0.00021 4.095354268665396e-08 0 4.0957502545668003e-08 0 4.0967502545668e-08 0.00021 4.0977502545668e-08 0 4.09789725335955e-08 0 4.09889725335955e-08 0.00021 4.09989725335955e-08 0 4.107770505720209e-08 0 4.1087705057202086e-08 0.00021 4.1097705057202084e-08 0 4.109770505720209e-08 0 4.110770505720209e-08 0.00021 4.111770505720209e-08 0 4.112972591775735e-08 0 4.113972591775735e-08 0.00021 4.114972591775735e-08 0 4.11514591105891e-08 0 4.1161459110589096e-08 0.00021 4.1171459110589094e-08 0 4.117219393315099e-08 0 4.118219393315099e-08 0.00021 4.119219393315099e-08 0 4.1213899065175445e-08 0 4.122389906517544e-08 0.00021 4.123389906517544e-08 0 4.123836203794364e-08 0 4.124836203794364e-08 0.00021 4.1258362037943636e-08 0 4.125836203794364e-08 0 4.126836203794364e-08 0.00021 4.127836203794364e-08 0 4.1278362037943645e-08 0 4.1288362037943643e-08 0.00021 4.129836203794364e-08 0 4.129836203794365e-08 0 4.1308362037943646e-08 0.00021 4.1318362037943644e-08 0 4.1355215512662444e-08 0 4.136521551266244e-08 0.00021 4.137521551266244e-08 0 4.137711257382847e-08 0 4.138711257382847e-08 0.00021 4.1397112573828465e-08 0 4.140135350510936e-08 0 4.141135350510936e-08 0.00021 4.142135350510936e-08 0 4.1421353505109365e-08 0 4.143135350510936e-08 0.00021 4.144135350510936e-08 0 4.144135350510937e-08 0 4.1451353505109366e-08 0.00021 4.1461353505109364e-08 0 4.1498814643079914e-08 0 4.150881464307991e-08 0.00021 4.151881464307991e-08 0 4.1525291854489146e-08 0 4.1535291854489145e-08 0.00021 4.154529185448914e-08 0 4.161031327767403e-08 0 4.1620313277674025e-08 0.00021 4.163031327767402e-08 0 4.163031327767403e-08 0 4.164031327767403e-08 0.00021 4.1650313277674026e-08 0 4.165031327767403e-08 0 4.166031327767403e-08 0.00021 4.167031327767403e-08 0 4.1670313277674035e-08 0 4.1680313277674034e-08 0.00021 4.169031327767403e-08 0 4.172726915802957e-08 0 4.173726915802957e-08 0.00021 4.174726915802957e-08 0 4.1747269158029573e-08 0 4.175726915802957e-08 0.00021 4.176726915802957e-08 0 4.1854886363272695e-08 0 4.186488636327269e-08 0.00021 4.187488636327269e-08 0 4.187624840361382e-08 0 4.1886248403613815e-08 0.00021 4.189624840361381e-08 0 4.19169724497705e-08 0 4.19269724497705e-08 0.00021 4.1936972449770496e-08 0 4.19369724497705e-08 0 4.19469724497705e-08 0.00021 4.19569724497705e-08 0 4.1956972449770505e-08 0 4.1966972449770504e-08 0.00021 4.19769724497705e-08 0 4.203239296237046e-08 0 4.204239296237046e-08 0.00021 4.2052392962370457e-08 0 4.207739752038891e-08 0 4.208739752038891e-08 0.00021 4.2097397520388906e-08 0 4.209739752038891e-08 0 4.210739752038891e-08 0.00021 4.211739752038891e-08 0 4.2117397520388915e-08 0 4.2127397520388913e-08 0.00021 4.213739752038891e-08 0 4.213739752038892e-08 0 4.2147397520388916e-08 0.00021 4.2157397520388914e-08 0 4.215739752038892e-08 0 4.216739752038892e-08 0.00021 4.217739752038892e-08 0 4.221103785934238e-08 0 4.222103785934238e-08 0.00021 4.223103785934238e-08 0 4.2231037859342385e-08 0 4.2241037859342383e-08 0.00021 4.225103785934238e-08 0 4.225103785934239e-08 0 4.2261037859342386e-08 0.00021 4.2271037859342384e-08 0 4.227103785934239e-08 0 4.228103785934239e-08 0.00021 4.229103785934239e-08 0 4.2291037859342394e-08 0 4.230103785934239e-08 0.00021 4.231103785934239e-08 0 4.2311037859342397e-08 0 4.2321037859342395e-08 0.00021 4.233103785934239e-08 0 4.23310378593424e-08 0 4.23410378593424e-08 0.00021 4.2351037859342396e-08 0 4.235949798487662e-08 0 4.236949798487662e-08 0.00021 4.2379497984876616e-08 0 4.2407399329273995e-08 0 4.241739932927399e-08 0.00021 4.242739932927399e-08 0 4.24278632773906e-08 0 4.2437863277390597e-08 0.00021 4.2447863277390595e-08 0 4.24478632773906e-08 0 4.24578632773906e-08 0.00021 4.24678632773906e-08 0 4.2467863277390604e-08 0 4.24778632773906e-08 0.00021 4.24878632773906e-08 0 4.248786327739061e-08 0 4.2497863277390605e-08 0.00021 4.25078632773906e-08 0 4.250786327739061e-08 0 4.251786327739061e-08 0.00021 4.2527863277390606e-08 0 4.252786327739061e-08 0 4.253786327739061e-08 0.00021 4.254786327739061e-08 0 4.2547863277390615e-08 0 4.2557863277390614e-08 0.00021 4.256786327739061e-08 0 4.256786327739062e-08 0 4.2577863277390616e-08 0.00021 4.2587863277390614e-08 0 4.258786327739062e-08 0 4.259786327739062e-08 0.00021 4.260786327739062e-08 0 4.2607863277390624e-08 0 4.261786327739062e-08 0.00021 4.262786327739062e-08 0 4.262786327739063e-08 0 4.2637863277390625e-08 0.00021 4.264786327739062e-08 0 4.265934000423758e-08 0 4.266934000423758e-08 0.00021 4.267934000423758e-08 0 4.2679340004237584e-08 0 4.268934000423758e-08 0.00021 4.269934000423758e-08 0 4.2699340004237587e-08 0 4.2709340004237585e-08 0.00021 4.271934000423758e-08 0 4.271934000423759e-08 0 4.272934000423759e-08 0.00021 4.2739340004237586e-08 0 4.2751678852542335e-08 0 4.2761678852542333e-08 0.00021 4.277167885254233e-08 0 4.277167885254234e-08 0 4.2781678852542336e-08 0.00021 4.2791678852542334e-08 0 4.2856787086565675e-08 0 4.286678708656567e-08 0.00021 4.287678708656567e-08 0 4.2959172237222565e-08 0 4.296917223722256e-08 0.00021 4.297917223722256e-08 0 4.310288601724899e-08 0 4.3112886017248986e-08 0.00021 4.3122886017248984e-08 0 4.316498956234606e-08 0 4.317498956234606e-08 0.00021 4.318498956234606e-08 0 4.322951173202189e-08 0 4.323951173202189e-08 0.00021 4.324951173202189e-08 0 4.3249511732021894e-08 0 4.325951173202189e-08 0.00021 4.326951173202189e-08 0 4.3274181465957135e-08 0 4.328418146595713e-08 0.00021 4.329418146595713e-08 0 4.329418146595714e-08 0 4.3304181465957136e-08 0.00021 4.3314181465957134e-08 0 4.333638530343885e-08 0 4.334638530343885e-08 0.00021 4.335638530343885e-08 0 4.3356385303438854e-08 0 4.336638530343885e-08 0.00021 4.337638530343885e-08 0 4.3381623799618504e-08 0 4.33916237996185e-08 0.00021 4.34016237996185e-08 0 4.340360421757928e-08 0 4.341360421757928e-08 0.00021 4.342360421757928e-08 0 4.3423604217579284e-08 0 4.343360421757928e-08 0.00021 4.344360421757928e-08 0 4.344360421757929e-08 0 4.3453604217579285e-08 0.00021 4.346360421757928e-08 0 4.347694320088685e-08 0 4.348694320088685e-08 0.00021 4.349694320088685e-08 0 4.3496943200886854e-08 0 4.350694320088685e-08 0.00021 4.351694320088685e-08 0 4.3521292509305886e-08 0 4.3531292509305885e-08 0.00021 4.354129250930588e-08 0 4.355634046491881e-08 0 4.3566340464918806e-08 0.00021 4.3576340464918804e-08 0 4.357634046491881e-08 0 4.358634046491881e-08 0.00021 4.359634046491881e-08 0 4.3725943908687445e-08 0 4.3735943908687444e-08 0.00021 4.374594390868744e-08 0 4.374594390868745e-08 0 4.3755943908687446e-08 0.00021 4.3765943908687444e-08 0 4.376594390868745e-08 0 4.377594390868745e-08 0.00021 4.378594390868745e-08 0 4.3785943908687454e-08 0 4.379594390868745e-08 0.00021 4.380594390868745e-08 0 4.382032992100981e-08 0 4.3830329921009806e-08 0.00021 4.3840329921009804e-08 0 4.390315632890572e-08 0 4.391315632890572e-08 0.00021 4.392315632890572e-08 0 4.3923156328905725e-08 0 4.393315632890572e-08 0.00021 4.394315632890572e-08 0 4.394315632890573e-08 0 4.3953156328905726e-08 0.00021 4.3963156328905724e-08 0 4.396407374596693e-08 0 4.397407374596693e-08 0.00021 4.398407374596693e-08 0 4.3984073745966934e-08 0 4.399407374596693e-08 0.00021 4.400407374596693e-08 0 4.4004073745966936e-08 0 4.4014073745966934e-08 0.00021 4.402407374596693e-08 0 4.403242060583071e-08 0 4.404242060583071e-08 0.00021 4.4052420605830705e-08 0 4.405242060583071e-08 0 4.406242060583071e-08 0.00021 4.407242060583071e-08 0 4.4081940825741674e-08 0 4.409194082574167e-08 0.00021 4.410194082574167e-08 0 4.4124874930230667e-08 0 4.4134874930230665e-08 0.00021 4.414487493023066e-08 0 4.4196680715643995e-08 0 4.420668071564399e-08 0.00021 4.421668071564399e-08 0 4.423831427097164e-08 0 4.424831427097164e-08 0.00021 4.4258314270971636e-08 0 4.427288527264922e-08 0 4.428288527264922e-08 0.00021 4.4292885272649217e-08 0 4.429288527264922e-08 0 4.430288527264922e-08 0.00021 4.431288527264922e-08 0 4.4312885272649226e-08 0 4.4322885272649224e-08 0.00021 4.433288527264922e-08 0 4.433288527264923e-08 0 4.434288527264923e-08 0.00021 4.4352885272649225e-08 0 4.435288527264923e-08 0 4.436288527264923e-08 0.00021 4.437288527264923e-08 0 4.4372885272649235e-08 0 4.438288527264923e-08 0.00021 4.439288527264923e-08 0 4.439288527264924e-08 0 4.4402885272649235e-08 0.00021 4.4412885272649234e-08 0 4.441288527264924e-08 0 4.442288527264924e-08 0.00021 4.4432885272649236e-08 0 4.445427506102885e-08 0 4.446427506102885e-08 0.00021 4.4474275061028846e-08 0 4.4516383210922764e-08 0 4.452638321092276e-08 0.00021 4.453638321092276e-08 0 4.453638321092277e-08 0 4.4546383210922765e-08 0.00021 4.455638321092276e-08 0 4.460598974937319e-08 0 4.4615989749373186e-08 0.00021 4.4625989749373184e-08 0 4.466287276112772e-08 0 4.467287276112772e-08 0.00021 4.4682872761127715e-08 0 4.468334329527093e-08 0 4.469334329527093e-08 0.00021 4.470334329527093e-08 0 4.4703343295270934e-08 0 4.471334329527093e-08 0.00021 4.472334329527093e-08 0 4.472545665249862e-08 0 4.473545665249862e-08 0.00021 4.474545665249862e-08 0 4.4745456652498624e-08 0 4.475545665249862e-08 0.00021 4.476545665249862e-08 0 4.4765456652498626e-08 0 4.4775456652498625e-08 0.00021 4.478545665249862e-08 0 4.478545665249863e-08 0 4.479545665249863e-08 0.00021 4.4805456652498625e-08 0 4.480545665249863e-08 0 4.481545665249863e-08 0.00021 4.482545665249863e-08 0 4.4825456652498635e-08 0 4.483545665249863e-08 0.00021 4.484545665249863e-08 0 4.484545665249864e-08 0 4.4855456652498636e-08 0.00021 4.4865456652498634e-08 0 4.486545665249864e-08 0 4.487545665249864e-08 0.00021 4.488545665249864e-08 0 4.4885456652498643e-08 0 4.489545665249864e-08 0.00021 4.490545665249864e-08 0 4.4905456652498646e-08 0 4.4915456652498644e-08 0.00021 4.492545665249864e-08 0 4.492545665249865e-08 0 4.493545665249865e-08 0.00021 4.4945456652498645e-08 0 4.494545665249865e-08 0 4.495545665249865e-08 0.00021 4.496545665249865e-08 0 4.4965456652498655e-08 0 4.497545665249865e-08 0.00021 4.498545665249865e-08 0 4.498545665249866e-08 0 4.4995456652498656e-08 0.00021 4.5005456652498654e-08 0 4.500545665249866e-08 0 4.501545665249866e-08 0.00021 4.5025456652498657e-08 0 4.502545665249866e-08 0 4.503545665249866e-08 0.00021 4.504545665249866e-08 0 4.5045456652498666e-08 0 4.5055456652498664e-08 0.00021 4.506545665249866e-08 0 4.506545665249867e-08 0 4.507545665249867e-08 0.00021 4.5085456652498665e-08 0 4.508545665249867e-08 0 4.509545665249867e-08 0.00021 4.510545665249867e-08 0 4.5105456652498674e-08 0 4.511545665249867e-08 0.00021 4.512545665249867e-08 0 4.512545665249868e-08 0 4.5135456652498675e-08 0.00021 4.5145456652498673e-08 0 4.514545665249868e-08 0 4.515545665249868e-08 0.00021 4.5165456652498676e-08 0 4.516545665249868e-08 0 4.517545665249868e-08 0.00021 4.518545665249868e-08 0 4.5185456652498686e-08 0 4.5195456652498684e-08 0.00021 4.520545665249868e-08 0 4.520545665249869e-08 0 4.5215456652498687e-08 0.00021 4.5225456652498685e-08 0 4.5273700165076884e-08 0 4.528370016507688e-08 0.00021 4.529370016507688e-08 0 4.529370016507689e-08 0 4.5303700165076885e-08 0.00021 4.531370016507688e-08 0 4.531370016507689e-08 0 4.532370016507689e-08 0.00021 4.5333700165076886e-08 0 4.533370016507689e-08 0 4.534370016507689e-08 0.00021 4.535370016507689e-08 0 4.5353700165076895e-08 0 4.536370016507689e-08 0.00021 4.537370016507689e-08 0 4.53737001650769e-08 0 4.5383700165076896e-08 0.00021 4.5393700165076894e-08 0 4.53937001650769e-08 0 4.54037001650769e-08 0.00021 4.54137001650769e-08 0 4.5413700165076904e-08 0 4.54237001650769e-08 0.00021 4.54337001650769e-08 0 4.5433700165076906e-08 0 4.5443700165076905e-08 0.00021 4.54537001650769e-08 0 4.545370016507691e-08 0 4.546370016507691e-08 0.00021 4.5473700165076906e-08 0 4.547370016507691e-08 0 4.548370016507691e-08 0.00021 4.549370016507691e-08 0 4.5493700165076915e-08 0 4.550370016507691e-08 0.00021 4.551370016507691e-08 0 4.551370016507692e-08 0 4.5523700165076916e-08 0.00021 4.5533700165076914e-08 0 4.555109390568505e-08 0 4.556109390568505e-08 0.00021 4.557109390568505e-08 0 4.568042063934571e-08 0 4.5690420639345705e-08 0.00021 4.5700420639345703e-08 0 4.570042063934571e-08 0 4.571042063934571e-08 0.00021 4.5720420639345706e-08 0 4.574183284499549e-08 0 4.5751832844995487e-08 0.00021 4.5761832844995485e-08 0 4.577288605515102e-08 0 4.578288605515102e-08 0.00021 4.579288605515102e-08 0 4.582216626737624e-08 0 4.5832166267376236e-08 0.00021 4.5842166267376234e-08 0 4.5845129235681156e-08 0 4.5855129235681155e-08 0.00021 4.586512923568115e-08 0 4.586512923568116e-08 0 4.587512923568116e-08 0.00021 4.5885129235681155e-08 0 4.5914866601609255e-08 0 4.592486660160925e-08 0.00021 4.593486660160925e-08 0 4.6044603785067176e-08 0 4.6054603785067174e-08 0.00021 4.606460378506717e-08 0 4.60808002540242e-08 0 4.6090800254024196e-08 0.00021 4.6100800254024194e-08 0 4.614417011012085e-08 0 4.6154170110120846e-08 0.00021 4.6164170110120845e-08 0 4.616417011012085e-08 0 4.617417011012085e-08 0.00021 4.618417011012085e-08 0 4.6184170110120854e-08 0 4.619417011012085e-08 0.00021 4.620417011012085e-08 0 4.620417011012086e-08 0 4.6214170110120855e-08 0.00021 4.622417011012085e-08 0 4.625267640310738e-08 0 4.626267640310738e-08 0.00021 4.6272676403107376e-08 0 4.627267640310738e-08 0 4.628267640310738e-08 0.00021 4.629267640310738e-08 0 4.6292676403107386e-08 0 4.6302676403107384e-08 0.00021 4.631267640310738e-08 0 4.631267640310739e-08 0 4.632267640310739e-08 0.00021 4.6332676403107385e-08 0 4.633267640310739e-08 0 4.634267640310739e-08 0.00021 4.635267640310739e-08 0 4.6369431473448555e-08 0 4.637943147344855e-08 0.00021 4.638943147344855e-08 0 4.638943147344856e-08 0 4.6399431473448556e-08 0.00021 4.6409431473448554e-08 0 4.646243452041097e-08 0 4.647243452041097e-08 0.00021 4.6482434520410966e-08 0 4.648243452041097e-08 0 4.649243452041097e-08 0.00021 4.650243452041097e-08 0 4.6502434520410976e-08 0 4.6512434520410974e-08 0.00021 4.652243452041097e-08 0 4.655561603608947e-08 0 4.6565616036089465e-08 0.00021 4.657561603608946e-08 0 4.658816576512397e-08 0 4.659816576512397e-08 0.00021 4.660816576512397e-08 0 4.678979798034647e-08 0 4.679979798034647e-08 0.00021 4.680979798034647e-08 0 4.6857065713215153e-08 0 4.686706571321515e-08 0.00021 4.687706571321515e-08 0 4.689743223285123e-08 0 4.6907432232851226e-08 0.00021 4.6917432232851225e-08 0 4.691743223285123e-08 0 4.692743223285123e-08 0.00021 4.693743223285123e-08 0 4.6937432232851234e-08 0 4.694743223285123e-08 0.00021 4.695743223285123e-08 0 4.698473766337963e-08 0 4.699473766337963e-08 0.00021 4.700473766337963e-08 0 4.7004737663379636e-08 0 4.7014737663379634e-08 0.00021 4.702473766337963e-08 0 4.702473766337964e-08 0 4.703473766337964e-08 0.00021 4.7044737663379635e-08 0 4.707940405596348e-08 0 4.7089404055963475e-08 0.00021 4.7099404055963474e-08 0 4.7133265582485286e-08 0 4.7143265582485284e-08 0.00021 4.715326558248528e-08 0 4.722191844296034e-08 0 4.7231918442960336e-08 0.00021 4.7241918442960334e-08 0 4.73185447857419e-08 0 4.73285447857419e-08 0.00021 4.73385447857419e-08 0 4.734969137642249e-08 0 4.7359691376422487e-08 0.00021 4.7369691376422485e-08 0 4.741413908470864e-08 0 4.742413908470864e-08 0.00021 4.7434139084708636e-08 0 4.76025699215661e-08 0 4.76125699215661e-08 0.00021 4.7622569921566097e-08 0 4.76225699215661e-08 0 4.76325699215661e-08 0.00021 4.76425699215661e-08 0 4.7642569921566106e-08 0 4.7652569921566104e-08 0.00021 4.76625699215661e-08 0 4.766256992156611e-08 0 4.767256992156611e-08 0.00021 4.7682569921566105e-08 0 4.768256992156611e-08 0 4.769256992156611e-08 0.00021 4.770256992156611e-08 0 4.771058417899543e-08 0 4.7720584178995427e-08 0.00021 4.7730584178995425e-08 0 4.773058417899543e-08 0 4.774058417899543e-08 0.00021 4.775058417899543e-08 0 4.7750584178995434e-08 0 4.776058417899543e-08 0.00021 4.777058417899543e-08 0 4.790256576595326e-08 0 4.791256576595326e-08 0.00021 4.7922565765953255e-08 0 4.792256576595326e-08 0 4.793256576595326e-08 0.00021 4.794256576595326e-08 0 4.7942565765953264e-08 0 4.795256576595326e-08 0.00021 4.796256576595326e-08 0 4.7992226419845535e-08 0 4.800222641984553e-08 0.00021 4.801222641984553e-08 0 4.810438347865279e-08 0 4.811438347865279e-08 0.00021 4.812438347865279e-08 0 4.8127754499485436e-08 0 4.8137754499485434e-08 0.00021 4.814775449948543e-08 0 4.814899245324225e-08 0 4.8158992453242247e-08 0.00021 4.8168992453242245e-08 0 4.816899245324225e-08 0 4.817899245324225e-08 0.00021 4.818899245324225e-08 0 4.819027422005923e-08 0 4.820027422005923e-08 0.00021 4.821027422005923e-08 0 4.8212939353678084e-08 0 4.822293935367808e-08 0.00021 4.823293935367808e-08 0 4.823293935367809e-08 0 4.8242939353678085e-08 0.00021 4.8252939353678083e-08 0 4.828488091093403e-08 0 4.829488091093403e-08 0.00021 4.830488091093403e-08 0 4.832681835359992e-08 0 4.833681835359992e-08 0.00021 4.834681835359992e-08 0 4.836633080003873e-08 0 4.837633080003873e-08 0.00021 4.8386330800038725e-08 0 4.838633080003873e-08 0 4.839633080003873e-08 0.00021 4.840633080003873e-08 0 4.8424503753461676e-08 0 4.8434503753461675e-08 0.00021 4.844450375346167e-08 0 4.866699586653102e-08 0 4.867699586653102e-08 0.00021 4.8686995866531017e-08 0 4.868699586653102e-08 0 4.869699586653102e-08 0.00021 4.870699586653102e-08 0 4.875302634698846e-08 0 4.8763026346988456e-08 0.00021 4.8773026346988454e-08 0 4.877302634698846e-08 0 4.878302634698846e-08 0.00021 4.879302634698846e-08 0 4.8793026346988464e-08 0 4.880302634698846e-08 0.00021 4.881302634698846e-08 0 4.8813026346988466e-08 0 4.8823026346988464e-08 0.00021 4.883302634698846e-08 0 4.886137703084648e-08 0 4.887137703084648e-08 0.00021 4.8881377030846475e-08 0 4.888137703084648e-08 0 4.889137703084648e-08 0.00021 4.890137703084648e-08 0 4.8901377030846485e-08 0 4.891137703084648e-08 0.00021 4.892137703084648e-08 0 4.892137703084649e-08 0 4.8931377030846486e-08 0.00021 4.8941377030846484e-08 0 4.894137703084649e-08 0 4.895137703084649e-08 0.00021 4.896137703084649e-08 0 4.897272327752906e-08 0 4.898272327752906e-08 0.00021 4.8992723277529056e-08 0 4.899272327752906e-08 0 4.900272327752906e-08 0.00021 4.901272327752906e-08 0 4.9098496739956065e-08 0 4.910849673995606e-08 0.00021 4.911849673995606e-08 0 4.911849673995607e-08 0 4.9128496739956066e-08 0.00021 4.9138496739956064e-08 0 4.913849673995607e-08 0 4.914849673995607e-08 0.00021 4.9158496739956067e-08 0 4.915849673995607e-08 0 4.916849673995607e-08 0.00021 4.917849673995607e-08 0 4.9178496739956076e-08 0 4.9188496739956074e-08 0.00021 4.919849673995607e-08 0 4.919849673995608e-08 0 4.920849673995608e-08 0.00021 4.9218496739956075e-08 0 4.921849673995608e-08 0 4.922849673995608e-08 0.00021 4.923849673995608e-08 0 4.9238496739956084e-08 0 4.924849673995608e-08 0.00021 4.925849673995608e-08 0 4.925849673995609e-08 0 4.9268496739956085e-08 0.00021 4.9278496739956083e-08 0 4.927849673995609e-08 0 4.928849673995609e-08 0.00021 4.9298496739956086e-08 0 4.936294162526123e-08 0 4.9372941625261225e-08 0.00021 4.938294162526122e-08 0 4.938294162526123e-08 0 4.939294162526123e-08 0.00021 4.9402941625261226e-08 0 4.940294162526123e-08 0 4.941294162526123e-08 0.00021 4.942294162526123e-08 0 4.9422941625261235e-08 0 4.9432941625261234e-08 0.00021 4.944294162526123e-08 0 4.9490912058756394e-08 0 4.950091205875639e-08 0.00021 4.951091205875639e-08 0 4.9510912058756397e-08 0 4.9520912058756395e-08 0.00021 4.953091205875639e-08 0 4.95309120587564e-08 0 4.95409120587564e-08 0.00021 4.9550912058756396e-08 0 4.95509120587564e-08 0 4.95609120587564e-08 0.00021 4.95709120587564e-08 0 4.9570912058756405e-08 0 4.95809120587564e-08 0.00021 4.95909120587564e-08 0 4.959091205875641e-08 0 4.9600912058756406e-08 0.00021 4.9610912058756404e-08 0 4.961091205875641e-08 0 4.962091205875641e-08 0.00021 4.963091205875641e-08 0 4.9630912058756414e-08 0 4.964091205875641e-08 0.00021 4.965091205875641e-08 0 4.9650912058756416e-08 0 4.9660912058756415e-08 0.00021 4.967091205875641e-08 0 4.967091205875642e-08 0 4.968091205875642e-08 0.00021 4.9690912058756416e-08 0 4.969091205875642e-08 0 4.970091205875642e-08 0.00021 4.971091205875642e-08 0 4.9710912058756425e-08 0 4.972091205875642e-08 0.00021 4.973091205875642e-08 0 4.973741571512849e-08 0 4.974741571512849e-08 0.00021 4.975741571512849e-08 0 4.9761543939853824e-08 0 4.977154393985382e-08 0.00021 4.978154393985382e-08 0 4.978154393985383e-08 0 4.9791543939853825e-08 0.00021 4.9801543939853823e-08 0 4.980154393985383e-08 0 4.981154393985383e-08 0.00021 4.9821543939853826e-08 0 4.982154393985383e-08 0 4.983154393985383e-08 0.00021 4.984154393985383e-08 0 4.9841543939853836e-08 0 4.9851543939853834e-08 0.00021 4.986154393985383e-08 0 4.992709683399392e-08 0 4.993709683399392e-08 0.00021 4.9947096833993915e-08 0 4.994709683399392e-08 0 4.995709683399392e-08 0.00021 4.996709683399392e-08 0 5.001369154548218e-08 0 5.002369154548218e-08 0.00021 5.003369154548218e-08 0 5.007015898605897e-08 0 5.0080158986058966e-08 0.00021 5.0090158986058964e-08 0 5.0093253643860834e-08 0 5.010325364386083e-08 0.00021 5.011325364386083e-08 0 5.0159570846156304e-08 0 5.01695708461563e-08 0.00021 5.01795708461563e-08 0 5.0179570846156306e-08 0 5.0189570846156305e-08 0.00021 5.01995708461563e-08 0 5.019957084615631e-08 0 5.020957084615631e-08 0.00021 5.0219570846156305e-08 0 5.021957084615631e-08 0 5.022957084615631e-08 0.00021 5.023957084615631e-08 0 5.0239570846156315e-08 0 5.024957084615631e-08 0.00021 5.025957084615631e-08 0 5.025957084615632e-08 0 5.0269570846156316e-08 0.00021 5.0279570846156314e-08 0 5.0359816976166406e-08 0 5.0369816976166404e-08 0.00021 5.03798169761664e-08 0 5.039371024405851e-08 0 5.040371024405851e-08 0.00021 5.0413710244058506e-08 0 5.0434910061669675e-08 0 5.0444910061669674e-08 0.00021 5.045491006166967e-08 0 5.045491006166968e-08 0 5.0464910061669676e-08 0.00021 5.0474910061669674e-08 0 5.0548249491348024e-08 0 5.055824949134802e-08 0.00021 5.056824949134802e-08 0 5.0568249491348027e-08 0 5.0578249491348025e-08 0.00021 5.058824949134802e-08 0 5.0729647639103116e-08 0 5.0739647639103114e-08 0.00021 5.074964763910311e-08 0 5.074964763910312e-08 0 5.0759647639103117e-08 0.00021 5.0769647639103115e-08 0 5.076964763910312e-08 0 5.077964763910312e-08 0.00021 5.078964763910312e-08 0 5.0789647639103124e-08 0 5.079964763910312e-08 0.00021 5.080964763910312e-08 0 5.080964763910313e-08 0 5.0819647639103125e-08 0.00021 5.082964763910312e-08 0 5.082964763910313e-08 0 5.083964763910313e-08 0.00021 5.0849647639103126e-08 0 5.084964763910313e-08 0 5.085964763910313e-08 0.00021 5.086964763910313e-08 0 5.0869647639103135e-08 0 5.0879647639103134e-08 0.00021 5.088964763910313e-08 0 5.088964763910314e-08 0 5.0899647639103136e-08 0.00021 5.0909647639103134e-08 0 5.090964763910314e-08 0 5.091964763910314e-08 0.00021 5.092964763910314e-08 0 5.0929647639103144e-08 0 5.093964763910314e-08 0.00021 5.094964763910314e-08 0 5.094964763910315e-08 0 5.0959647639103145e-08 0.00021 5.096964763910314e-08 0 5.096964763910315e-08 0 5.097964763910315e-08 0.00021 5.0989647639103146e-08 0 5.098964763910315e-08 0 5.099964763910315e-08 0.00021 5.100964763910315e-08 0 5.1009647639103155e-08 0 5.1019647639103153e-08 0.00021 5.102964763910315e-08 0 5.102964763910316e-08 0 5.1039647639103156e-08 0.00021 5.1049647639103154e-08 0 5.104964763910316e-08 0 5.105964763910316e-08 0.00021 5.106964763910316e-08 0 5.1070306888587184e-08 0 5.108030688858718e-08 0.00021 5.109030688858718e-08 0 5.109030688858719e-08 0 5.1100306888587185e-08 0.00021 5.111030688858718e-08 0 5.1144126792068726e-08 0 5.1154126792068724e-08 0.00021 5.116412679206872e-08 0 5.116412679206873e-08 0 5.117412679206873e-08 0.00021 5.1184126792068725e-08 0 5.1202629989223074e-08 0 5.121262998922307e-08 0.00021 5.122262998922307e-08 0 5.122768309976133e-08 0 5.123768309976133e-08 0.00021 5.124768309976133e-08 0 5.1247683099761335e-08 0 5.125768309976133e-08 0.00021 5.126768309976133e-08 0 5.126768309976134e-08 0 5.1277683099761336e-08 0.00021 5.1287683099761334e-08 0 5.128768309976134e-08 0 5.129768309976134e-08 0.00021 5.130768309976134e-08 0 5.1307683099761344e-08 0 5.131768309976134e-08 0.00021 5.132768309976134e-08 0 5.1327683099761346e-08 0 5.1337683099761345e-08 0.00021 5.134768309976134e-08 0 5.1378961532749224e-08 0 5.138896153274922e-08 0.00021 5.139896153274922e-08 0 5.1402181341854246e-08 0 5.1412181341854244e-08 0.00021 5.142218134185424e-08 0 5.151718570116381e-08 0 5.152718570116381e-08 0.00021 5.1537185701163805e-08 0 5.153718570116381e-08 0 5.154718570116381e-08 0.00021 5.155718570116381e-08 0 5.1557185701163814e-08 0 5.156718570116381e-08 0.00021 5.157718570116381e-08 0 5.159264160853147e-08 0 5.160264160853147e-08 0.00021 5.1612641608531467e-08 0 5.161264160853147e-08 0 5.162264160853147e-08 0.00021 5.163264160853147e-08 0 5.164437339060786e-08 0 5.165437339060786e-08 0.00021 5.1664373390607856e-08 0 5.166437339060786e-08 0 5.167437339060786e-08 0.00021 5.168437339060786e-08 0 5.1684373390607865e-08 0 5.169437339060786e-08 0.00021 5.170437339060786e-08 0 5.170437339060787e-08 0 5.1714373390607866e-08 0.00021 5.1724373390607864e-08 0 5.1768507409901514e-08 0 5.177850740990151e-08 0.00021 5.178850740990151e-08 0 5.178850740990152e-08 0 5.1798507409901515e-08 0.00021 5.1808507409901513e-08 0 5.180850740990152e-08 0 5.181850740990152e-08 0.00021 5.1828507409901516e-08 0 5.190384900910215e-08 0 5.191384900910215e-08 0.00021 5.192384900910215e-08 0 5.1923849009102154e-08 0 5.193384900910215e-08 0.00021 5.194384900910215e-08 0 5.1943849009102156e-08 0 5.1953849009102155e-08 0.00021 5.196384900910215e-08 0 5.196384900910216e-08 0 5.197384900910216e-08 0.00021 5.1983849009102155e-08 0 5.198384900910216e-08 0 5.199384900910216e-08 0.00021 5.200384900910216e-08 0 5.2062798225216515e-08 0 5.207279822521651e-08 0.00021 5.208279822521651e-08 0 5.208279822521652e-08 0 5.2092798225216515e-08 0.00021 5.2102798225216514e-08 0 5.210279822521652e-08 0 5.211279822521652e-08 0.00021 5.2122798225216516e-08 0 5.2166326686218994e-08 0 5.217632668621899e-08 0.00021 5.218632668621899e-08 0 5.227676889169298e-08 0 5.228676889169298e-08 0.00021 5.229676889169298e-08 0 5.233650192422184e-08 0 5.234650192422184e-08 0.00021 5.2356501924221836e-08 0 5.2357232039237085e-08 0 5.2367232039237084e-08 0.00021 5.237723203923708e-08 0 5.244160131344234e-08 0 5.245160131344234e-08 0.00021 5.246160131344234e-08 0 5.2461601313442344e-08 0 5.247160131344234e-08 0.00021 5.248160131344234e-08 0 5.248160131344235e-08 0 5.2491601313442345e-08 0.00021 5.250160131344234e-08 0 5.250160131344235e-08 0 5.251160131344235e-08 0.00021 5.2521601313442346e-08 0 5.252160131344235e-08 0 5.253160131344235e-08 0.00021 5.254160131344235e-08 0 5.255702435208709e-08 0 5.256702435208709e-08 0.00021 5.257702435208709e-08 0 5.260548089842138e-08 0 5.2615480898421377e-08 0.00021 5.2625480898421375e-08 0 5.262548089842138e-08 0 5.263548089842138e-08 0.00021 5.264548089842138e-08 0 5.2645480898421384e-08 0 5.265548089842138e-08 0.00021 5.266548089842138e-08 0 5.266548089842139e-08 0 5.2675480898421385e-08 0.00021 5.268548089842138e-08 0 5.269070525925637e-08 0 5.270070525925637e-08 0.00021 5.271070525925637e-08 0 5.272204873057275e-08 0 5.273204873057275e-08 0.00021 5.2742048730572745e-08 0 5.275701667367713e-08 0 5.276701667367713e-08 0.00021 5.277701667367713e-08 0 5.280699484755337e-08 0 5.281699484755337e-08 0.00021 5.282699484755337e-08 0 5.2826994847553375e-08 0 5.283699484755337e-08 0.00021 5.284699484755337e-08 0 5.290652289451627e-08 0 5.291652289451627e-08 0.00021 5.2926522894516266e-08 0 5.297524197741803e-08 0 5.298524197741803e-08 0.00021 5.2995241977418026e-08 0 5.299524197741803e-08 0 5.300524197741803e-08 0.00021 5.301524197741803e-08 0 5.302273810641071e-08 0 5.303273810641071e-08 0.00021 5.304273810641071e-08 0 5.307114943517056e-08 0 5.308114943517056e-08 0.00021 5.3091149435170555e-08 0 5.309856319098207e-08 0 5.3108563190982066e-08 0.00021 5.3118563190982064e-08 0 5.3142165249001326e-08 0 5.3152165249001324e-08 0.00021 5.316216524900132e-08 0 5.316216524900133e-08 0 5.317216524900133e-08 0.00021 5.3182165249001325e-08 0 5.318216524900133e-08 0 5.319216524900133e-08 0.00021 5.320216524900133e-08 0 5.3202165249001334e-08 0 5.321216524900133e-08 0.00021 5.322216524900133e-08 0 5.322216524900134e-08 0 5.3232165249001335e-08 0.00021 5.3242165249001333e-08 0 5.324216524900134e-08 0 5.325216524900134e-08 0.00021 5.3262165249001336e-08 0 5.326216524900134e-08 0 5.327216524900134e-08 0.00021 5.328216524900134e-08 0 5.3282165249001346e-08 0 5.3292165249001344e-08 0.00021 5.330216524900134e-08 0 5.330216524900135e-08 0 5.3312165249001347e-08 0.00021 5.3322165249001345e-08 0 5.3331833510054925e-08 0 5.334183351005492e-08 0.00021 5.335183351005492e-08 0 5.337416848541885e-08 0 5.338416848541885e-08 0.00021 5.339416848541885e-08 0 5.3394168485418855e-08 0 5.340416848541885e-08 0.00021 5.341416848541885e-08 0 5.341416848541886e-08 0 5.3424168485418855e-08 0.00021 5.3434168485418854e-08 0 5.343416848541886e-08 0 5.344416848541886e-08 0.00021 5.3454168485418856e-08 0 5.3565086909093573e-08 0 5.357508690909357e-08 0.00021 5.358508690909357e-08 0 5.359905064840312e-08 0 5.3609050648403115e-08 0.00021 5.3619050648403114e-08 0 5.363566053898451e-08 0 5.364566053898451e-08 0.00021 5.3655660538984506e-08 0 5.3675363401125815e-08 0 5.3685363401125813e-08 0.00021 5.369536340112581e-08 0 5.372463514771563e-08 0 5.373463514771563e-08 0.00021 5.3744635147715626e-08 0 5.375929725348075e-08 0 5.3769297253480746e-08 0.00021 5.3779297253480744e-08 0 5.377929725348075e-08 0 5.378929725348075e-08 0.00021 5.379929725348075e-08 0 5.3799297253480753e-08 0 5.380929725348075e-08 0.00021 5.381929725348075e-08 0 5.38723587990635e-08 0 5.38823587990635e-08 0.00021 5.38923587990635e-08 0 5.3892358799063505e-08 0 5.39023587990635e-08 0.00021 5.39123587990635e-08 0 5.392624917177911e-08 0 5.3936249171779106e-08 0.00021 5.3946249171779104e-08 0 5.4027669901910865e-08 0 5.403766990191086e-08 0.00021 5.404766990191086e-08 0 5.404766990191087e-08 0 5.4057669901910866e-08 0.00021 5.4067669901910864e-08 0 5.4074418388977394e-08 0 5.408441838897739e-08 0.00021 5.409441838897739e-08 0 5.417736475841226e-08 0 5.4187364758412255e-08 0.00021 5.419736475841225e-08 0 5.4216375472002146e-08 0 5.4226375472002144e-08 0.00021 5.423637547200214e-08 0 5.426090252132027e-08 0 5.427090252132027e-08 0.00021 5.428090252132027e-08 0 5.4280902521320274e-08 0 5.429090252132027e-08 0.00021 5.430090252132027e-08 0 5.430090252132028e-08 0 5.4310902521320275e-08 0.00021 5.4320902521320273e-08 0 5.435801918061808e-08 0 5.436801918061808e-08 0.00021 5.437801918061808e-08 0 5.442057320474236e-08 0 5.443057320474236e-08 0.00021 5.444057320474236e-08 0 5.447206611956145e-08 0 5.4482066119561446e-08 0.00021 5.4492066119561444e-08 0 5.449206611956145e-08 0 5.450206611956145e-08 0.00021 5.4512066119561447e-08 0 5.4519492072391087e-08 0 5.4529492072391085e-08 0.00021 5.453949207239108e-08 0 5.455934657824477e-08 0 5.456934657824477e-08 0.00021 5.457934657824477e-08 0 5.4579346578244776e-08 0 5.4589346578244774e-08 0.00021 5.459934657824477e-08 0 5.459934657824478e-08 0 5.460934657824478e-08 0.00021 5.4619346578244775e-08 0 5.461934657824478e-08 0 5.462934657824478e-08 0.00021 5.463934657824478e-08 0 5.4639346578244784e-08 0 5.464934657824478e-08 0.00021 5.465934657824478e-08 0 5.465934657824479e-08 0 5.4669346578244785e-08 0.00021 5.4679346578244783e-08 0 5.467934657824479e-08 0 5.468934657824479e-08 0.00021 5.4699346578244786e-08 0 5.469934657824479e-08 0 5.470934657824479e-08 0.00021 5.471934657824479e-08 0 5.4719346578244796e-08 0 5.4729346578244794e-08 0.00021 5.473934657824479e-08 0 5.47393465782448e-08 0 5.4749346578244797e-08 0.00021 5.4759346578244795e-08 0 5.47593465782448e-08 0 5.47693465782448e-08 0.00021 5.47793465782448e-08 0 5.4779346578244804e-08 0 5.47893465782448e-08 0.00021 5.47993465782448e-08 0 5.479934657824481e-08 0 5.4809346578244805e-08 0.00021 5.48193465782448e-08 0 5.481934657824481e-08 0 5.482934657824481e-08 0.00021 5.4839346578244806e-08 0 5.483934657824481e-08 0 5.484934657824481e-08 0.00021 5.485934657824481e-08 0 5.4859346578244815e-08 0 5.4869346578244814e-08 0.00021 5.487934657824481e-08 0 5.489833015641033e-08 0 5.490833015641033e-08 0.00021 5.4918330156410326e-08 0 5.491833015641033e-08 0 5.492833015641033e-08 0.00021 5.493833015641033e-08 0 5.4944935653515905e-08 0 5.49549356535159e-08 0.00021 5.49649356535159e-08 0 5.4982244195353406e-08 0 5.4992244195353404e-08 0.00021 5.50022441953534e-08 0 5.500224419535341e-08 0 5.501224419535341e-08 0.00021 5.5022244195353405e-08 0 5.502224419535341e-08 0 5.503224419535341e-08 0.00021 5.504224419535341e-08 0 5.5042244195353415e-08 0 5.505224419535341e-08 0.00021 5.506224419535341e-08 0 5.506224419535342e-08 0 5.5072244195353416e-08 0.00021 5.5082244195353414e-08 0 5.508224419535342e-08 0 5.509224419535342e-08 0.00021 5.5102244195353417e-08 0 5.510224419535342e-08 0 5.511224419535342e-08 0.00021 5.512224419535342e-08 0 5.5122244195353426e-08 0 5.5132244195353424e-08 0.00021 5.514224419535342e-08 0 5.514224419535343e-08 0 5.515224419535343e-08 0.00021 5.5162244195353425e-08 0 5.516224419535343e-08 0 5.517224419535343e-08 0.00021 5.518224419535343e-08 0 5.519984205243497e-08 0 5.520984205243497e-08 0.00021 5.521984205243497e-08 0 5.5219842052434976e-08 0 5.5229842052434974e-08 0.00021 5.523984205243497e-08 0 5.523984205243498e-08 0 5.524984205243498e-08 0.00021 5.5259842052434975e-08 0 5.5281278505890533e-08 0 5.529127850589053e-08 0.00021 5.530127850589053e-08 0 5.539384036870722e-08 0 5.540384036870722e-08 0.00021 5.541384036870722e-08 0 5.541600986792578e-08 0 5.542600986792578e-08 0.00021 5.5436009867925776e-08 0 5.545834089016132e-08 0 5.546834089016132e-08 0.00021 5.5478340890161315e-08 0 5.550945083792383e-08 0 5.551945083792383e-08 0.00021 5.552945083792383e-08 0 5.554580054942089e-08 0 5.555580054942089e-08 0.00021 5.5565800549420885e-08 0 5.556806932776917e-08 0 5.557806932776917e-08 0.00021 5.5588069327769166e-08 0 5.563743055474483e-08 0 5.5647430554744826e-08 0.00021 5.5657430554744825e-08 0 5.565743055474483e-08 0 5.566743055474483e-08 0.00021 5.567743055474483e-08 0 5.56843567418732e-08 0 5.56943567418732e-08 0.00021 5.57043567418732e-08 0 5.5704356741873206e-08 0 5.5714356741873204e-08 0.00021 5.57243567418732e-08 0 5.575216792103942e-08 0 5.576216792103942e-08 0.00021 5.5772167921039415e-08 0 5.5788637730647475e-08 0 5.579863773064747e-08 0.00021 5.580863773064747e-08 0 5.580863773064748e-08 0 5.5818637730647476e-08 0.00021 5.5828637730647474e-08 0 5.587617837516829e-08 0 5.588617837516829e-08 0.00021 5.5896178375168286e-08 0 5.5911642785748317e-08 0 5.5921642785748315e-08 0.00021 5.593164278574831e-08 0 5.593164278574832e-08 0 5.594164278574832e-08 0.00021 5.5951642785748316e-08 0 5.597463602163e-08 0 5.5984636021629997e-08 0.00021 5.5994636021629995e-08 0 5.599463602163e-08 0 5.600463602163e-08 0.00021 5.601463602163e-08 0 5.6014636021630004e-08 0 5.602463602163e-08 0.00021 5.603463602163e-08 0 5.603662350667874e-08 0 5.604662350667874e-08 0.00021 5.605662350667874e-08 0 5.6082286075551406e-08 0 5.6092286075551404e-08 0.00021 5.61022860755514e-08 0 5.6207152325782375e-08 0 5.621715232578237e-08 0.00021 5.622715232578237e-08 0 5.6285152242334035e-08 0 5.629515224233403e-08 0.00021 5.630515224233403e-08 0 5.631704218960389e-08 0 5.632704218960389e-08 0.00021 5.633704218960389e-08 0 5.6337042189603895e-08 0 5.634704218960389e-08 0.00021 5.635704218960389e-08 0 5.643499597825938e-08 0 5.6444995978259376e-08 0.00021 5.6454995978259374e-08 0 5.645499597825938e-08 0 5.646499597825938e-08 0.00021 5.647499597825938e-08 0 5.6474995978259384e-08 0 5.648499597825938e-08 0.00021 5.649499597825938e-08 0 5.6494995978259387e-08 0 5.6504995978259385e-08 0.00021 5.651499597825938e-08 0 5.651499597825939e-08 0 5.652499597825939e-08 0.00021 5.6534995978259386e-08 0 5.653499597825939e-08 0 5.654499597825939e-08 0.00021 5.655499597825939e-08 0 5.656710741364724e-08 0 5.657710741364724e-08 0.00021 5.6587107413647236e-08 0 5.65876811122988e-08 0 5.65976811122988e-08 0.00021 5.6607681112298795e-08 0 5.6618150580471916e-08 0 5.6628150580471914e-08 0.00021 5.663815058047191e-08 0 5.663815058047192e-08 0 5.664815058047192e-08 0.00021 5.6658150580471915e-08 0 5.6677723292386344e-08 0 5.668772329238634e-08 0.00021 5.669772329238634e-08 0 5.669772329238635e-08 0 5.6707723292386345e-08 0.00021 5.671772329238634e-08 0 5.671772329238635e-08 0 5.672772329238635e-08 0.00021 5.6737723292386346e-08 0 5.673772329238635e-08 0 5.674772329238635e-08 0.00021 5.675772329238635e-08 0 5.6757723292386356e-08 0 5.6767723292386354e-08 0.00021 5.677772329238635e-08 0 5.677772329238636e-08 0 5.6787723292386357e-08 0.00021 5.6797723292386355e-08 0 5.6986788879035187e-08 0 5.6996788879035185e-08 0.00021 5.700678887903518e-08 0 5.701681010240341e-08 0 5.702681010240341e-08 0.00021 5.703681010240341e-08 0 5.7036810102403413e-08 0 5.704681010240341e-08 0.00021 5.705681010240341e-08 0 5.721332411877739e-08 0 5.7223324118777385e-08 0.00021 5.723332411877738e-08 0 5.7239045617799605e-08 0 5.72490456177996e-08 0.00021 5.72590456177996e-08 0 5.727618860770735e-08 0 5.728618860770735e-08 0.00021 5.729618860770735e-08 0 5.731507654181435e-08 0 5.732507654181435e-08 0.00021 5.733507654181435e-08 0 5.7393870202795916e-08 0 5.7403870202795914e-08 0.00021 5.741387020279591e-08 0 5.743932803383919e-08 0 5.744932803383919e-08 0.00021 5.745932803383919e-08 0 5.7459328033839195e-08 0 5.746932803383919e-08 0.00021 5.747932803383919e-08 0 5.74793280338392e-08 0 5.7489328033839196e-08 0.00021 5.7499328033839194e-08 0 5.74993280338392e-08 0 5.75093280338392e-08 0.00021 5.75193280338392e-08 0 5.7519328033839204e-08 0 5.75293280338392e-08 0.00021 5.75393280338392e-08 0 5.7630614117622057e-08 0 5.7640614117622055e-08 0.00021 5.765061411762205e-08 0 5.7734934361510134e-08 0 5.774493436151013e-08 0.00021 5.775493436151013e-08 0 5.776695375144389e-08 0 5.7776953751443886e-08 0.00021 5.7786953751443884e-08 0 5.778695375144389e-08 0 5.779695375144389e-08 0.00021 5.780695375144389e-08 0 5.7806953751443894e-08 0 5.781695375144389e-08 0.00021 5.782695375144389e-08 0 5.7826953751443897e-08 0 5.7836953751443895e-08 0.00021 5.784695375144389e-08 0 5.78469537514439e-08 0 5.78569537514439e-08 0.00021 5.7866953751443896e-08 0 5.794837149503977e-08 0 5.795837149503977e-08 0.00021 5.7968371495039766e-08 0 5.796837149503977e-08 0 5.797837149503977e-08 0.00021 5.798837149503977e-08 0 5.7998362209781385e-08 0 5.800836220978138e-08 0.00021 5.801836220978138e-08 0 5.806613139342128e-08 0 5.8076131393421276e-08 0.00021 5.8086131393421274e-08 0 5.8095883031610176e-08 0 5.8105883031610174e-08 0.00021 5.811588303161017e-08 0 5.811588303161018e-08 0 5.812588303161018e-08 0.00021 5.8135883031610175e-08 0 5.818648348892778e-08 0 5.819648348892778e-08 0.00021 5.8206483488927776e-08 0 5.822588894975299e-08 0 5.823588894975299e-08 0.00021 5.8245888949752985e-08 0 5.82663980721027e-08 0 5.82763980721027e-08 0.00021 5.82863980721027e-08 0 5.8286398072102705e-08 0 5.82963980721027e-08 0.00021 5.83063980721027e-08 0 5.830639807210271e-08 0 5.8316398072102706e-08 0.00021 5.8326398072102704e-08 0 5.832639807210271e-08 0 5.833639807210271e-08 0.00021 5.8346398072102706e-08 0 5.839808609642672e-08 0 5.840808609642672e-08 0.00021 5.8418086096426715e-08 0 5.852715591965375e-08 0 5.853715591965375e-08 0.00021 5.854715591965375e-08 0 5.8547155919653755e-08 0 5.855715591965375e-08 0.00021 5.856715591965375e-08 0 5.8688334238152435e-08 0 5.869833423815243e-08 0.00021 5.870833423815243e-08 0 5.870833423815244e-08 0 5.8718334238152436e-08 0.00021 5.8728334238152434e-08 0 5.872833423815244e-08 0 5.873833423815244e-08 0.00021 5.874833423815244e-08 0 5.877342671752904e-08 0 5.8783426717529036e-08 0.00021 5.8793426717529034e-08 0 5.879342671752904e-08 0 5.880342671752904e-08 0.00021 5.8813426717529036e-08 0 5.8828080307108254e-08 0 5.883808030710825e-08 0.00021 5.884808030710825e-08 0 5.884808030710826e-08 0 5.8858080307108255e-08 0.00021 5.886808030710825e-08 0 5.886808030710826e-08 0 5.887808030710826e-08 0.00021 5.8888080307108256e-08 0 5.894282794064684e-08 0 5.8952827940646836e-08 0.00021 5.8962827940646834e-08 0 5.896282794064684e-08 0 5.897282794064684e-08 0.00021 5.898282794064684e-08 0 5.899413553935099e-08 0 5.9004135539350985e-08 0.00021 5.9014135539350984e-08 0 5.901620604375458e-08 0 5.902620604375458e-08 0.00021 5.903620604375458e-08 0 5.9036206043754585e-08 0 5.904620604375458e-08 0.00021 5.905620604375458e-08 0 5.905620604375459e-08 0 5.9066206043754586e-08 0.00021 5.9076206043754584e-08 0 5.910840508971621e-08 0 5.911840508971621e-08 0.00021 5.9128405089716206e-08 0 5.913328357159029e-08 0 5.914328357159029e-08 0.00021 5.915328357159029e-08 0 5.9153962313886894e-08 0 5.916396231388689e-08 0.00021 5.917396231388689e-08 0 5.920076205134084e-08 0 5.921076205134084e-08 0.00021 5.922076205134084e-08 0 5.924532947467425e-08 0 5.9255329474674245e-08 0.00021 5.9265329474674243e-08 0 5.926532947467425e-08 0 5.927532947467425e-08 0.00021 5.9285329474674246e-08 0 5.928532947467425e-08 0 5.929532947467425e-08 0.00021 5.930532947467425e-08 0 5.9305329474674256e-08 0 5.9315329474674254e-08 0.00021 5.932532947467425e-08 0 5.937894507944049e-08 0 5.938894507944049e-08 0.00021 5.939894507944049e-08 0 5.940099044587577e-08 0 5.9410990445875766e-08 0.00021 5.9420990445875764e-08 0 5.962188455972521e-08 0 5.963188455972521e-08 0.00021 5.964188455972521e-08 0 5.964974310070208e-08 0 5.965974310070208e-08 0.00021 5.966974310070208e-08 0 5.974451331357835e-08 0 5.975451331357835e-08 0.00021 5.976451331357835e-08 0 5.976451331357835e-08 0 5.977451331357834e-08 0.00021 5.978451331357834e-08 0 5.978451331357834e-08 0 5.979451331357834e-08 0.00021 5.980451331357834e-08 0 5.980451331357834e-08 0 5.981451331357834e-08 0.00021 5.982451331357834e-08 0 5.982451331357834e-08 0 5.983451331357833e-08 0.00021 5.984451331357833e-08 0 5.984451331357833e-08 0 5.985451331357833e-08 0.00021 5.986451331357833e-08 0 5.987719772923171e-08 0 5.98871977292317e-08 0.00021 5.98971977292317e-08 0 5.98971977292317e-08 0 5.99071977292317e-08 0.00021 5.99171977292317e-08 0 5.99171977292317e-08 0 5.99271977292317e-08 0.00021 5.99371977292317e-08 0 6.001046518170085e-08 0 6.002046518170085e-08 0.00021 6.003046518170084e-08 0 6.003677912455875e-08 0 6.004677912455875e-08 0.00021 6.005677912455875e-08 0 6.012586930232432e-08 0 6.013586930232431e-08 0.00021 6.014586930232431e-08 0 6.02603288896104e-08 0 6.02703288896104e-08 0.00021 6.02803288896104e-08 0 6.031305056015329e-08 0 6.032305056015329e-08 0.00021 6.033305056015329e-08 0 6.033305056015329e-08 0 6.034305056015329e-08 0.00021 6.035305056015328e-08 0 6.035305056015328e-08 0 6.036305056015328e-08 0.00021 6.037305056015328e-08 0 6.037305056015328e-08 0 6.038305056015328e-08 0.00021 6.039305056015328e-08 0 6.039305056015328e-08 0 6.040305056015328e-08 0.00021 6.041305056015327e-08 0 6.041305056015327e-08 0 6.042305056015327e-08 0.00021 6.043305056015327e-08 0 6.043305056015327e-08 0 6.044305056015327e-08 0.00021 6.045305056015327e-08 0 6.045305056015327e-08 0 6.046305056015326e-08 0.00021 6.047305056015326e-08 0 6.047305056015326e-08 0 6.048305056015326e-08 0.00021 6.049305056015326e-08 0 6.049765060910436e-08 0 6.050765060910436e-08 0.00021 6.051765060910436e-08 0 6.051765060910436e-08 0 6.052765060910436e-08 0.00021 6.053765060910435e-08 0 6.053765060910435e-08 0 6.054765060910435e-08 0.00021 6.055765060910435e-08 0 6.056075396102695e-08 0 6.057075396102694e-08 0.00021 6.058075396102694e-08 0 6.059614549008586e-08 0 6.060614549008586e-08 0.00021 6.061614549008585e-08 0 6.077690963172246e-08 0 6.078690963172245e-08 0.00021 6.079690963172245e-08 0 6.082183162576974e-08 0 6.083183162576974e-08 0.00021 6.084183162576974e-08 0 6.084211545564834e-08 0 6.085211545564834e-08 0.00021 6.086211545564834e-08 0 6.086211545564834e-08 0 6.087211545564834e-08 0.00021 6.088211545564833e-08 0 6.088211545564833e-08 0 6.089211545564833e-08 0.00021 6.090211545564833e-08 0 6.090211545564833e-08 0 6.091211545564833e-08 0.00021 6.092211545564833e-08 0 6.092211545564833e-08 0 6.093211545564832e-08 0.00021 6.094211545564832e-08 0 6.094211545564832e-08 0 6.095211545564832e-08 0.00021 6.096211545564832e-08 0 6.096211545564832e-08 0 6.097211545564832e-08 0.00021 6.098211545564831e-08 0 6.098211545564831e-08 0 6.099211545564831e-08 0.00021 6.100211545564831e-08 0 6.100211545564831e-08 0 6.101211545564831e-08 0.00021 6.102211545564831e-08 0 6.102211545564831e-08 0 6.10321154556483e-08 0.00021 6.10421154556483e-08 0 6.10421154556483e-08 0 6.10521154556483e-08 0.00021 6.10621154556483e-08 0 6.10621154556483e-08 0 6.10721154556483e-08 0.00021 6.10821154556483e-08 0 6.10821154556483e-08 0 6.10921154556483e-08 0.00021 6.110211545564829e-08 0 6.110211545564829e-08 0 6.111211545564829e-08 0.00021 6.112211545564829e-08 0 6.112211545564829e-08 0 6.113211545564829e-08 0.00021 6.114211545564828e-08 0 6.114211545564828e-08 0 6.115211545564828e-08 0.00021 6.116211545564828e-08 0 6.116211545564828e-08 0 6.117211545564828e-08 0.00021 6.118211545564828e-08 0 6.118211545564828e-08 0 6.119211545564827e-08 0.00021 6.120211545564827e-08 0 6.120211545564827e-08 0 6.121211545564827e-08 0.00021 6.122211545564827e-08 0 6.122211545564827e-08 0 6.123211545564827e-08 0.00021 6.124211545564827e-08 0 6.124211545564827e-08 0 6.125211545564826e-08 0.00021 6.126211545564826e-08 0 6.126211545564826e-08 0 6.127211545564826e-08 0.00021 6.128211545564826e-08 0 6.128211545564826e-08 0 6.129211545564826e-08 0.00021 6.130211545564825e-08 0 6.130211545564825e-08 0 6.131211545564825e-08 0.00021 6.132211545564825e-08 0 6.132211545564825e-08 0 6.133211545564825e-08 0.00021 6.134211545564825e-08 0 6.134211545564825e-08 0 6.135211545564824e-08 0.00021 6.136211545564824e-08 0 6.136211545564824e-08 0 6.137211545564824e-08 0.00021 6.138211545564824e-08 0 6.138211545564824e-08 0 6.139211545564824e-08 0.00021 6.140211545564823e-08 0 6.140211545564823e-08 0 6.141211545564823e-08 0.00021 6.142211545564823e-08 0 6.142211545564823e-08 0 6.143211545564823e-08 0.00021 6.144211545564823e-08 0 6.147463833079128e-08 0 6.148463833079128e-08 0.00021 6.149463833079128e-08 0 6.149463833079128e-08 0 6.150463833079128e-08 0.00021 6.151463833079128e-08 0 6.151463833079128e-08 0 6.152463833079127e-08 0.00021 6.153463833079127e-08 0 6.153463833079127e-08 0 6.154463833079127e-08 0.00021 6.155463833079127e-08 0 6.155463833079127e-08 0 6.156463833079127e-08 0.00021 6.157463833079126e-08 0 6.157463833079126e-08 0 6.158463833079126e-08 0.00021 6.159463833079126e-08 0 6.159463833079126e-08 0 6.160463833079126e-08 0.00021 6.161463833079126e-08 0 6.167246129791531e-08 0 6.16824612979153e-08 0.00021 6.16924612979153e-08 0 6.176721882514989e-08 0 6.177721882514989e-08 0.00021 6.178721882514988e-08 0 6.178721882514988e-08 0 6.179721882514988e-08 0.00021 6.180721882514988e-08 0 6.183863729238891e-08 0 6.184863729238891e-08 0.00021 6.185863729238891e-08 0 6.185863729238891e-08 0 6.186863729238891e-08 0.00021 6.18786372923889e-08 0 6.18786372923889e-08 0 6.18886372923889e-08 0.00021 6.18986372923889e-08 0 6.18986372923889e-08 0 6.19086372923889e-08 0.00021 6.19186372923889e-08 0 6.19186372923889e-08 0 6.19286372923889e-08 0.00021 6.19386372923889e-08 0 6.19972369424105e-08 0 6.20072369424105e-08 0.00021 6.20172369424105e-08 0 6.20172369424105e-08 0 6.20272369424105e-08 0.00021 6.20372369424105e-08 0 6.203876209477133e-08 0 6.204876209477133e-08 0.00021 6.205876209477132e-08 0 6.205876209477132e-08 0 6.206876209477132e-08 0.00021 6.207876209477132e-08 0 6.207876209477132e-08 0 6.208876209477132e-08 0.00021 6.209876209477132e-08 0 6.209876209477132e-08 0 6.210876209477131e-08 0.00021 6.211876209477131e-08 0 6.211876209477131e-08 0 6.212876209477131e-08 0.00021 6.213876209477131e-08 0 6.213876209477131e-08 0 6.214876209477131e-08 0.00021 6.21587620947713e-08 0 6.21587620947713e-08 0 6.21687620947713e-08 0.00021 6.21787620947713e-08 0 6.21787620947713e-08 0 6.21887620947713e-08 0.00021 6.21987620947713e-08 0 6.21987620947713e-08 0 6.22087620947713e-08 0.00021 6.22187620947713e-08 0 6.22187620947713e-08 0 6.222876209477129e-08 0.00021 6.223876209477129e-08 0 6.223876209477129e-08 0 6.224876209477129e-08 0.00021 6.225876209477129e-08 0 6.225876209477129e-08 0 6.226876209477128e-08 0.00021 6.227876209477128e-08 0 6.243993596609841e-08 0 6.24499359660984e-08 0.00021 6.24599359660984e-08 0 6.24599359660984e-08 0 6.24699359660984e-08 0.00021 6.24799359660984e-08 0 6.24799359660984e-08 0 6.24899359660984e-08 0.00021 6.24999359660984e-08 0 6.251154467604872e-08 0 6.252154467604872e-08 0.00021 6.253154467604871e-08 0 6.259751616218679e-08 0 6.260751616218679e-08 0.00021 6.261751616218679e-08 0 6.261751616218679e-08 0 6.262751616218679e-08 0.00021 6.263751616218678e-08 0 6.263751616218678e-08 0 6.264751616218678e-08 0.00021 6.265751616218678e-08 0 6.269843902911119e-08 0 6.270843902911118e-08 0.00021 6.271843902911118e-08 0 6.271843902911118e-08 0 6.272843902911118e-08 0.00021 6.273843902911118e-08 0 6.273843902911118e-08 0 6.274843902911118e-08 0.00021 6.275843902911118e-08 0 6.275843902911118e-08 0 6.276843902911117e-08 0.00021 6.277843902911117e-08 0 6.277843902911117e-08 0 6.278843902911117e-08 0.00021 6.279843902911117e-08 0 6.279843902911117e-08 0 6.280843902911117e-08 0.00021 6.281843902911116e-08 0 6.281843902911116e-08 0 6.282843902911116e-08 0.00021 6.283843902911116e-08 0 6.298806959461344e-08 0 6.299806959461344e-08 0.00021 6.300806959461344e-08 0 6.303296008469274e-08 0 6.304296008469274e-08 0.00021 6.305296008469274e-08 0 6.305826230899655e-08 0 6.306826230899655e-08 0.00021 6.307826230899655e-08 0 6.307826230899655e-08 0 6.308826230899655e-08 0.00021 6.309826230899654e-08 0 6.310813465211076e-08 0 6.311813465211075e-08 0.00021 6.312813465211075e-08 0 6.312813465211075e-08 0 6.313813465211075e-08 0.00021 6.314813465211075e-08 0 6.314813465211075e-08 0 6.315813465211075e-08 0.00021 6.316813465211074e-08 0 6.316813465211074e-08 0 6.317813465211074e-08 0.00021 6.318813465211074e-08 0 6.318813465211074e-08 0 6.319813465211074e-08 0.00021 6.320813465211074e-08 0 6.320813465211074e-08 0 6.321813465211073e-08 0.00021 6.322813465211073e-08 0 6.322813465211073e-08 0 6.323813465211073e-08 0.00021 6.324813465211073e-08 0 6.329160219354328e-08 0 6.330160219354328e-08 0.00021 6.331160219354327e-08 0 6.336256137360666e-08 0 6.337256137360666e-08 0.00021 6.338256137360666e-08 0 6.34158165426136e-08 0 6.34258165426136e-08 0.00021 6.34358165426136e-08 0 6.34358165426136e-08 0 6.34458165426136e-08 0.00021 6.34558165426136e-08 0 6.34558165426136e-08 0 6.34658165426136e-08 0.00021 6.34758165426136e-08 0 6.357950617366783e-08 0 6.358950617366782e-08 0.00021 6.359950617366782e-08 0 6.361434772789654e-08 0 6.362434772789653e-08 0.00021 6.363434772789653e-08 0 6.364881358154957e-08 0 6.365881358154957e-08 0.00021 6.366881358154956e-08 0 6.367103318938985e-08 0 6.368103318938984e-08 0.00021 6.369103318938984e-08 0 6.369103318938984e-08 0 6.370103318938984e-08 0.00021 6.371103318938984e-08 0 6.371103318938984e-08 0 6.372103318938984e-08 0.00021 6.373103318938983e-08 0 6.374821371232983e-08 0 6.375821371232983e-08 0.00021 6.376821371232982e-08 0 6.376821371232982e-08 0 6.377821371232982e-08 0.00021 6.378821371232982e-08 0 6.378821371232982e-08 0 6.379821371232982e-08 0.00021 6.380821371232982e-08 0 6.380821371232982e-08 0 6.381821371232981e-08 0.00021 6.382821371232981e-08 0 6.382821371232981e-08 0 6.383821371232981e-08 0.00021 6.384821371232981e-08 0 6.384821371232981e-08 0 6.385821371232981e-08 0.00021 6.38682137123298e-08 0 6.38682137123298e-08 0 6.38782137123298e-08 0.00021 6.38882137123298e-08 0 6.389502967269332e-08 0 6.390502967269332e-08 0.00021 6.391502967269332e-08 0 6.391502967269332e-08 0 6.392502967269331e-08 0.00021 6.393502967269331e-08 0 6.39442814968259e-08 0 6.39542814968259e-08 0.00021 6.39642814968259e-08 0 6.39642814968259e-08 0 6.397428149682589e-08 0.00021 6.398428149682589e-08 0 6.398428149682589e-08 0 6.399428149682589e-08 0.00021 6.400428149682589e-08 0 6.400428149682589e-08 0 6.401428149682589e-08 0.00021 6.402428149682588e-08 0 6.402428149682588e-08 0 6.403428149682588e-08 0.00021 6.404428149682588e-08 0 6.406366822007552e-08 0 6.407366822007551e-08 0.00021 6.408366822007551e-08 0 6.408366822007551e-08 0 6.409366822007551e-08 0.00021 6.410366822007551e-08 0 6.410366822007551e-08 0 6.41136682200755e-08 0.00021 6.41236682200755e-08 0 6.41236682200755e-08 0 6.41336682200755e-08 0.00021 6.41436682200755e-08 0 6.41436682200755e-08 0 6.41536682200755e-08 0.00021 6.41636682200755e-08 0 6.41636682200755e-08 0 6.41736682200755e-08 0.00021 6.418366822007549e-08 0 6.418366822007549e-08 0 6.419366822007549e-08 0.00021 6.420366822007549e-08 0 6.420366822007549e-08 0 6.421366822007549e-08 0.00021 6.422366822007548e-08 0 6.422366822007548e-08 0 6.423366822007548e-08 0.00021 6.424366822007548e-08 0 6.424366822007548e-08 0 6.425366822007548e-08 0.00021 6.426366822007548e-08 0 6.426366822007548e-08 0 6.427366822007548e-08 0.00021 6.428366822007547e-08 0 6.428366822007547e-08 0 6.429366822007547e-08 0.00021 6.430366822007547e-08 0 6.430366822007547e-08 0 6.431366822007547e-08 0.00021 6.432366822007547e-08 0 6.432366822007547e-08 0 6.433366822007546e-08 0.00021 6.434366822007546e-08 0 6.434366822007546e-08 0 6.435366822007546e-08 0.00021 6.436366822007546e-08 0 6.436366822007546e-08 0 6.437366822007546e-08 0.00021 6.438366822007545e-08 0 6.444733677565477e-08 0 6.445733677565477e-08 0.00021 6.446733677565477e-08 0 6.446733677565477e-08 0 6.447733677565477e-08 0.00021 6.448733677565477e-08 0 6.448733677565477e-08 0 6.449733677565476e-08 0.00021 6.450733677565476e-08 0 6.458196659872618e-08 0 6.459196659872617e-08 0.00021 6.460196659872617e-08 0 6.460196659872617e-08 0 6.461196659872617e-08 0.00021 6.462196659872617e-08 0 6.462196659872617e-08 0 6.463196659872617e-08 0.00021 6.464196659872617e-08 0 6.464196659872617e-08 0 6.465196659872616e-08 0.00021 6.466196659872616e-08 0 6.466196659872616e-08 0 6.467196659872616e-08 0.00021 6.468196659872616e-08 0 6.468196659872616e-08 0 6.469196659872616e-08 0.00021 6.470196659872615e-08 0 6.470196659872615e-08 0 6.471196659872615e-08 0.00021 6.472196659872615e-08 0 6.472196659872615e-08 0 6.473196659872615e-08 0.00021 6.474196659872615e-08 0 6.474196659872615e-08 0 6.475196659872614e-08 0.00021 6.476196659872614e-08 0 6.476196659872614e-08 0 6.477196659872614e-08 0.00021 6.478196659872614e-08 0 6.478196659872614e-08 0 6.479196659872614e-08 0.00021 6.480196659872613e-08 0 6.480196659872613e-08 0 6.481196659872613e-08 0.00021 6.482196659872613e-08 0 6.482196659872613e-08 0 6.483196659872613e-08 0.00021 6.484196659872613e-08 0 6.484196659872613e-08 0 6.485196659872613e-08 0.00021 6.486196659872612e-08 0 6.486196659872612e-08 0 6.487196659872612e-08 0.00021 6.488196659872612e-08 0 6.500779050461977e-08 0 6.501779050461977e-08 0.00021 6.502779050461977e-08 0 6.502779050461977e-08 0 6.503779050461977e-08 0.00021 6.504779050461977e-08 0 6.510993348737997e-08 0 6.511993348737996e-08 0.00021 6.512993348737996e-08 0 6.515437430435816e-08 0 6.516437430435816e-08 0.00021 6.517437430435816e-08 0 6.519930149280486e-08 0 6.520930149280486e-08 0.00021 6.521930149280486e-08 0 6.523113640892136e-08 0 6.524113640892135e-08 0.00021 6.525113640892135e-08 0 6.525113640892135e-08 0 6.526113640892135e-08 0.00021 6.527113640892135e-08 0 6.527113640892135e-08 0 6.528113640892135e-08 0.00021 6.529113640892134e-08 0 6.529113640892134e-08 0 6.530113640892134e-08 0.00021 6.531113640892134e-08 0 6.53237255978256e-08 0 6.53337255978256e-08 0.00021 6.53437255978256e-08 0 6.53437255978256e-08 0 6.53537255978256e-08 0.00021 6.53637255978256e-08 0 6.53637255978256e-08 0 6.537372559782559e-08 0.00021 6.538372559782559e-08 0 6.541341340838041e-08 0 6.542341340838041e-08 0.00021 6.543341340838041e-08 0 6.543341340838041e-08 0 6.544341340838041e-08 0.00021 6.54534134083804e-08 0 6.54534134083804e-08 0 6.54634134083804e-08 0.00021 6.54734134083804e-08 0 6.54734134083804e-08 0 6.54834134083804e-08 0.00021 6.54934134083804e-08 0 6.54934134083804e-08 0 6.55034134083804e-08 0.00021 6.55134134083804e-08 0 6.55567076964799e-08 0 6.55667076964799e-08 0.00021 6.55767076964799e-08 0 6.559487426419694e-08 0 6.560487426419694e-08 0.00021 6.561487426419694e-08 0 6.564079355443271e-08 0 6.565079355443271e-08 0.00021 6.56607935544327e-08 0 6.567254709630192e-08 0 6.568254709630192e-08 0.00021 6.569254709630192e-08 0 6.569254709630192e-08 0 6.570254709630192e-08 0.00021 6.571254709630191e-08 0 6.571254709630191e-08 0 6.572254709630191e-08 0.00021 6.573254709630191e-08 0 6.573254709630191e-08 0 6.574254709630191e-08 0.00021 6.57525470963019e-08 0 6.57525470963019e-08 0 6.57625470963019e-08 0.00021 6.57725470963019e-08 0 6.57725470963019e-08 0 6.57825470963019e-08 0.00021 6.57925470963019e-08 0 6.57925470963019e-08 0 6.58025470963019e-08 0.00021 6.58125470963019e-08 0 6.58125470963019e-08 0 6.582254709630189e-08 0.00021 6.583254709630189e-08 0 6.583254709630189e-08 0 6.584254709630189e-08 0.00021 6.585254709630189e-08 0 6.585254709630189e-08 0 6.586254709630189e-08 0.00021 6.587254709630188e-08 0 6.587254709630188e-08 0 6.588254709630188e-08 0.00021 6.589254709630188e-08 0 6.589254709630188e-08 0 6.590254709630188e-08 0.00021 6.591254709630188e-08 0 6.591254709630188e-08 0 6.592254709630187e-08 0.00021 6.593254709630187e-08 0 6.593254709630187e-08 0 6.594254709630187e-08 0.00021 6.595254709630187e-08 0 6.595254709630187e-08 0 6.596254709630187e-08 0.00021 6.597254709630186e-08 0 6.597254709630186e-08 0 6.598254709630186e-08 0.00021 6.599254709630186e-08 0 6.599254709630186e-08 0 6.600254709630186e-08 0.00021 6.601254709630186e-08 0 6.601254709630186e-08 0 6.602254709630186e-08 0.00021 6.603254709630185e-08 0 6.603254709630185e-08 0 6.604254709630185e-08 0.00021 6.605254709630185e-08 0 6.605254709630185e-08 0 6.606254709630185e-08 0.00021 6.607254709630185e-08 0 6.607254709630185e-08 0 6.608254709630184e-08 0.00021 6.609254709630184e-08 0 6.609254709630184e-08 0 6.610254709630184e-08 0.00021 6.611254709630184e-08 0 6.611254709630184e-08 0 6.612254709630184e-08 0.00021 6.613254709630183e-08 0 6.613254709630183e-08 0 6.614254709630183e-08 0.00021 6.615254709630183e-08 0 6.615254709630183e-08 0 6.616254709630183e-08 0.00021 6.617254709630183e-08 0 6.617254709630183e-08 0 6.618254709630183e-08 0.00021 6.619254709630182e-08 0 6.619254709630182e-08 0 6.620254709630182e-08 0.00021 6.621254709630182e-08 0 6.621254709630182e-08 0 6.622254709630182e-08 0.00021 6.623254709630182e-08 0 6.623254709630182e-08 0 6.624254709630181e-08 0.00021 6.625254709630181e-08 0 6.63185200550004e-08 0 6.63285200550004e-08 0.00021 6.633852005500039e-08 0 6.635670165204798e-08 0 6.636670165204798e-08 0.00021 6.637670165204797e-08 0 6.641988115395574e-08 0 6.642988115395574e-08 0.00021 6.643988115395574e-08 0 6.646884386431026e-08 0 6.647884386431026e-08 0.00021 6.648884386431026e-08 0 6.650454333767748e-08 0 6.651454333767747e-08 0.00021 6.652454333767747e-08 0 6.652454333767747e-08 0 6.653454333767747e-08 0.00021 6.654454333767747e-08 0 6.654454333767747e-08 0 6.655454333767747e-08 0.00021 6.656454333767746e-08 0 6.656504385484865e-08 0 6.657504385484865e-08 0.00021 6.658504385484865e-08 0 6.671142170022749e-08 0 6.672142170022748e-08 0.00021 6.673142170022748e-08 0 6.673142170022748e-08 0 6.674142170022748e-08 0.00021 6.675142170022748e-08 0 6.675142170022748e-08 0 6.676142170022748e-08 0.00021 6.677142170022747e-08 0 6.677142170022747e-08 0 6.678142170022747e-08 0.00021 6.679142170022747e-08 0 6.679142170022747e-08 0 6.680142170022747e-08 0.00021 6.681142170022747e-08 0 6.681142170022747e-08 0 6.682142170022747e-08 0.00021 6.683142170022746e-08 0 6.68482444117022e-08 0 6.68582444117022e-08 0.00021 6.68682444117022e-08 0 6.68698502659854e-08 0 6.68798502659854e-08 0.00021 6.68898502659854e-08 0 6.68898502659854e-08 0 6.68998502659854e-08 0.00021 6.69098502659854e-08 0 6.693166236833993e-08 0 6.694166236833992e-08 0.00021 6.695166236833992e-08 0 6.695166236833992e-08 0 6.696166236833992e-08 0.00021 6.697166236833992e-08 0 6.710603502397885e-08 0 6.711603502397885e-08 0.00021 6.712603502397885e-08 0 6.712603502397885e-08 0 6.713603502397885e-08 0.00021 6.714603502397885e-08 0 6.714603502397885e-08 0 6.715603502397884e-08 0.00021 6.716603502397884e-08 0 6.716607239134799e-08 0 6.717607239134799e-08 0.00021 6.718607239134799e-08 0 6.718607239134799e-08 0 6.719607239134799e-08 0.00021 6.720607239134798e-08 0 6.721117683646241e-08 0 6.72211768364624e-08 0.00021 6.72311768364624e-08 0 6.724809361480092e-08 0 6.725809361480092e-08 0.00021 6.726809361480092e-08 0 6.726809361480092e-08 0 6.727809361480091e-08 0.00021 6.728809361480091e-08 0 6.728809361480091e-08 0 6.729809361480091e-08 0.00021 6.730809361480091e-08 0 6.730809361480091e-08 0 6.73180936148009e-08 0.00021 6.73280936148009e-08 0 6.73280936148009e-08 0 6.73380936148009e-08 0.00021 6.73480936148009e-08 0 6.73480936148009e-08 0 6.73580936148009e-08 0.00021 6.73680936148009e-08 0 6.73680936148009e-08 0 6.73780936148009e-08 0.00021 6.738809361480089e-08 0 6.74483125561723e-08 0 6.74583125561723e-08 0.00021 6.74683125561723e-08 0 6.752747165464412e-08 0 6.753747165464412e-08 0.00021 6.754747165464412e-08 0 6.754747165464412e-08 0 6.755747165464412e-08 0.00021 6.756747165464412e-08 0 6.756747165464412e-08 0 6.757747165464412e-08 0.00021 6.758747165464411e-08 0 6.758747165464411e-08 0 6.759747165464411e-08 0.00021 6.760747165464411e-08 0 6.760747165464411e-08 0 6.761747165464411e-08 0.00021 6.76274716546441e-08 0 6.76571949141256e-08 0 6.76671949141256e-08 0.00021 6.76771949141256e-08 0 6.76771949141256e-08 0 6.76871949141256e-08 0.00021 6.76971949141256e-08 0 6.770014237969807e-08 0 6.771014237969807e-08 0.00021 6.772014237969807e-08 0 6.772014237969807e-08 0 6.773014237969807e-08 0.00021 6.774014237969806e-08 0 6.778895665134024e-08 0 6.779895665134024e-08 0.00021 6.780895665134023e-08 0 6.780895665134023e-08 0 6.781895665134023e-08 0.00021 6.782895665134023e-08 0 6.78734379014591e-08 0 6.78834379014591e-08 0.00021 6.78934379014591e-08 0 6.789858139398031e-08 0 6.790858139398031e-08 0.00021 6.79185813939803e-08 0 6.792843672727652e-08 0 6.793843672727652e-08 0.00021 6.794843672727652e-08 0 6.797649022263602e-08 0 6.798649022263602e-08 0.00021 6.799649022263602e-08 0 6.799649022263602e-08 0 6.800649022263602e-08 0.00021 6.801649022263601e-08 0 6.801649022263601e-08 0 6.802649022263601e-08 0.00021 6.803649022263601e-08 0 6.803649022263601e-08 0 6.804649022263601e-08 0.00021 6.805649022263601e-08 0 6.805649022263601e-08 0 6.8066490222636e-08 0.00021 6.8076490222636e-08 0 6.8076490222636e-08 0 6.8086490222636e-08 0.00021 6.8096490222636e-08 0 6.8096490222636e-08 0 6.8106490222636e-08 0.00021 6.8116490222636e-08 0 6.8116490222636e-08 0 6.8126490222636e-08 0.00021 6.813649022263599e-08 0 6.814805848426633e-08 0 6.815805848426633e-08 0.00021 6.816805848426633e-08 0 6.820022491631196e-08 0 6.821022491631196e-08 0.00021 6.822022491631196e-08 0 6.822022491631196e-08 0 6.823022491631196e-08 0.00021 6.824022491631196e-08 0 6.828232273538443e-08 0 6.829232273538443e-08 0.00021 6.830232273538442e-08 0 6.830232273538442e-08 0 6.831232273538442e-08 0.00021 6.832232273538442e-08 0 6.833738647972914e-08 0 6.834738647972913e-08 0.00021 6.835738647972913e-08 0 6.836589572566252e-08 0 6.837589572566252e-08 0.00021 6.838589572566251e-08 0 6.838589572566251e-08 0 6.839589572566251e-08 0.00021 6.840589572566251e-08 0 6.840589572566251e-08 0 6.841589572566251e-08 0.00021 6.84258957256625e-08 0 6.84258957256625e-08 0 6.84358957256625e-08 0.00021 6.84458957256625e-08 0 6.84458957256625e-08 0 6.84558957256625e-08 0.00021 6.84658957256625e-08 0 6.84658957256625e-08 0 6.84758957256625e-08 0.00021 6.84858957256625e-08 0 6.84858957256625e-08 0 6.849589572566249e-08 0.00021 6.850589572566249e-08 0 6.850589572566249e-08 0 6.851589572566249e-08 0.00021 6.852589572566249e-08 0 6.855857333706445e-08 0 6.856857333706445e-08 0.00021 6.857857333706445e-08 0 6.867124329063577e-08 0 6.868124329063577e-08 0.00021 6.869124329063577e-08 0 6.869124329063577e-08 0 6.870124329063577e-08 0.00021 6.871124329063577e-08 0 6.875606920096923e-08 0 6.876606920096923e-08 0.00021 6.877606920096923e-08 0 6.877606920096923e-08 0 6.878606920096922e-08 0.00021 6.879606920096922e-08 0 6.879606920096922e-08 0 6.880606920096922e-08 0.00021 6.881606920096922e-08 0 6.881883205043177e-08 0 6.882883205043177e-08 0.00021 6.883883205043177e-08 0 6.884766965919896e-08 0 6.885766965919895e-08 0.00021 6.886766965919895e-08 0 6.886766965919895e-08 0 6.887766965919895e-08 0.00021 6.888766965919895e-08 0 6.8901755914691e-08 0 6.8911755914691e-08 0.00021 6.8921755914691e-08 0 6.8921755914691e-08 0 6.8931755914691e-08 0.00021 6.8941755914691e-08 0 6.899138028277189e-08 0 6.900138028277189e-08 0.00021 6.901138028277189e-08 0 6.90204050194984e-08 0 6.90304050194984e-08 0.00021 6.90404050194984e-08 0 6.906159583461568e-08 0 6.907159583461568e-08 0.00021 6.908159583461568e-08 0 6.908159583461568e-08 0 6.909159583461568e-08 0.00021 6.910159583461567e-08 0 6.910159583461567e-08 0 6.911159583461567e-08 0.00021 6.912159583461567e-08 0 6.912159583461567e-08 0 6.913159583461567e-08 0.00021 6.914159583461567e-08 0 6.914159583461567e-08 0 6.915159583461567e-08 0.00021 6.916159583461566e-08 0 6.916159583461566e-08 0 6.917159583461566e-08 0.00021 6.918159583461566e-08 0 6.918159583461566e-08 0 6.919159583461566e-08 0.00021 6.920159583461566e-08 0 6.926222410353312e-08 0 6.927222410353312e-08 0.00021 6.928222410353312e-08 0 6.929574705700351e-08 0 6.930574705700351e-08 0.00021 6.931574705700351e-08 0 6.936765671212754e-08 0 6.937765671212754e-08 0.00021 6.938765671212754e-08 0 6.93901844506203e-08 0 6.94001844506203e-08 0.00021 6.94101844506203e-08 0 6.94144732708866e-08 0 6.94244732708866e-08 0.00021 6.94344732708866e-08 0 6.94344732708866e-08 0 6.94444732708866e-08 0.00021 6.945447327088659e-08 0 6.949114181197136e-08 0 6.950114181197136e-08 0.00021 6.951114181197136e-08 0 6.954052986947804e-08 0 6.955052986947803e-08 0.00021 6.956052986947803e-08 0 6.960678498817773e-08 0 6.961678498817773e-08 0.00021 6.962678498817773e-08 0 6.962678498817773e-08 0 6.963678498817773e-08 0.00021 6.964678498817773e-08 0 6.964678498817773e-08 0 6.965678498817772e-08 0.00021 6.966678498817772e-08 0 6.966678498817772e-08 0 6.967678498817772e-08 0.00021 6.968678498817772e-08 0 6.968678498817772e-08 0 6.969678498817772e-08 0.00021 6.970678498817771e-08 0 6.970678498817771e-08 0 6.971678498817771e-08 0.00021 6.972678498817771e-08 0 6.972678498817771e-08 0 6.973678498817771e-08 0.00021 6.97467849881777e-08 0 6.97467849881777e-08 0 6.97567849881777e-08 0.00021 6.97667849881777e-08 0 6.97667849881777e-08 0 6.97767849881777e-08 0.00021 6.97867849881777e-08 0 6.978955757942693e-08 0 6.979955757942693e-08 0.00021 6.980955757942693e-08 0 6.980955757942693e-08 0 6.981955757942692e-08 0.00021 6.982955757942692e-08 0 6.982955757942692e-08 0 6.983955757942692e-08 0.00021 6.984955757942692e-08 0 6.984955757942692e-08 0 6.985955757942692e-08 0.00021 6.986955757942691e-08 0 6.986955757942691e-08 0 6.987955757942691e-08 0.00021 6.988955757942691e-08 0 6.988955757942691e-08 0 6.989955757942691e-08 0.00021 6.99095575794269e-08 0 6.99095575794269e-08 0 6.99195575794269e-08 0.00021 6.99295575794269e-08 0 6.99295575794269e-08 0 6.99395575794269e-08 0.00021 6.99495575794269e-08 0 6.99495575794269e-08 0 6.99595575794269e-08 0.00021 6.99695575794269e-08 0 6.99695575794269e-08 0 6.997955757942689e-08 0.00021 6.998955757942689e-08 0 6.998955757942689e-08 0 6.999955757942689e-08 0.00021 7.000955757942689e-08 0 7.000955757942689e-08 0 7.001955757942689e-08 0.00021 7.002955757942688e-08 0 7.002955757942688e-08 0 7.003955757942688e-08 0.00021 7.004955757942688e-08 0 7.004955757942688e-08 0 7.005955757942688e-08 0.00021 7.006955757942688e-08 0 7.006955757942688e-08 0 7.007955757942687e-08 0.00021 7.008955757942687e-08 0 7.008955757942687e-08 0 7.009955757942687e-08 0.00021 7.010955757942687e-08 0 7.010955757942687e-08 0 7.011955757942687e-08 0.00021 7.012955757942686e-08 0 7.012955757942686e-08 0 7.013955757942686e-08 0.00021 7.014955757942686e-08 0 7.014955757942686e-08 0 7.015955757942686e-08 0.00021 7.016955757942686e-08 0 7.016955757942686e-08 0 7.017955757942686e-08 0.00021 7.018955757942685e-08 0 7.018955757942685e-08 0 7.019955757942685e-08 0.00021 7.020955757942685e-08 0 7.02172221780962e-08 0 7.02272221780962e-08 0.00021 7.02372221780962e-08 0 7.03912789256961e-08 0 7.04012789256961e-08 0.00021 7.04112789256961e-08 0 7.042931926606053e-08 0 7.043931926606053e-08 0.00021 7.044931926606053e-08 0 7.044931926606053e-08 0 7.045931926606053e-08 0.00021 7.046931926606053e-08 0 7.05344902798723e-08 0 7.05444902798723e-08 0.00021 7.05544902798723e-08 0 7.05544902798723e-08 0 7.05644902798723e-08 0.00021 7.05744902798723e-08 0 7.057872067467026e-08 0 7.058872067467025e-08 0.00021 7.059872067467025e-08 0 7.059872067467025e-08 0 7.060872067467025e-08 0.00021 7.061872067467025e-08 0 7.067539480312047e-08 0 7.068539480312047e-08 0.00021 7.069539480312047e-08 0 7.069539480312047e-08 0 7.070539480312047e-08 0.00021 7.071539480312046e-08 0 7.071539480312046e-08 0 7.072539480312046e-08 0.00021 7.073539480312046e-08 0 7.073539480312046e-08 0 7.074539480312046e-08 0.00021 7.075539480312046e-08 0 7.077742292255285e-08 0 7.078742292255285e-08 0.00021 7.079742292255285e-08 0 7.081298306127425e-08 0 7.082298306127425e-08 0.00021 7.083298306127425e-08 0 7.083298306127425e-08 0 7.084298306127424e-08 0.00021 7.085298306127424e-08 0 7.085552892669108e-08 0 7.086552892669108e-08 0.00021 7.087552892669108e-08 0 7.099520959636802e-08 0 7.100520959636802e-08 0.00021 7.101520959636802e-08 0 7.101520959636802e-08 0 7.102520959636802e-08 0.00021 7.103520959636802e-08 0 7.103520959636802e-08 0 7.104520959636801e-08 0.00021 7.105520959636801e-08 0 7.110061626604899e-08 0 7.111061626604899e-08 0.00021 7.112061626604899e-08 0 7.112061626604899e-08 0 7.113061626604899e-08 0.00021 7.114061626604898e-08 0 7.114061626604898e-08 0 7.115061626604898e-08 0.00021 7.116061626604898e-08 0 7.116061626604898e-08 0 7.117061626604898e-08 0.00021 7.118061626604898e-08 0 7.118061626604898e-08 0 7.119061626604897e-08 0.00021 7.120061626604897e-08 0 7.120061626604897e-08 0 7.121061626604897e-08 0.00021 7.122061626604897e-08 0 7.127098652089922e-08 0 7.128098652089922e-08 0.00021 7.129098652089922e-08 0 7.133167514043066e-08 0 7.134167514043065e-08 0.00021 7.135167514043065e-08 0 7.136320701663472e-08 0 7.137320701663472e-08 0.00021 7.138320701663472e-08 0 7.141371904633861e-08 0 7.142371904633861e-08 0.00021 7.143371904633861e-08 0 7.145438974842238e-08 0 7.146438974842238e-08 0.00021 7.147438974842238e-08 0 7.148606117968436e-08 0 7.149606117968436e-08 0.00021 7.150606117968436e-08 0 7.151634421035707e-08 0 7.152634421035706e-08 0.00021 7.153634421035706e-08 0 7.159024569313571e-08 0 7.160024569313571e-08 0.00021 7.161024569313571e-08 0 7.161024569313571e-08 0 7.162024569313571e-08 0.00021 7.16302456931357e-08 0 7.16302456931357e-08 0 7.16402456931357e-08 0.00021 7.16502456931357e-08 0 7.175617481890924e-08 0 7.176617481890923e-08 0.00021 7.177617481890923e-08 0 7.180000050727806e-08 0 7.181000050727806e-08 0.00021 7.182000050727806e-08 0 7.182000050727806e-08 0 7.183000050727805e-08 0.00021 7.184000050727805e-08 0 7.184000050727805e-08 0 7.185000050727805e-08 0.00021 7.186000050727805e-08 0 7.186000050727805e-08 0 7.187000050727805e-08 0.00021 7.188000050727805e-08 0 7.188000050727805e-08 0 7.189000050727804e-08 0.00021 7.190000050727804e-08 0 7.190000050727804e-08 0 7.191000050727804e-08 0.00021 7.192000050727804e-08 0 7.192000050727804e-08 0 7.193000050727804e-08 0.00021 7.194000050727803e-08 0 7.202183540355097e-08 0 7.203183540355097e-08 0.00021 7.204183540355097e-08 0 7.20644026552226e-08 0 7.20744026552226e-08 0.00021 7.20844026552226e-08 0 7.208573321831909e-08 0 7.209573321831909e-08 0.00021 7.210573321831908e-08 0 7.215029902188161e-08 0 7.21602990218816e-08 0.00021 7.21702990218816e-08 0 7.21702990218816e-08 0 7.21802990218816e-08 0.00021 7.21902990218816e-08 0 7.21902990218816e-08 0 7.22002990218816e-08 0.00021 7.22102990218816e-08 0 7.22102990218816e-08 0 7.22202990218816e-08 0.00021 7.223029902188159e-08 0 7.223029902188159e-08 0 7.224029902188159e-08 0.00021 7.225029902188159e-08 0 7.225164042516244e-08 0 7.226164042516244e-08 0.00021 7.227164042516244e-08 0 7.227164042516244e-08 0 7.228164042516243e-08 0.00021 7.229164042516243e-08 0 7.229164042516243e-08 0 7.230164042516243e-08 0.00021 7.231164042516243e-08 0 7.231164042516243e-08 0 7.232164042516243e-08 0.00021 7.233164042516242e-08 0 7.233164042516242e-08 0 7.234164042516242e-08 0.00021 7.235164042516242e-08 0 7.235164042516242e-08 0 7.236164042516242e-08 0.00021 7.237164042516242e-08 0 7.237164042516242e-08 0 7.238164042516241e-08 0.00021 7.239164042516241e-08 0 7.239164042516241e-08 0 7.240164042516241e-08 0.00021 7.241164042516241e-08 0 7.245273280371384e-08 0 7.246273280371384e-08 0.00021 7.247273280371384e-08 0 7.247273280371384e-08 0 7.248273280371384e-08 0.00021 7.249273280371384e-08 0 7.249273280371384e-08 0 7.250273280371383e-08 0.00021 7.251273280371383e-08 0 7.251273280371383e-08 0 7.252273280371383e-08 0.00021 7.253273280371383e-08 0 7.253273280371383e-08 0 7.254273280371383e-08 0.00021 7.255273280371382e-08 0 7.25622331638858e-08 0 7.25722331638858e-08 0.00021 7.258223316388579e-08 0 7.261658639342542e-08 0 7.262658639342542e-08 0.00021 7.263658639342541e-08 0 7.270668892384413e-08 0 7.271668892384413e-08 0.00021 7.272668892384412e-08 0 7.290344660268416e-08 0 7.291344660268415e-08 0.00021 7.292344660268415e-08 0 7.292344660268415e-08 0 7.293344660268415e-08 0.00021 7.294344660268415e-08 0 7.296308877056216e-08 0 7.297308877056215e-08 0.00021 7.298308877056215e-08 0 7.302506390999122e-08 0 7.303506390999122e-08 0.00021 7.304506390999122e-08 0 7.305959864252773e-08 0 7.306959864252772e-08 0.00021 7.307959864252772e-08 0 7.307959864252772e-08 0 7.308959864252772e-08 0.00021 7.309959864252772e-08 0 7.31496884862845e-08 0 7.31596884862845e-08 0.00021 7.316968848628449e-08 0 7.317348960555695e-08 0 7.318348960555694e-08 0.00021 7.319348960555694e-08 0 7.332887258034583e-08 0 7.333887258034583e-08 0.00021 7.334887258034583e-08 0 7.334887258034583e-08 0 7.335887258034583e-08 0.00021 7.336887258034583e-08 0 7.34248150290187e-08 0 7.34348150290187e-08 0.00021 7.34448150290187e-08 0 7.34448150290187e-08 0 7.34548150290187e-08 0.00021 7.34648150290187e-08 0 7.34648150290187e-08 0 7.347481502901869e-08 0.00021 7.348481502901869e-08 0 7.358718197422662e-08 0 7.359718197422662e-08 0.00021 7.360718197422662e-08 0 7.360718197422662e-08 0 7.361718197422662e-08 0.00021 7.362718197422661e-08 0 7.362718197422661e-08 0 7.363718197422661e-08 0.00021 7.364718197422661e-08 0 7.364718197422661e-08 0 7.365718197422661e-08 0.00021 7.36671819742266e-08 0 7.36671819742266e-08 0 7.36771819742266e-08 0.00021 7.36871819742266e-08 0 7.36871819742266e-08 0 7.36971819742266e-08 0.00021 7.37071819742266e-08 0 7.37071819742266e-08 0 7.37171819742266e-08 0.00021 7.37271819742266e-08 0 7.37271819742266e-08 0 7.373718197422659e-08 0.00021 7.374718197422659e-08 0 7.374718197422659e-08 0 7.375718197422659e-08 0.00021 7.376718197422659e-08 0 7.376718197422659e-08 0 7.377718197422659e-08 0.00021 7.378718197422658e-08 0 7.386696742535048e-08 0 7.387696742535048e-08 0.00021 7.388696742535048e-08 0 7.389078954656183e-08 0 7.390078954656182e-08 0.00021 7.391078954656182e-08 0 7.391078954656182e-08 0 7.392078954656182e-08 0.00021 7.393078954656182e-08 0 7.394232990475576e-08 0 7.395232990475576e-08 0.00021 7.396232990475575e-08 0 7.4021241221139e-08 0 7.4031241221139e-08 0.00021 7.4041241221139e-08 0 7.405305272984254e-08 0 7.406305272984253e-08 0.00021 7.407305272984253e-08 0 7.407305272984253e-08 0 7.408305272984253e-08 0.00021 7.409305272984253e-08 0 7.416369923480329e-08 0 7.417369923480328e-08 0.00021 7.418369923480328e-08 0 7.420665776859669e-08 0 7.421665776859669e-08 0.00021 7.422665776859668e-08 0 7.422665776859668e-08 0 7.423665776859668e-08 0.00021 7.424665776859668e-08 0 7.424665776859668e-08 0 7.425665776859668e-08 0.00021 7.426665776859668e-08 0 7.426665776859668e-08 0 7.427665776859667e-08 0.00021 7.428665776859667e-08 0 7.431836173566395e-08 0 7.432836173566395e-08 0.00021 7.433836173566394e-08 0 7.433891574262702e-08 0 7.434891574262701e-08 0.00021 7.435891574262701e-08 0 7.435891574262701e-08 0 7.436891574262701e-08 0.00021 7.437891574262701e-08 0 7.437891574262701e-08 0 7.4388915742627e-08 0.00021 7.4398915742627e-08 0 7.440967317232617e-08 0 7.441967317232617e-08 0.00021 7.442967317232617e-08 0 7.443468924957788e-08 0 7.444468924957787e-08 0.00021 7.445468924957787e-08 0 7.448676368118268e-08 0 7.449676368118267e-08 0.00021 7.450676368118267e-08 0 7.450676368118267e-08 0 7.451676368118267e-08 0.00021 7.452676368118267e-08 0 7.453352050980439e-08 0 7.454352050980438e-08 0.00021 7.455352050980438e-08 0 7.458408073872095e-08 0 7.459408073872095e-08 0.00021 7.460408073872095e-08 0 7.460408073872095e-08 0 7.461408073872095e-08 0.00021 7.462408073872094e-08 0 7.464119218793554e-08 0 7.465119218793553e-08 0.00021 7.466119218793553e-08 0 7.466773057272857e-08 0 7.467773057272857e-08 0.00021 7.468773057272857e-08 0 7.481162693451042e-08 0 7.482162693451042e-08 0.00021 7.483162693451042e-08 0 7.483563677792526e-08 0 7.484563677792526e-08 0.00021 7.485563677792526e-08 0 7.485563677792526e-08 0 7.486563677792526e-08 0.00021 7.487563677792525e-08 0 7.490077079575499e-08 0 7.491077079575499e-08 0.00021 7.492077079575499e-08 0 7.493256003477695e-08 0 7.494256003477695e-08 0.00021 7.495256003477695e-08 0 7.496677035321291e-08 0 7.497677035321291e-08 0.00021 7.49867703532129e-08 0 7.49867703532129e-08 0 7.49967703532129e-08 0.00021 7.50067703532129e-08 0 7.502299523249448e-08 0 7.503299523249448e-08 0.00021 7.504299523249448e-08 0 7.504299523249448e-08 0 7.505299523249448e-08 0.00021 7.506299523249447e-08 0 7.506299523249447e-08 0 7.507299523249447e-08 0.00021 7.508299523249447e-08 0 7.508299523249447e-08 0 7.509299523249447e-08 0.00021 7.510299523249447e-08 0 7.510299523249447e-08 0 7.511299523249446e-08 0.00021 7.512299523249446e-08 0 7.512299523249446e-08 0 7.513299523249446e-08 0.00021 7.514299523249446e-08 0 7.514847730606132e-08 0 7.515847730606131e-08 0.00021 7.516847730606131e-08 0 7.523566145560828e-08 0 7.524566145560827e-08 0.00021 7.525566145560827e-08 0 7.525566145560827e-08 0 7.526566145560827e-08 0.00021 7.527566145560827e-08 0 7.527566145560827e-08 0 7.528566145560827e-08 0.00021 7.529566145560826e-08 0 7.540163978076842e-08 0 7.541163978076842e-08 0.00021 7.542163978076842e-08 0 7.542163978076842e-08 0 7.543163978076842e-08 0.00021 7.544163978076842e-08 0 7.544163978076842e-08 0 7.545163978076842e-08 0.00021 7.546163978076841e-08 0 7.546773734964171e-08 0 7.547773734964171e-08 0.00021 7.548773734964171e-08 0 7.548773734964171e-08 0 7.54977373496417e-08 0.00021 7.55077373496417e-08 0 7.55077373496417e-08 0 7.55177373496417e-08 0.00021 7.55277373496417e-08 0 7.55277373496417e-08 0 7.55377373496417e-08 0.00021 7.55477373496417e-08 0 7.55477373496417e-08 0 7.55577373496417e-08 0.00021 7.556773734964169e-08 0 7.556773734964169e-08 0 7.557773734964169e-08 0.00021 7.558773734964169e-08 0 7.561377654511192e-08 0 7.562377654511192e-08 0.00021 7.563377654511191e-08 0 7.563377654511191e-08 0 7.564377654511191e-08 0.00021 7.565377654511191e-08 0 7.565377654511191e-08 0 7.566377654511191e-08 0.00021 7.56737765451119e-08 0 7.56737765451119e-08 0 7.56837765451119e-08 0.00021 7.56937765451119e-08 0 7.571890293618684e-08 0 7.572890293618684e-08 0.00021 7.573890293618683e-08 0 7.573890293618683e-08 0 7.574890293618683e-08 0.00021 7.575890293618683e-08 0 7.575890293618683e-08 0 7.576890293618683e-08 0.00021 7.577890293618683e-08 0 7.577890293618683e-08 0 7.578890293618682e-08 0.00021 7.579890293618682e-08 0 7.580658385394623e-08 0 7.581658385394622e-08 0.00021 7.582658385394622e-08 0 7.582658385394622e-08 0 7.583658385394622e-08 0.00021 7.584658385394622e-08 0 7.584658385394622e-08 0 7.585658385394622e-08 0.00021 7.586658385394621e-08 0 7.586658385394621e-08 0 7.587658385394621e-08 0.00021 7.588658385394621e-08 0 7.594228720443892e-08 0 7.595228720443892e-08 0.00021 7.596228720443892e-08 0 7.597689506354304e-08 0 7.598689506354304e-08 0.00021 7.599689506354304e-08 0 7.602714610893518e-08 0 7.603714610893518e-08 0.00021 7.604714610893518e-08 0 7.604714610893518e-08 0 7.605714610893518e-08 0.00021 7.606714610893518e-08 0 7.611952940260358e-08 0 7.612952940260358e-08 0.00021 7.613952940260358e-08 0 7.613952940260358e-08 0 7.614952940260358e-08 0.00021 7.615952940260357e-08 0 7.615952940260357e-08 0 7.616952940260357e-08 0.00021 7.617952940260357e-08 0 7.627906270845753e-08 0 7.628906270845753e-08 0.00021 7.629906270845752e-08 0 7.629906270845752e-08 0 7.630906270845752e-08 0.00021 7.631906270845752e-08 0 7.632662351585171e-08 0 7.633662351585171e-08 0.00021 7.63466235158517e-08 0 7.63466235158517e-08 0 7.63566235158517e-08 0.00021 7.63666235158517e-08 0 7.63775669828226e-08 0 7.63875669828226e-08 0.00021 7.639756698282259e-08 0 7.639756698282259e-08 0 7.640756698282259e-08 0.00021 7.641756698282259e-08 0 7.641756698282259e-08 0 7.642756698282259e-08 0.00021 7.643756698282259e-08 0 7.643756698282259e-08 0 7.644756698282258e-08 0.00021 7.645756698282258e-08 0 7.645756698282258e-08 0 7.646756698282258e-08 0.00021 7.647756698282258e-08 0 7.647756698282258e-08 0 7.648756698282258e-08 0.00021 7.649756698282257e-08 0 7.649756698282257e-08 0 7.650756698282257e-08 0.00021 7.651756698282257e-08 0 7.651756698282257e-08 0 7.652756698282257e-08 0.00021 7.653756698282257e-08 0 7.653756698282257e-08 0 7.654756698282256e-08 0.00021 7.655756698282256e-08 0 7.656834678844378e-08 0 7.657834678844378e-08 0.00021 7.658834678844378e-08 0 7.664640359771377e-08 0 7.665640359771376e-08 0.00021 7.666640359771376e-08 0 7.666640359771376e-08 0 7.667640359771376e-08 0.00021 7.668640359771376e-08 0 7.669862307064415e-08 0 7.670862307064415e-08 0.00021 7.671862307064415e-08 0 7.671930146819514e-08 0 7.672930146819514e-08 0.00021 7.673930146819514e-08 0 7.675609901368043e-08 0 7.676609901368043e-08 0.00021 7.677609901368043e-08 0 7.677609901368043e-08 0 7.678609901368043e-08 0.00021 7.679609901368043e-08 0 7.679609901368043e-08 0 7.680609901368042e-08 0.00021 7.681609901368042e-08 0 7.682742014149605e-08 0 7.683742014149605e-08 0.00021 7.684742014149605e-08 0 7.688255426346527e-08 0 7.689255426346527e-08 0.00021 7.690255426346526e-08 0 7.69162979213852e-08 0 7.69262979213852e-08 0.00021 7.69362979213852e-08 0 7.69362979213852e-08 0 7.694629792138519e-08 0.00021 7.695629792138519e-08 0 7.695629792138519e-08 0 7.696629792138519e-08 0.00021 7.697629792138519e-08 0 7.70044764581547e-08 0 7.701447645815469e-08 0.00021 7.702447645815469e-08 0 7.702447645815469e-08 0 7.703447645815469e-08 0.00021 7.704447645815469e-08 0 7.704447645815469e-08 0 7.705447645815468e-08 0.00021 7.706447645815468e-08 0 7.707781074698194e-08 0 7.708781074698194e-08 0.00021 7.709781074698194e-08 0 7.709781074698194e-08 0 7.710781074698194e-08 0.00021 7.711781074698193e-08 0 7.711781074698193e-08 0 7.712781074698193e-08 0.00021 7.713781074698193e-08 0 7.725942219118598e-08 0 7.726942219118597e-08 0.00021 7.727942219118597e-08 0 7.727942219118597e-08 0 7.728942219118597e-08 0.00021 7.729942219118597e-08 0 7.729942219118597e-08 0 7.730942219118597e-08 0.00021 7.731942219118597e-08 0 7.732806998608208e-08 0 7.733806998608207e-08 0.00021 7.734806998608207e-08 0 7.734806998608207e-08 0 7.735806998608207e-08 0.00021 7.736806998608207e-08 0 7.736806998608207e-08 0 7.737806998608207e-08 0.00021 7.738806998608206e-08 0 7.738806998608206e-08 0 7.739806998608206e-08 0.00021 7.740806998608206e-08 0 7.740806998608206e-08 0 7.741806998608206e-08 0.00021 7.742806998608206e-08 0 7.743961201303017e-08 0 7.744961201303016e-08 0.00021 7.745961201303016e-08 0 7.745961201303016e-08 0 7.746961201303016e-08 0.00021 7.747961201303016e-08 0 7.747961201303016e-08 0 7.748961201303016e-08 0.00021 7.749961201303015e-08 0 7.749961201303015e-08 0 7.750961201303015e-08 0.00021 7.751961201303015e-08 0 7.751961201303015e-08 0 7.752961201303015e-08 0.00021 7.753961201303015e-08 0 7.753961201303015e-08 0 7.754961201303014e-08 0.00021 7.755961201303014e-08 0 7.755961201303014e-08 0 7.756961201303014e-08 0.00021 7.757961201303014e-08 0 7.759671479469295e-08 0 7.760671479469295e-08 0.00021 7.761671479469295e-08 0 7.767362370557475e-08 0 7.768362370557474e-08 0.00021 7.769362370557474e-08 0 7.771230951599046e-08 0 7.772230951599046e-08 0.00021 7.773230951599046e-08 0 7.773230951599046e-08 0 7.774230951599045e-08 0.00021 7.775230951599045e-08 0 7.775230951599045e-08 0 7.776230951599045e-08 0.00021 7.777230951599045e-08 0 7.777230951599045e-08 0 7.778230951599045e-08 0.00021 7.779230951599044e-08 0 7.782937327386037e-08 0 7.783937327386037e-08 0.00021 7.784937327386036e-08 0 7.784937327386036e-08 0 7.785937327386036e-08 0.00021 7.786937327386036e-08 0 7.79037197915257e-08 0 7.791371979152569e-08 0.00021 7.792371979152569e-08 0 7.792371979152569e-08 0 7.793371979152569e-08 0.00021 7.794371979152569e-08 0 7.794371979152569e-08 0 7.795371979152568e-08 0.00021 7.796371979152568e-08 0 7.796371979152568e-08 0 7.797371979152568e-08 0.00021 7.798371979152568e-08 0 7.799166457328848e-08 0 7.800166457328848e-08 0.00021 7.801166457328848e-08 0 7.801166457328848e-08 0 7.802166457328848e-08 0.00021 7.803166457328847e-08 0 7.803166457328847e-08 0 7.804166457328847e-08 0.00021 7.805166457328847e-08 0 7.805166457328847e-08 0 7.806166457328847e-08 0.00021 7.807166457328847e-08 0 7.807166457328847e-08 0 7.808166457328846e-08 0.00021 7.809166457328846e-08 0 7.809166457328846e-08 0 7.810166457328846e-08 0.00021 7.811166457328846e-08 0 7.811198158053864e-08 0 7.812198158053863e-08 0.00021 7.813198158053863e-08 0 7.813811118834507e-08 0 7.814811118834507e-08 0.00021 7.815811118834506e-08 0 7.823183478873645e-08 0 7.824183478873645e-08 0.00021 7.825183478873645e-08 0 7.827821072614026e-08 0 7.828821072614026e-08 0.00021 7.829821072614026e-08 0 7.829821072614026e-08 0 7.830821072614026e-08 0.00021 7.831821072614026e-08 0 7.839363841992577e-08 0 7.840363841992577e-08 0.00021 7.841363841992577e-08 0 7.841363841992577e-08 0 7.842363841992577e-08 0.00021 7.843363841992577e-08 0 7.851691582181292e-08 0 7.852691582181292e-08 0.00021 7.853691582181292e-08 0 7.853691582181292e-08 0 7.854691582181292e-08 0.00021 7.855691582181291e-08 0 7.855691582181291e-08 0 7.856691582181291e-08 0.00021 7.857691582181291e-08 0 7.861402737270793e-08 0 7.862402737270793e-08 0.00021 7.863402737270792e-08 0 7.863979666293897e-08 0 7.864979666293897e-08 0.00021 7.865979666293897e-08 0 7.871863688999864e-08 0 7.872863688999863e-08 0.00021 7.873863688999863e-08 0 7.873863688999863e-08 0 7.874863688999863e-08 0.00021 7.875863688999863e-08 0 7.883491852151018e-08 0 7.884491852151017e-08 0.00021 7.885491852151017e-08 0 7.88784334150019e-08 0 7.88884334150019e-08 0.00021 7.889843341500189e-08 0 7.892263631681867e-08 0 7.893263631681867e-08 0.00021 7.894263631681867e-08 0 7.899459839965521e-08 0 7.900459839965521e-08 0.00021 7.90145983996552e-08 0 7.90145983996552e-08 0 7.90245983996552e-08 0.00021 7.90345983996552e-08 0 7.90345983996552e-08 0 7.90445983996552e-08 0.00021 7.90545983996552e-08 0 7.90545983996552e-08 0 7.90645983996552e-08 0.00021 7.90745983996552e-08 0 7.90745983996552e-08 0 7.908459839965519e-08 0.00021 7.909459839965519e-08 0 7.914090427652905e-08 0 7.915090427652905e-08 0.00021 7.916090427652905e-08 0 7.916090427652905e-08 0 7.917090427652904e-08 0.00021 7.918090427652904e-08 0 7.918964717780519e-08 0 7.919964717780518e-08 0.00021 7.920964717780518e-08 0 7.920964717780518e-08 0 7.921964717780518e-08 0.00021 7.922964717780518e-08 0 7.926774159531213e-08 0 7.927774159531212e-08 0.00021 7.928774159531212e-08 0 7.928774159531212e-08 0 7.929774159531212e-08 0.00021 7.930774159531212e-08 0 7.936585823812464e-08 0 7.937585823812464e-08 0.00021 7.938585823812463e-08 0 7.940139916914874e-08 0 7.941139916914873e-08 0.00021 7.942139916914873e-08 0 7.951852479061642e-08 0 7.952852479061641e-08 0.00021 7.953852479061641e-08 0 7.954152268354667e-08 0 7.955152268354666e-08 0.00021 7.956152268354666e-08 0 7.961332560630047e-08 0 7.962332560630046e-08 0.00021 7.963332560630046e-08 0 7.967657730549869e-08 0 7.968657730549869e-08 0.00021 7.969657730549869e-08 0 7.969657730549869e-08 0 7.970657730549869e-08 0.00021 7.971657730549868e-08 0 7.971657730549868e-08 0 7.972657730549868e-08 0.00021 7.973657730549868e-08 0 7.974987046777642e-08 0 7.975987046777642e-08 0.00021 7.976987046777642e-08 0 7.97885513819656e-08 0 7.97985513819656e-08 0.00021 7.98085513819656e-08 0 7.981945625660882e-08 0 7.982945625660882e-08 0.00021 7.983945625660882e-08 0 7.983945625660882e-08 0 7.984945625660882e-08 0.00021 7.985945625660882e-08 0 7.985945625660882e-08 0 7.986945625660882e-08 0.00021 7.987945625660881e-08 0 7.987945625660881e-08 0 7.988945625660881e-08 0.00021 7.989945625660881e-08 0 7.989945625660881e-08 0 7.990945625660881e-08 0.00021 7.99194562566088e-08 0 7.99194562566088e-08 0 7.99294562566088e-08 0.00021 7.99394562566088e-08 0 8.002293148662518e-08 0 8.003293148662518e-08 0.00021 8.004293148662518e-08 0 8.006654741242755e-08 0 8.007654741242755e-08 0.00021 8.008654741242755e-08 0 8.008654741242755e-08 0 8.009654741242755e-08 0.00021 8.010654741242754e-08 0 8.014721856446176e-08 0 8.015721856446175e-08 0.00021 8.016721856446175e-08 0 8.016721856446175e-08 0 8.017721856446175e-08 0.00021 8.018721856446175e-08 0 8.018721856446175e-08 0 8.019721856446175e-08 0.00021 8.020721856446175e-08 0 8.020721856446175e-08 0 8.021721856446174e-08 0.00021 8.022721856446174e-08 0 8.026782490056061e-08 0 8.027782490056061e-08 0.00021 8.02878249005606e-08 0 8.02878249005606e-08 0 8.02978249005606e-08 0.00021 8.03078249005606e-08 0 8.03078249005606e-08 0 8.03178249005606e-08 0.00021 8.03278249005606e-08 0 8.033307836148681e-08 0 8.034307836148681e-08 0.00021 8.03530783614868e-08 0 8.03530783614868e-08 0 8.03630783614868e-08 0.00021 8.03730783614868e-08 0 8.042034612742569e-08 0 8.043034612742569e-08 0.00021 8.044034612742569e-08 0 8.044034612742569e-08 0 8.045034612742568e-08 0.00021 8.046034612742568e-08 0 8.046034612742568e-08 0 8.047034612742568e-08 0.00021 8.048034612742568e-08 0 8.05039822948355e-08 0 8.05139822948355e-08 0.00021 8.05239822948355e-08 0 8.05239822948355e-08 0 8.053398229483549e-08 0.00021 8.054398229483549e-08 0 8.054398229483549e-08 0 8.055398229483549e-08 0.00021 8.056398229483549e-08 0 8.056398229483549e-08 0 8.057398229483548e-08 0.00021 8.058398229483548e-08 0 8.058398229483548e-08 0 8.059398229483548e-08 0.00021 8.060398229483548e-08 0 8.060398229483548e-08 0 8.061398229483548e-08 0.00021 8.062398229483548e-08 0 8.062398229483548e-08 0 8.063398229483547e-08 0.00021 8.064398229483547e-08 0 8.067014542326977e-08 0 8.068014542326976e-08 0.00021 8.069014542326976e-08 0 8.069014542326976e-08 0 8.070014542326976e-08 0.00021 8.071014542326976e-08 0 8.071890398068593e-08 0 8.072890398068593e-08 0.00021 8.073890398068593e-08 0 8.073890398068593e-08 0 8.074890398068593e-08 0.00021 8.075890398068593e-08 0 8.079372041174657e-08 0 8.080372041174657e-08 0.00021 8.081372041174657e-08 0 8.082513669768848e-08 0 8.083513669768848e-08 0.00021 8.084513669768848e-08 0 8.086504377569528e-08 0 8.087504377569527e-08 0.00021 8.088504377569527e-08 0 8.088504377569527e-08 0 8.089504377569527e-08 0.00021 8.090504377569527e-08 0 8.090504377569527e-08 0 8.091504377569527e-08 0.00021 8.092504377569527e-08 0 8.092504377569527e-08 0 8.093504377569526e-08 0.00021 8.094504377569526e-08 0 8.10429890837136e-08 0 8.10529890837136e-08 0.00021 8.106298908371359e-08 0 8.107895741247849e-08 0 8.108895741247849e-08 0.00021 8.109895741247849e-08 0 8.115237549563443e-08 0 8.116237549563443e-08 0.00021 8.117237549563442e-08 0 8.132843052426939e-08 0 8.133843052426938e-08 0.00021 8.134843052426938e-08 0 8.134843052426938e-08 0 8.135843052426938e-08 0.00021 8.136843052426938e-08 0 8.136843052426938e-08 0 8.137843052426938e-08 0.00021 8.138843052426937e-08 0 8.140623086063825e-08 0 8.141623086063825e-08 0.00021 8.142623086063825e-08 0 8.144308917802011e-08 0 8.145308917802011e-08 0.00021 8.14630891780201e-08 0 8.148152165876406e-08 0 8.149152165876405e-08 0.00021 8.150152165876405e-08 0 8.153885547936353e-08 0 8.154885547936353e-08 0.00021 8.155885547936353e-08 0 8.155885547936353e-08 0 8.156885547936352e-08 0.00021 8.157885547936352e-08 0 8.158090999297986e-08 0 8.159090999297985e-08 0.00021 8.160090999297985e-08 0 8.1632744357561e-08 0 8.164274435756099e-08 0.00021 8.165274435756099e-08 0 8.165274435756099e-08 0 8.166274435756099e-08 0.00021 8.167274435756099e-08 0 8.16840204681871e-08 0 8.16940204681871e-08 0.00021 8.17040204681871e-08 0 8.17040204681871e-08 0 8.171402046818709e-08 0.00021 8.172402046818709e-08 0 8.172402046818709e-08 0 8.173402046818709e-08 0.00021 8.174402046818709e-08 0 8.18047898670876e-08 0 8.18147898670876e-08 0.00021 8.18247898670876e-08 0 8.184164416604206e-08 0 8.185164416604206e-08 0.00021 8.186164416604206e-08 0 8.186164416604206e-08 0 8.187164416604205e-08 0.00021 8.188164416604205e-08 0 8.192031358295088e-08 0 8.193031358295088e-08 0.00021 8.194031358295088e-08 0 8.195686668263559e-08 0 8.196686668263559e-08 0.00021 8.197686668263559e-08 0 8.200031394252635e-08 0 8.201031394252634e-08 0.00021 8.202031394252634e-08 0 8.204994773383367e-08 0 8.205994773383367e-08 0.00021 8.206994773383366e-08 0 8.207116587062711e-08 0 8.208116587062711e-08 0.00021 8.209116587062711e-08 0 8.214519667606616e-08 0 8.215519667606616e-08 0.00021 8.216519667606615e-08 0 8.216519667606615e-08 0 8.217519667606615e-08 0.00021 8.218519667606615e-08 0 8.218519667606615e-08 0 8.219519667606615e-08 0.00021 8.220519667606615e-08 0 8.222122055310415e-08 0 8.223122055310414e-08 0.00021 8.224122055310414e-08 0 8.224122055310414e-08 0 8.225122055310414e-08 0.00021 8.226122055310414e-08 0 8.226176700887286e-08 0 8.227176700887285e-08 0.00021 8.228176700887285e-08 0 8.237926192482458e-08 0 8.238926192482458e-08 0.00021 8.239926192482457e-08 0 8.24357743347892e-08 0 8.24457743347892e-08 0.00021 8.24557743347892e-08 0 8.248379807063861e-08 0 8.249379807063861e-08 0.00021 8.250379807063861e-08 0 8.259198122979406e-08 0 8.260198122979405e-08 0.00021 8.261198122979405e-08 0 8.261198122979405e-08 0 8.262198122979405e-08 0.00021 8.263198122979405e-08 0 8.264780537799746e-08 0 8.265780537799746e-08 0.00021 8.266780537799746e-08 0 8.273747477132625e-08 0 8.274747477132625e-08 0.00021 8.275747477132624e-08 0 8.275747477132624e-08 0 8.276747477132624e-08 0.00021 8.277747477132624e-08 0 8.280582868087218e-08 0 8.281582868087218e-08 0.00021 8.282582868087218e-08 0 8.282582868087218e-08 0 8.283582868087217e-08 0.00021 8.284582868087217e-08 0 8.288050274084783e-08 0 8.289050274084783e-08 0.00021 8.290050274084783e-08 0 8.290050274084783e-08 0 8.291050274084783e-08 0.00021 8.292050274084782e-08 0 8.292050274084782e-08 0 8.293050274084782e-08 0.00021 8.294050274084782e-08 0 8.294050274084782e-08 0 8.295050274084782e-08 0.00021 8.296050274084782e-08 0 8.298564133287987e-08 0 8.299564133287986e-08 0.00021 8.300564133287986e-08 0 8.300564133287986e-08 0 8.301564133287986e-08 0.00021 8.302564133287986e-08 0 8.302564133287986e-08 0 8.303564133287986e-08 0.00021 8.304564133287985e-08 0 8.304564133287985e-08 0 8.305564133287985e-08 0.00021 8.306564133287985e-08 0 8.306564133287985e-08 0 8.307564133287985e-08 0.00021 8.308564133287985e-08 0 8.308564133287985e-08 0 8.309564133287985e-08 0.00021 8.310564133287984e-08 0 8.310564133287984e-08 0 8.311564133287984e-08 0.00021 8.312564133287984e-08 0 8.313388715427467e-08 0 8.314388715427467e-08 0.00021 8.315388715427467e-08 0 8.328455560659381e-08 0 8.329455560659381e-08 0.00021 8.330455560659381e-08 0 8.330455560659381e-08 0 8.33145556065938e-08 0.00021 8.33245556065938e-08 0 8.33245556065938e-08 0 8.33345556065938e-08 0.00021 8.33445556065938e-08 0 8.33445556065938e-08 0 8.33545556065938e-08 0.00021 8.33645556065938e-08 0 8.33645556065938e-08 0 8.33745556065938e-08 0.00021 8.338455560659379e-08 0 8.338455560659379e-08 0 8.339455560659379e-08 0.00021 8.340455560659379e-08 0 8.340455560659379e-08 0 8.341455560659379e-08 0.00021 8.342455560659379e-08 0 8.343343931128346e-08 0 8.344343931128346e-08 0.00021 8.345343931128346e-08 0 8.350240027872364e-08 0 8.351240027872364e-08 0.00021 8.352240027872364e-08 0 8.355238871718171e-08 0 8.35623887171817e-08 0.00021 8.35723887171817e-08 0 8.35723887171817e-08 0 8.35823887171817e-08 0.00021 8.35923887171817e-08 0 8.35923887171817e-08 0 8.36023887171817e-08 0.00021 8.36123887171817e-08 0 8.36188045757722e-08 0 8.36288045757722e-08 0.00021 8.36388045757722e-08 0 8.365359000225584e-08 0 8.366359000225584e-08 0.00021 8.367359000225584e-08 0 8.367359000225584e-08 0 8.368359000225584e-08 0.00021 8.369359000225584e-08 0 8.369359000225584e-08 0 8.370359000225584e-08 0.00021 8.371359000225583e-08 0 8.371359000225583e-08 0 8.372359000225583e-08 0.00021 8.373359000225583e-08 0 8.373359000225583e-08 0 8.374359000225583e-08 0.00021 8.375359000225583e-08 0 8.375359000225583e-08 0 8.376359000225582e-08 0.00021 8.377359000225582e-08 0 8.377359000225582e-08 0 8.378359000225582e-08 0.00021 8.379359000225582e-08 0 8.381480418183513e-08 0 8.382480418183513e-08 0.00021 8.383480418183513e-08 0 8.383480418183513e-08 0 8.384480418183513e-08 0.00021 8.385480418183513e-08 0 8.393936166939614e-08 0 8.394936166939614e-08 0.00021 8.395936166939614e-08 0 8.39865346729795e-08 0 8.39965346729795e-08 0.00021 8.400653467297949e-08 0 8.400802487922606e-08 0 8.401802487922606e-08 0.00021 8.402802487922606e-08 0 8.402802487922606e-08 0 8.403802487922606e-08 0.00021 8.404802487922606e-08 0 8.404802487922606e-08 0 8.405802487922605e-08 0.00021 8.406802487922605e-08 0 8.412484444755053e-08 0 8.413484444755053e-08 0.00021 8.414484444755052e-08 0 8.414484444755052e-08 0 8.415484444755052e-08 0.00021 8.416484444755052e-08 0 8.416484444755052e-08 0 8.417484444755052e-08 0.00021 8.418484444755052e-08 0 8.418484444755052e-08 0 8.419484444755051e-08 0.00021 8.420484444755051e-08 0 8.420484444755051e-08 0 8.421484444755051e-08 0.00021 8.422484444755051e-08 0 8.423572407658261e-08 0 8.424572407658261e-08 0.00021 8.42557240765826e-08 0 8.430065852430704e-08 0 8.431065852430704e-08 0.00021 8.432065852430704e-08 0 8.436181956533253e-08 0 8.437181956533253e-08 0.00021 8.438181956533253e-08 0 8.441020397428724e-08 0 8.442020397428724e-08 0.00021 8.443020397428724e-08 0 8.443020397428724e-08 0 8.444020397428724e-08 0.00021 8.445020397428723e-08 0 8.445020397428723e-08 0 8.446020397428723e-08 0.00021 8.447020397428723e-08 0 8.447519076428748e-08 0 8.448519076428748e-08 0.00021 8.449519076428748e-08 0 8.449519076428748e-08 0 8.450519076428748e-08 0.00021 8.451519076428748e-08 0 8.458500720977439e-08 0 8.459500720977439e-08 0.00021 8.460500720977439e-08 0 8.464983580687804e-08 0 8.465983580687804e-08 0.00021 8.466983580687804e-08 0 8.474855550651022e-08 0 8.475855550651022e-08 0.00021 8.476855550651021e-08 0 8.479512909811278e-08 0 8.480512909811278e-08 0.00021 8.481512909811278e-08 0 8.483296223707969e-08 0 8.484296223707969e-08 0.00021 8.485296223707968e-08 0 8.48927493603223e-08 0 8.49027493603223e-08 0.00021 8.49127493603223e-08 0 8.49127493603223e-08 0 8.49227493603223e-08 0.00021 8.49327493603223e-08 0 8.49327493603223e-08 0 8.49427493603223e-08 0.00021 8.495274936032229e-08 0 8.495274936032229e-08 0 8.496274936032229e-08 0.00021 8.497274936032229e-08 0 8.497274936032229e-08 0 8.498274936032229e-08 0.00021 8.499274936032229e-08 0 8.499274936032229e-08 0 8.500274936032228e-08 0.00021 8.501274936032228e-08 0 8.501274936032228e-08 0 8.502274936032228e-08 0.00021 8.503274936032228e-08 0 8.503274936032228e-08 0 8.504274936032228e-08 0.00021 8.505274936032227e-08 0 8.512572516301905e-08 0 8.513572516301905e-08 0.00021 8.514572516301904e-08 0 8.514572516301904e-08 0 8.515572516301904e-08 0.00021 8.516572516301904e-08 0 8.516572516301904e-08 0 8.517572516301904e-08 0.00021 8.518572516301904e-08 0 8.519074814362781e-08 0 8.520074814362781e-08 0.00021 8.521074814362781e-08 0 8.522975628635015e-08 0 8.523975628635014e-08 0.00021 8.524975628635014e-08 0 8.525860897894943e-08 0 8.526860897894942e-08 0.00021 8.527860897894942e-08 0 8.529610212419628e-08 0 8.530610212419628e-08 0.00021 8.531610212419628e-08 0 8.531610212419628e-08 0 8.532610212419628e-08 0.00021 8.533610212419628e-08 0 8.533610212419628e-08 0 8.534610212419627e-08 0.00021 8.535610212419627e-08 0 8.535610212419627e-08 0 8.536610212419627e-08 0.00021 8.537610212419627e-08 0 8.537610212419627e-08 0 8.538610212419627e-08 0.00021 8.539610212419626e-08 0 8.546659195819475e-08 0 8.547659195819475e-08 0.00021 8.548659195819475e-08 0 8.548659195819475e-08 0 8.549659195819475e-08 0.00021 8.550659195819474e-08 0 8.550659195819474e-08 0 8.551659195819474e-08 0.00021 8.552659195819474e-08 0 8.552659195819474e-08 0 8.553659195819474e-08 0.00021 8.554659195819474e-08 0 8.5631476273873e-08 0 8.5641476273873e-08 0.00021 8.5651476273873e-08 0 8.566006917153614e-08 0 8.567006917153613e-08 0.00021 8.568006917153613e-08 0 8.568006917153613e-08 0 8.569006917153613e-08 0.00021 8.570006917153613e-08 0 8.570006917153613e-08 0 8.571006917153613e-08 0.00021 8.572006917153612e-08 0 8.572006917153612e-08 0 8.573006917153612e-08 0.00021 8.574006917153612e-08 0 8.575334173872592e-08 0 8.576334173872592e-08 0.00021 8.577334173872592e-08 0 8.577527713354656e-08 0 8.578527713354656e-08 0.00021 8.579527713354656e-08 0 8.585773660281347e-08 0 8.586773660281346e-08 0.00021 8.587773660281346e-08 0 8.587773660281346e-08 0 8.588773660281346e-08 0.00021 8.589773660281346e-08 0 8.589773660281346e-08 0 8.590773660281346e-08 0.00021 8.591773660281345e-08 0 8.591773660281345e-08 0 8.592773660281345e-08 0.00021 8.593773660281345e-08 0 8.596322187701594e-08 0 8.597322187701593e-08 0.00021 8.598322187701593e-08 0 8.601301047708481e-08 0 8.602301047708481e-08 0.00021 8.60330104770848e-08 0 8.60335151871426e-08 0 8.60435151871426e-08 0.00021 8.60535151871426e-08 0 8.60535151871426e-08 0 8.60635151871426e-08 0.00021 8.60735151871426e-08 0 8.624803446588927e-08 0 8.625803446588927e-08 0.00021 8.626803446588926e-08 0 8.626803446588926e-08 0 8.627803446588926e-08 0.00021 8.628803446588926e-08 0 8.628803446588926e-08 0 8.629803446588926e-08 0.00021 8.630803446588926e-08 0 8.631166663688101e-08 0 8.6321666636881e-08 0.00021 8.6331666636881e-08 0 8.6331666636881e-08 0 8.6341666636881e-08 0.00021 8.6351666636881e-08 0 8.638828516925474e-08 0 8.639828516925474e-08 0.00021 8.640828516925474e-08 0 8.640828516925474e-08 0 8.641828516925473e-08 0.00021 8.642828516925473e-08 0 8.644392663680489e-08 0 8.645392663680489e-08 0.00021 8.646392663680488e-08 0 8.646392663680488e-08 0 8.647392663680488e-08 0.00021 8.648392663680488e-08 0 8.651537749965179e-08 0 8.652537749965179e-08 0.00021 8.653537749965178e-08 0 8.653537749965178e-08 0 8.654537749965178e-08 0.00021 8.655537749965178e-08 0 8.660530504494777e-08 0 8.661530504494777e-08 0.00021 8.662530504494777e-08 0 8.662530504494777e-08 0 8.663530504494777e-08 0.00021 8.664530504494776e-08 0 8.664530504494776e-08 0 8.665530504494776e-08 0.00021 8.666530504494776e-08 0 8.666530504494776e-08 0 8.667530504494776e-08 0.00021 8.668530504494776e-08 0 8.668530504494776e-08 0 8.669530504494775e-08 0.00021 8.670530504494775e-08 0 8.670530504494775e-08 0 8.671530504494775e-08 0.00021 8.672530504494775e-08 0 8.673404198243037e-08 0 8.674404198243037e-08 0.00021 8.675404198243037e-08 0 8.676444385269146e-08 0 8.677444385269146e-08 0.00021 8.678444385269146e-08 0 8.678444385269146e-08 0 8.679444385269145e-08 0.00021 8.680444385269145e-08 0 8.680444385269145e-08 0 8.681444385269145e-08 0.00021 8.682444385269145e-08 0 8.682444385269145e-08 0 8.683444385269145e-08 0.00021 8.684444385269144e-08 0 8.685494792384005e-08 0 8.686494792384005e-08 0.00021 8.687494792384005e-08 0 8.689268496932399e-08 0 8.690268496932399e-08 0.00021 8.691268496932399e-08 0 8.691268496932399e-08 0 8.692268496932399e-08 0.00021 8.693268496932398e-08 0 8.693268496932398e-08 0 8.694268496932398e-08 0.00021 8.695268496932398e-08 0 8.695268496932398e-08 0 8.696268496932398e-08 0.00021 8.697268496932398e-08 0 8.697268496932398e-08 0 8.698268496932397e-08 0.00021 8.699268496932397e-08 0 8.699268496932397e-08 0 8.700268496932397e-08 0.00021 8.701268496932397e-08 0 8.701268496932397e-08 0 8.702268496932397e-08 0.00021 8.703268496932397e-08 0 8.7078872953275e-08 0 8.7088872953275e-08 0.00021 8.7098872953275e-08 0 8.7098872953275e-08 0 8.7108872953275e-08 0.00021 8.711887295327499e-08 0 8.711887295327499e-08 0 8.712887295327499e-08 0.00021 8.713887295327499e-08 0 8.7140024349279e-08 0 8.7150024349279e-08 0.00021 8.7160024349279e-08 0 8.718581493781645e-08 0 8.719581493781645e-08 0.00021 8.720581493781645e-08 0 8.725789141226974e-08 0 8.726789141226974e-08 0.00021 8.727789141226974e-08 0 8.727789141226974e-08 0 8.728789141226974e-08 0.00021 8.729789141226974e-08 0 8.729789141226974e-08 0 8.730789141226973e-08 0.00021 8.731789141226973e-08 0 8.731789141226973e-08 0 8.732789141226973e-08 0.00021 8.733789141226973e-08 0 8.742237204864141e-08 0 8.743237204864141e-08 0.00021 8.74423720486414e-08 0 8.746280953874051e-08 0 8.747280953874051e-08 0.00021 8.748280953874051e-08 0 8.75089702865559e-08 0 8.751897028655589e-08 0.00021 8.752897028655589e-08 0 8.761788118386466e-08 0 8.762788118386466e-08 0.00021 8.763788118386466e-08 0 8.763788118386466e-08 0 8.764788118386466e-08 0.00021 8.765788118386466e-08 0 8.766210493019523e-08 0 8.767210493019522e-08 0.00021 8.768210493019522e-08 0 8.768210493019522e-08 0 8.769210493019522e-08 0.00021 8.770210493019522e-08 0 8.772828751946376e-08 0 8.773828751946376e-08 0.00021 8.774828751946376e-08 0 8.780467883047387e-08 0 8.781467883047387e-08 0.00021 8.782467883047387e-08 0 8.782622404272319e-08 0 8.783622404272319e-08 0.00021 8.784622404272319e-08 0 8.791999917373209e-08 0 8.792999917373209e-08 0.00021 8.793999917373208e-08 0 8.793999917373208e-08 0 8.794999917373208e-08 0.00021 8.795999917373208e-08 0 8.795999917373208e-08 0 8.796999917373208e-08 0.00021 8.797999917373208e-08 0 8.797999917373208e-08 0 8.798999917373207e-08 0.00021 8.799999917373207e-08 0 8.799999917373207e-08 0 8.800999917373207e-08 0.00021 8.801999917373207e-08 0 8.801999917373207e-08 0 8.802999917373207e-08 0.00021 8.803999917373207e-08 0 8.803999917373207e-08 0 8.804999917373206e-08 0.00021 8.805999917373206e-08 0 8.811608929772188e-08 0 8.812608929772187e-08 0.00021 8.813608929772187e-08 0 8.815463623482322e-08 0 8.816463623482322e-08 0.00021 8.817463623482322e-08 0 8.820862268414118e-08 0 8.821862268414118e-08 0.00021 8.822862268414117e-08 0 8.825726524742591e-08 0 8.826726524742591e-08 0.00021 8.82772652474259e-08 0 8.82772652474259e-08 0 8.82872652474259e-08 0.00021 8.82972652474259e-08 0 8.835030800634421e-08 0 8.836030800634421e-08 0.00021 8.83703080063442e-08 0 8.83703080063442e-08 0 8.83803080063442e-08 0.00021 8.83903080063442e-08 0 8.841584530482518e-08 0 8.842584530482518e-08 0.00021 8.843584530482518e-08 0 8.844496683699744e-08 0 8.845496683699744e-08 0.00021 8.846496683699743e-08 0 8.846496683699743e-08 0 8.847496683699743e-08 0.00021 8.848496683699743e-08 0 8.85301009534381e-08 0 8.85401009534381e-08 0.00021 8.85501009534381e-08 0 8.856965624834317e-08 0 8.857965624834316e-08 0.00021 8.858965624834316e-08 0 8.863626334948229e-08 0 8.864626334948229e-08 0.00021 8.865626334948228e-08 0 8.873470243587312e-08 0 8.874470243587312e-08 0.00021 8.875470243587312e-08 0 8.877891863078898e-08 0 8.878891863078898e-08 0.00021 8.879891863078898e-08 0 8.884612578911214e-08 0 8.885612578911213e-08 0.00021 8.886612578911213e-08 0 8.887645008129773e-08 0 8.888645008129773e-08 0.00021 8.889645008129773e-08 0 8.891239955539683e-08 0 8.892239955539683e-08 0.00021 8.893239955539683e-08 0 8.894643219958738e-08 0 8.895643219958738e-08 0.00021 8.896643219958738e-08 0 8.896643219958738e-08 0 8.897643219958737e-08 0.00021 8.898643219958737e-08 0 8.89890955912236e-08 0 8.89990955912236e-08 0.00021 8.90090955912236e-08 0 8.90090955912236e-08 0 8.90190955912236e-08 0.00021 8.90290955912236e-08 0 8.90290955912236e-08 0 8.903909559122359e-08 0.00021 8.904909559122359e-08 0 8.906199502471912e-08 0 8.907199502471912e-08 0.00021 8.908199502471912e-08 0 8.908199502471912e-08 0 8.909199502471912e-08 0.00021 8.910199502471912e-08 0 8.91249699545441e-08 0 8.91349699545441e-08 0.00021 8.91449699545441e-08 0 8.91449699545441e-08 0 8.91549699545441e-08 0.00021 8.91649699545441e-08 0 8.921799447737271e-08 0 8.922799447737271e-08 0.00021 8.923799447737271e-08 0 8.923983692865742e-08 0 8.924983692865742e-08 0.00021 8.925983692865742e-08 0 8.93138895658692e-08 0 8.93238895658692e-08 0.00021 8.93338895658692e-08 0 8.937708761030925e-08 0 8.938708761030925e-08 0.00021 8.939708761030925e-08 0 8.94152612301468e-08 0 8.94252612301468e-08 0.00021 8.943526123014679e-08 0 8.943526123014679e-08 0 8.944526123014679e-08 0.00021 8.945526123014679e-08 0 8.946025800923448e-08 0 8.947025800923447e-08 0.00021 8.948025800923447e-08 0 8.948987804624268e-08 0 8.949987804624267e-08 0.00021 8.950987804624267e-08 0 8.950987804624267e-08 0 8.951987804624267e-08 0.00021 8.952987804624267e-08 0 8.955920972447343e-08 0 8.956920972447342e-08 0.00021 8.957920972447342e-08 0 8.957920972447342e-08 0 8.958920972447342e-08 0.00021 8.959920972447342e-08 0 8.959920972447342e-08 0 8.960920972447342e-08 0.00021 8.961920972447341e-08 0 8.961920972447341e-08 0 8.962920972447341e-08 0.00021 8.963920972447341e-08 0 8.963920972447341e-08 0 8.964920972447341e-08 0.00021 8.965920972447341e-08 0 8.965920972447341e-08 0 8.96692097244734e-08 0.00021 8.96792097244734e-08 0 8.96792097244734e-08 0 8.96892097244734e-08 0.00021 8.96992097244734e-08 0 8.96992097244734e-08 0 8.97092097244734e-08 0.00021 8.97192097244734e-08 0 8.97219060608636e-08 0 8.97319060608636e-08 0.00021 8.974190606086359e-08 0 8.982123957516516e-08 0 8.983123957516516e-08 0.00021 8.984123957516516e-08 0 8.984123957516516e-08 0 8.985123957516516e-08 0.00021 8.986123957516516e-08 0 8.986123957516516e-08 0 8.987123957516515e-08 0.00021 8.988123957516515e-08 0 8.988123957516515e-08 0 8.989123957516515e-08 0.00021 8.990123957516515e-08 0 8.99578015363171e-08 0 8.99678015363171e-08 0.00021 8.99778015363171e-08 0 9.002384115158149e-08 0 9.003384115158149e-08 0.00021 9.004384115158148e-08 0 9.007729310566629e-08 0 9.008729310566628e-08 0.00021 9.009729310566628e-08 0 9.013392710523502e-08 0 9.014392710523502e-08 0.00021 9.015392710523502e-08 0 9.018616320245274e-08 0 9.019616320245274e-08 0.00021 9.020616320245274e-08 0 9.020616320245274e-08 0 9.021616320245273e-08 0.00021 9.022616320245273e-08 0 9.025880053100442e-08 0 9.026880053100441e-08 0.00021 9.027880053100441e-08 0 9.028065287674643e-08 0 9.029065287674643e-08 0.00021 9.030065287674643e-08 0 9.030380805764077e-08 0 9.031380805764077e-08 0.00021 9.032380805764076e-08 0 9.032380805764076e-08 0 9.033380805764076e-08 0.00021 9.034380805764076e-08 0 9.034380805764076e-08 0 9.035380805764076e-08 0.00021 9.036380805764076e-08 0 9.036380805764076e-08 0 9.037380805764075e-08 0.00021 9.038380805764075e-08 0 9.038380805764075e-08 0 9.039380805764075e-08 0.00021 9.040380805764075e-08 0 9.040380805764075e-08 0 9.041380805764075e-08 0.00021 9.042380805764075e-08 0 9.042380805764075e-08 0 9.043380805764074e-08 0.00021 9.044380805764074e-08 0 9.045815371932677e-08 0 9.046815371932677e-08 0.00021 9.047815371932677e-08 0 9.047815371932677e-08 0 9.048815371932676e-08 0.00021 9.049815371932676e-08 0 9.049821400616509e-08 0 9.050821400616509e-08 0.00021 9.051821400616509e-08 0 9.05263398579725e-08 0 9.053633985797249e-08 0.00021 9.054633985797249e-08 0 9.054633985797249e-08 0 9.055633985797249e-08 0.00021 9.056633985797249e-08 0 9.056633985797249e-08 0 9.057633985797249e-08 0.00021 9.058633985797248e-08 0 9.058633985797248e-08 0 9.059633985797248e-08 0.00021 9.060633985797248e-08 0 9.060633985797248e-08 0 9.061633985797248e-08 0.00021 9.062633985797248e-08 0 9.062633985797248e-08 0 9.063633985797247e-08 0.00021 9.064633985797247e-08 0 9.064633985797247e-08 0 9.065633985797247e-08 0.00021 9.066633985797247e-08 0 9.066633985797247e-08 0 9.067633985797247e-08 0.00021 9.068633985797246e-08 0 9.068633985797246e-08 0 9.069633985797246e-08 0.00021 9.070633985797246e-08 0 9.070633985797246e-08 0 9.071633985797246e-08 0.00021 9.072633985797246e-08 0 9.072633985797246e-08 0 9.073633985797246e-08 0.00021 9.074633985797245e-08 0 9.074633985797245e-08 0 9.075633985797245e-08 0.00021 9.076633985797245e-08 0 9.076633985797245e-08 0 9.077633985797245e-08 0.00021 9.078633985797245e-08 0 9.078633985797245e-08 0 9.079633985797244e-08 0.00021 9.080633985797244e-08 0 9.080633985797244e-08 0 9.081633985797244e-08 0.00021 9.082633985797244e-08 0 9.082633985797244e-08 0 9.083633985797244e-08 0.00021 9.084633985797243e-08 0 9.084633985797243e-08 0 9.085633985797243e-08 0.00021 9.086633985797243e-08 0 9.086633985797243e-08 0 9.087633985797243e-08 0.00021 9.088633985797243e-08 0 9.088633985797243e-08 0 9.089633985797243e-08 0.00021 9.090633985797242e-08 0 9.090633985797242e-08 0 9.091633985797242e-08 0.00021 9.092633985797242e-08 0 9.106376459087137e-08 0 9.107376459087137e-08 0.00021 9.108376459087137e-08 0 9.108376459087137e-08 0 9.109376459087136e-08 0.00021 9.110376459087136e-08 0 9.111394244552615e-08 0 9.112394244552615e-08 0.00021 9.113394244552615e-08 0 9.113766893610718e-08 0 9.114766893610717e-08 0.00021 9.115766893610717e-08 0 9.118164595300612e-08 0 9.119164595300612e-08 0.00021 9.120164595300612e-08 0 9.120164595300612e-08 0 9.121164595300612e-08 0.00021 9.122164595300612e-08 0 9.123522367866012e-08 0 9.124522367866012e-08 0.00021 9.125522367866012e-08 0 9.125522367866012e-08 0 9.126522367866011e-08 0.00021 9.127522367866011e-08 0 9.129324681622322e-08 0 9.130324681622322e-08 0.00021 9.131324681622322e-08 0 9.131324681622322e-08 0 9.132324681622322e-08 0.00021 9.133324681622322e-08 0 9.133324681622322e-08 0 9.134324681622321e-08 0.00021 9.135324681622321e-08 0 9.143689271486692e-08 0 9.144689271486692e-08 0.00021 9.145689271486692e-08 0 9.14786863263864e-08 0 9.14886863263864e-08 0.00021 9.14986863263864e-08 0 9.150089753625078e-08 0 9.151089753625078e-08 0.00021 9.152089753625077e-08 0 9.153019225253747e-08 0 9.154019225253747e-08 0.00021 9.155019225253746e-08 0 9.155019225253746e-08 0 9.156019225253746e-08 0.00021 9.157019225253746e-08 0 9.163615336313389e-08 0 9.164615336313389e-08 0.00021 9.165615336313389e-08 0 9.165615336313389e-08 0 9.166615336313388e-08 0.00021 9.167615336313388e-08 0 9.167615336313388e-08 0 9.168615336313388e-08 0.00021 9.169615336313388e-08 0 9.169615336313388e-08 0 9.170615336313388e-08 0.00021 9.171615336313388e-08 0 9.178113676565897e-08 0 9.179113676565896e-08 0.00021 9.180113676565896e-08 0 9.182837608603939e-08 0 9.183837608603939e-08 0.00021 9.184837608603939e-08 0 9.184837608603939e-08 0 9.185837608603939e-08 0.00021 9.186837608603938e-08 0 9.18807262251124e-08 0 9.18907262251124e-08 0.00021 9.19007262251124e-08 0 9.19020904161583e-08 0 9.19120904161583e-08 0.00021 9.19220904161583e-08 0 9.19220904161583e-08 0 9.19320904161583e-08 0.00021 9.19420904161583e-08 0 9.202418990587578e-08 0 9.203418990587578e-08 0.00021 9.204418990587578e-08 0 9.205676049524063e-08 0 9.206676049524063e-08 0.00021 9.207676049524063e-08 0 9.21726355293467e-08 0 9.21826355293467e-08 0.00021 9.21926355293467e-08 0 9.21926355293467e-08 0 9.22026355293467e-08 0.00021 9.22126355293467e-08 0 9.229626852300641e-08 0 9.230626852300641e-08 0.00021 9.23162685230064e-08 0 9.23162685230064e-08 0 9.23262685230064e-08 0.00021 9.23362685230064e-08 0 9.23362685230064e-08 0 9.23462685230064e-08 0.00021 9.23562685230064e-08 0 9.237901560036718e-08 0 9.238901560036718e-08 0.00021 9.239901560036718e-08 0 9.24657467220198e-08 0 9.24757467220198e-08 0.00021 9.24857467220198e-08 0 9.25325473707543e-08 0 9.25425473707543e-08 0.00021 9.25525473707543e-08 0 9.258939452522502e-08 0 9.259939452522502e-08 0.00021 9.260939452522502e-08 0 9.261356184355962e-08 0 9.262356184355961e-08 0.00021 9.263356184355961e-08 0 9.266561130491898e-08 0 9.267561130491898e-08 0.00021 9.268561130491898e-08 0 9.268561130491898e-08 0 9.269561130491897e-08 0.00021 9.270561130491897e-08 0 9.270561130491897e-08 0 9.271561130491897e-08 0.00021 9.272561130491897e-08 0 9.272561130491897e-08 0 9.273561130491897e-08 0.00021 9.274561130491896e-08 0 9.274561130491896e-08 0 9.275561130491896e-08 0.00021 9.276561130491896e-08 0 9.276561130491896e-08 0 9.277561130491896e-08 0.00021 9.278561130491896e-08 0 9.278561130491896e-08 0 9.279561130491895e-08 0.00021 9.280561130491895e-08 0 9.280561130491895e-08 0 9.281561130491895e-08 0.00021 9.282561130491895e-08 0 9.284513383482273e-08 0 9.285513383482273e-08 0.00021 9.286513383482273e-08 0 9.286513383482273e-08 0 9.287513383482272e-08 0.00021 9.288513383482272e-08 0 9.288513383482272e-08 0 9.289513383482272e-08 0.00021 9.290513383482272e-08 0 9.292042761190624e-08 0 9.293042761190624e-08 0.00021 9.294042761190623e-08 0 9.294042761190623e-08 0 9.295042761190623e-08 0.00021 9.296042761190623e-08 0 9.296042761190623e-08 0 9.297042761190623e-08 0.00021 9.298042761190623e-08 0 9.299764593081118e-08 0 9.300764593081118e-08 0.00021 9.301764593081118e-08 0 9.301886123939286e-08 0 9.302886123939286e-08 0.00021 9.303886123939286e-08 0 9.303886123939286e-08 0 9.304886123939286e-08 0.00021 9.305886123939286e-08 0 9.306584256178905e-08 0 9.307584256178905e-08 0.00021 9.308584256178904e-08 0 9.308584256178904e-08 0 9.309584256178904e-08 0.00021 9.310584256178904e-08 0 9.311676333215129e-08 0 9.312676333215129e-08 0.00021 9.313676333215129e-08 0 9.31464575719445e-08 0 9.31564575719445e-08 0.00021 9.31664575719445e-08 0 9.316707188719913e-08 0 9.317707188719912e-08 0.00021 9.318707188719912e-08 0 9.319929003464658e-08 0 9.320929003464658e-08 0.00021 9.321929003464657e-08 0 9.322101257130154e-08 0 9.323101257130154e-08 0.00021 9.324101257130154e-08 0 9.324101257130154e-08 0 9.325101257130154e-08 0.00021 9.326101257130154e-08 0 9.326101257130154e-08 0 9.327101257130153e-08 0.00021 9.328101257130153e-08 0 9.328101257130153e-08 0 9.329101257130153e-08 0.00021 9.330101257130153e-08 0 9.330101257130153e-08 0 9.331101257130153e-08 0.00021 9.332101257130152e-08 0 9.332101257130152e-08 0 9.333101257130152e-08 0.00021 9.334101257130152e-08 0 9.334101257130152e-08 0 9.335101257130152e-08 0.00021 9.336101257130152e-08 0 9.336101257130152e-08 0 9.337101257130151e-08 0.00021 9.338101257130151e-08 0 9.338101257130151e-08 0 9.339101257130151e-08 0.00021 9.340101257130151e-08 0 9.353861606408291e-08 0 9.354861606408291e-08 0.00021 9.355861606408291e-08 0 9.355861606408291e-08 0 9.35686160640829e-08 0.00021 9.35786160640829e-08 0 9.35786160640829e-08 0 9.35886160640829e-08 0.00021 9.35986160640829e-08 0 9.35986160640829e-08 0 9.36086160640829e-08 0.00021 9.36186160640829e-08 0 9.3719968552286e-08 0 9.372996855228599e-08 0.00021 9.373996855228599e-08 0 9.373996855228599e-08 0 9.374996855228599e-08 0.00021 9.375996855228599e-08 0 9.377368625366289e-08 0 9.378368625366289e-08 0.00021 9.379368625366289e-08 0 9.38521966954894e-08 0 9.38621966954894e-08 0.00021 9.38721966954894e-08 0 9.38721966954894e-08 0 9.38821966954894e-08 0.00021 9.38921966954894e-08 0 9.38921966954894e-08 0 9.39021966954894e-08 0.00021 9.391219669548939e-08 0 9.391219669548939e-08 0 9.392219669548939e-08 0.00021 9.393219669548939e-08 0 9.393219669548939e-08 0 9.394219669548939e-08 0.00021 9.395219669548939e-08 0 9.395219669548939e-08 0 9.396219669548938e-08 0.00021 9.397219669548938e-08 0 9.403603320652349e-08 0 9.404603320652349e-08 0.00021 9.405603320652349e-08 0 9.405603320652349e-08 0 9.406603320652348e-08 0.00021 9.407603320652348e-08 0 9.408406798344389e-08 0 9.409406798344388e-08 0.00021 9.410406798344388e-08 0 9.414853813288831e-08 0 9.415853813288831e-08 0.00021 9.41685381328883e-08 0 9.417880306121046e-08 0 9.418880306121046e-08 0.00021 9.419880306121046e-08 0 9.419880306121046e-08 0 9.420880306121046e-08 0.00021 9.421880306121046e-08 0 9.423376459001104e-08 0 9.424376459001104e-08 0.00021 9.425376459001104e-08 0 9.432007708025404e-08 0 9.433007708025404e-08 0.00021 9.434007708025404e-08 0 9.434414809600648e-08 0 9.435414809600648e-08 0.00021 9.436414809600648e-08 0 9.438542454450058e-08 0 9.439542454450058e-08 0.00021 9.440542454450058e-08 0 9.44629167796495e-08 0 9.447291677964949e-08 0.00021 9.448291677964949e-08 0 9.448600479700614e-08 0 9.449600479700614e-08 0.00021 9.450600479700614e-08 0 9.451295341342473e-08 0 9.452295341342473e-08 0.00021 9.453295341342473e-08 0 9.454457973886929e-08 0 9.455457973886929e-08 0.00021 9.456457973886928e-08 0 9.456460337385703e-08 0 9.457460337385702e-08 0.00021 9.458460337385702e-08 0 9.459092659306023e-08 0 9.460092659306023e-08 0.00021 9.461092659306023e-08 0 9.461092659306023e-08 0 9.462092659306022e-08 0.00021 9.463092659306022e-08 0 9.463092659306022e-08 0 9.464092659306022e-08 0.00021 9.465092659306022e-08 0 9.465092659306022e-08 0 9.466092659306022e-08 0.00021 9.467092659306021e-08 0 9.467092659306021e-08 0 9.468092659306021e-08 0.00021 9.469092659306021e-08 0 9.469092659306021e-08 0 9.470092659306021e-08 0.00021 9.47109265930602e-08 0 9.47109265930602e-08 0 9.47209265930602e-08 0.00021 9.47309265930602e-08 0 9.47309265930602e-08 0 9.47409265930602e-08 0.00021 9.47509265930602e-08 0 9.47509265930602e-08 0 9.47609265930602e-08 0.00021 9.47709265930602e-08 0 9.47709265930602e-08 0 9.478092659306019e-08 0.00021 9.479092659306019e-08 0 9.479092659306019e-08 0 9.480092659306019e-08 0.00021 9.481092659306019e-08 0 9.481092659306019e-08 0 9.482092659306019e-08 0.00021 9.483092659306018e-08 0 9.483092659306018e-08 0 9.484092659306018e-08 0.00021 9.485092659306018e-08 0 9.485092659306018e-08 0 9.486092659306018e-08 0.00021 9.487092659306018e-08 0 9.487092659306018e-08 0 9.488092659306017e-08 0.00021 9.489092659306017e-08 0 9.489092659306017e-08 0 9.490092659306017e-08 0.00021 9.491092659306017e-08 0 9.491092659306017e-08 0 9.492092659306017e-08 0.00021 9.493092659306016e-08 0 9.493092659306016e-08 0 9.494092659306016e-08 0.00021 9.495092659306016e-08 0 9.495092659306016e-08 0 9.496092659306016e-08 0.00021 9.497092659306016e-08 0 9.497092659306016e-08 0 9.498092659306015e-08 0.00021 9.499092659306015e-08 0 9.500005489656557e-08 0 9.501005489656557e-08 0.00021 9.502005489656557e-08 0 9.502005489656557e-08 0 9.503005489656556e-08 0.00021 9.504005489656556e-08 0 9.504005489656556e-08 0 9.505005489656556e-08 0.00021 9.506005489656556e-08 0 9.506005489656556e-08 0 9.507005489656556e-08 0.00021 9.508005489656555e-08 0 9.508005489656555e-08 0 9.509005489656555e-08 0.00021 9.510005489656555e-08 0 9.510005489656555e-08 0 9.511005489656555e-08 0.00021 9.512005489656555e-08 0 9.512005489656555e-08 0 9.513005489656554e-08 0.00021 9.514005489656554e-08 0 9.514005489656554e-08 0 9.515005489656554e-08 0.00021 9.516005489656554e-08 0 9.536018102110881e-08 0 9.537018102110881e-08 0.00021 9.538018102110881e-08 0 9.539107346397025e-08 0 9.540107346397025e-08 0.00021 9.541107346397024e-08 0 9.541333924691905e-08 0 9.542333924691904e-08 0.00021 9.543333924691904e-08 0 9.543359385038162e-08 0 9.544359385038162e-08 0.00021 9.545359385038162e-08 0 9.552835413087692e-08 0 9.553835413087692e-08 0.00021 9.554835413087692e-08 0 9.573673102516623e-08 0 9.574673102516623e-08 0.00021 9.575673102516623e-08 0 9.575673102516623e-08 0 9.576673102516623e-08 0.00021 9.577673102516622e-08 0 9.577673102516622e-08 0 9.578673102516622e-08 0.00021 9.579673102516622e-08 0 9.579673102516622e-08 0 9.580673102516622e-08 0.00021 9.581673102516622e-08 0 9.584860937213565e-08 0 9.585860937213565e-08 0.00021 9.586860937213565e-08 0 9.593208476414612e-08 0 9.594208476414611e-08 0.00021 9.595208476414611e-08 0 9.595208476414611e-08 0 9.596208476414611e-08 0.00021 9.597208476414611e-08 0 9.6024481160988e-08 0 9.6034481160988e-08 0.00021 9.6044481160988e-08 0 9.605192888393334e-08 0 9.606192888393334e-08 0.00021 9.607192888393333e-08 0 9.612814937441611e-08 0 9.613814937441611e-08 0.00021 9.614814937441611e-08 0 9.614814937441611e-08 0 9.615814937441611e-08 0.00021 9.616814937441611e-08 0 9.616814937441611e-08 0 9.61781493744161e-08 0.00021 9.61881493744161e-08 0 9.625546937827356e-08 0 9.626546937827356e-08 0.00021 9.627546937827356e-08 0 9.627546937827356e-08 0 9.628546937827356e-08 0.00021 9.629546937827356e-08 0 9.629546937827356e-08 0 9.630546937827355e-08 0.00021 9.631546937827355e-08 0 9.63871758219541e-08 0 9.63971758219541e-08 0.00021 9.64071758219541e-08 0 9.64071758219541e-08 0 9.64171758219541e-08 0.00021 9.64271758219541e-08 0 9.644988043997645e-08 0 9.645988043997645e-08 0.00021 9.646988043997645e-08 0 9.652444136651694e-08 0 9.653444136651693e-08 0.00021 9.654444136651693e-08 0 9.654478128105994e-08 0 9.655478128105994e-08 0.00021 9.656478128105994e-08 0 9.656478128105994e-08 0 9.657478128105993e-08 0.00021 9.658478128105993e-08 0 9.658478128105993e-08 0 9.659478128105993e-08 0.00021 9.660478128105993e-08 0 9.661697385681499e-08 0 9.662697385681499e-08 0.00021 9.663697385681499e-08 0 9.663697385681499e-08 0 9.664697385681499e-08 0.00021 9.665697385681498e-08 0 9.665697385681498e-08 0 9.666697385681498e-08 0.00021 9.667697385681498e-08 0 9.667697385681498e-08 0 9.668697385681498e-08 0.00021 9.669697385681498e-08 0 9.669697385681498e-08 0 9.670697385681498e-08 0.00021 9.671697385681497e-08 0 9.671697385681497e-08 0 9.672697385681497e-08 0.00021 9.673697385681497e-08 0 9.673697385681497e-08 0 9.674697385681497e-08 0.00021 9.675697385681497e-08 0 9.678671806572225e-08 0 9.679671806572225e-08 0.00021 9.680671806572225e-08 0 9.680671806572225e-08 0 9.681671806572225e-08 0.00021 9.682671806572225e-08 0 9.684035332707229e-08 0 9.685035332707229e-08 0.00021 9.686035332707229e-08 0 9.689407520579378e-08 0 9.690407520579377e-08 0.00021 9.691407520579377e-08 0 9.699868389226196e-08 0 9.700868389226196e-08 0.00021 9.701868389226196e-08 0 9.706245744677526e-08 0 9.707245744677526e-08 0.00021 9.708245744677526e-08 0 9.710605499209515e-08 0 9.711605499209515e-08 0.00021 9.712605499209515e-08 0 9.716500380880624e-08 0 9.717500380880624e-08 0.00021 9.718500380880624e-08 0 9.720384050275187e-08 0 9.721384050275187e-08 0.00021 9.722384050275187e-08 0 9.722384050275187e-08 0 9.723384050275186e-08 0.00021 9.724384050275186e-08 0 9.729477846987476e-08 0 9.730477846987476e-08 0.00021 9.731477846987476e-08 0 9.732614298064553e-08 0 9.733614298064553e-08 0.00021 9.734614298064553e-08 0 9.734614298064553e-08 0 9.735614298064553e-08 0.00021 9.736614298064552e-08 0 9.737440085727112e-08 0 9.738440085727112e-08 0.00021 9.739440085727111e-08 0 9.742087548348489e-08 0 9.743087548348489e-08 0.00021 9.744087548348489e-08 0 9.744941118491225e-08 0 9.745941118491225e-08 0.00021 9.746941118491225e-08 0 9.746941118491225e-08 0 9.747941118491225e-08 0.00021 9.748941118491224e-08 0 9.749683199606346e-08 0 9.750683199606345e-08 0.00021 9.751683199606345e-08 0 9.756159759865072e-08 0 9.757159759865072e-08 0.00021 9.758159759865071e-08 0 9.758159759865071e-08 0 9.759159759865071e-08 0.00021 9.760159759865071e-08 0 9.760159759865071e-08 0 9.761159759865071e-08 0.00021 9.76215975986507e-08 0 9.763050689812209e-08 0 9.764050689812209e-08 0.00021 9.765050689812208e-08 0 9.767033403306434e-08 0 9.768033403306433e-08 0.00021 9.769033403306433e-08 0 9.769033403306433e-08 0 9.770033403306433e-08 0.00021 9.771033403306433e-08 0 9.778784816195478e-08 0 9.779784816195478e-08 0.00021 9.780784816195478e-08 0 9.781337300941741e-08 0 9.782337300941741e-08 0.00021 9.783337300941741e-08 0 9.784315064652676e-08 0 9.785315064652676e-08 0.00021 9.786315064652676e-08 0 9.786733165204377e-08 0 9.787733165204377e-08 0.00021 9.788733165204377e-08 0 9.789019302849343e-08 0 9.790019302849343e-08 0.00021 9.791019302849343e-08 0 9.791019302849343e-08 0 9.792019302849343e-08 0.00021 9.793019302849342e-08 0 9.797457416338435e-08 0 9.798457416338435e-08 0.00021 9.799457416338435e-08 0 9.80239058678883e-08 0 9.80339058678883e-08 0.00021 9.80439058678883e-08 0 9.805887728026875e-08 0 9.806887728026874e-08 0.00021 9.807887728026874e-08 0 9.807887728026874e-08 0 9.808887728026874e-08 0.00021 9.809887728026874e-08 0 9.809887728026874e-08 0 9.810887728026874e-08 0.00021 9.811887728026873e-08 0 9.811887728026873e-08 0 9.812887728026873e-08 0.00021 9.813887728026873e-08 0 9.819807311761756e-08 0 9.820807311761755e-08 0.00021 9.821807311761755e-08 0 9.822629377715256e-08 0 9.823629377715255e-08 0.00021 9.824629377715255e-08 0 9.835981842131256e-08 0 9.836981842131256e-08 0.00021 9.837981842131256e-08 0 9.838870625207779e-08 0 9.839870625207778e-08 0.00021 9.840870625207778e-08 0 9.840870625207778e-08 0 9.841870625207778e-08 0.00021 9.842870625207778e-08 0 9.842870625207778e-08 0 9.843870625207778e-08 0.00021 9.844870625207778e-08 0 9.849997036685104e-08 0 9.850997036685104e-08 0.00021 9.851997036685104e-08 0 9.856981117396879e-08 0 9.857981117396879e-08 0.00021 9.858981117396879e-08 0 9.858981117396879e-08 0 9.859981117396879e-08 0.00021 9.860981117396879e-08 0 9.862716835109902e-08 0 9.863716835109902e-08 0.00021 9.864716835109902e-08 0 9.864716835109902e-08 0 9.865716835109902e-08 0.00021 9.866716835109901e-08 0 9.866716835109901e-08 0 9.867716835109901e-08 0.00021 9.868716835109901e-08 0 9.868716835109901e-08 0 9.869716835109901e-08 0.00021 9.870716835109901e-08 0 9.874140599238671e-08 0 9.875140599238671e-08 0.00021 9.87614059923867e-08 0 9.878842370135375e-08 0 9.879842370135374e-08 0.00021 9.880842370135374e-08 0 9.880842370135374e-08 0 9.881842370135374e-08 0.00021 9.882842370135374e-08 0 9.882842370135374e-08 0 9.883842370135374e-08 0.00021 9.884842370135373e-08 0 9.884842370135373e-08 0 9.885842370135373e-08 0.00021 9.886842370135373e-08 0 9.886842370135373e-08 0 9.887842370135373e-08 0.00021 9.888842370135373e-08 0 9.888842370135373e-08 0 9.889842370135373e-08 0.00021 9.890842370135372e-08 0 9.898601362041027e-08 0 9.899601362041026e-08 0.00021 9.900601362041026e-08 0 9.906705630876549e-08 0 9.907705630876549e-08 0.00021 9.908705630876549e-08 0 9.908705630876549e-08 0 9.909705630876549e-08 0.00021 9.910705630876549e-08 0 9.913394560189648e-08 0 9.914394560189648e-08 0.00021 9.915394560189648e-08 0 9.915394560189648e-08 0 9.916394560189648e-08 0.00021 9.917394560189647e-08 0 9.917394560189647e-08 0 9.918394560189647e-08 0.00021 9.919394560189647e-08 0 9.919394560189647e-08 0 9.920394560189647e-08 0.00021 9.921394560189647e-08 0 9.922983122700739e-08 0 9.923983122700739e-08 0.00021 9.924983122700739e-08 0 9.925816249806893e-08 0 9.926816249806893e-08 0.00021 9.927816249806893e-08 0 9.927816249806893e-08 0 9.928816249806893e-08 0.00021 9.929816249806892e-08 0 9.931216933500259e-08 0 9.932216933500259e-08 0.00021 9.933216933500259e-08 0 9.933216933500259e-08 0 9.934216933500258e-08 0.00021 9.935216933500258e-08 0 9.935216933500258e-08 0 9.936216933500258e-08 0.00021 9.937216933500258e-08 0 9.937325012641038e-08 0 9.938325012641038e-08 0.00021 9.939325012641038e-08 0 9.939909080322902e-08 0 9.940909080322902e-08 0.00021 9.941909080322902e-08 0 9.941909080322902e-08 0 9.942909080322901e-08 0.00021 9.943909080322901e-08 0 9.94431598036517e-08 0 9.94531598036517e-08 0.00021 9.94631598036517e-08 0 9.949419976154097e-08 0 9.950419976154097e-08 0.00021 9.951419976154097e-08 0 9.951419976154097e-08 0 9.952419976154096e-08 0.00021 9.953419976154096e-08 0 9.953582432535751e-08 0 9.954582432535751e-08 0.00021 9.955582432535751e-08 0 9.955582432535751e-08 0 9.956582432535751e-08 0.00021 9.95758243253575e-08 0 9.95817370213456e-08 0 9.95917370213456e-08 0.00021 9.96017370213456e-08 0 9.963489017120776e-08 0 9.964489017120775e-08 0.00021 9.965489017120775e-08 0 9.974549049464694e-08 0 9.975549049464694e-08 0.00021 9.976549049464694e-08 0 9.976549049464694e-08 0 9.977549049464693e-08 0.00021 9.978549049464693e-08 0 9.978549049464693e-08 0 9.979549049464693e-08 0.00021 9.980549049464693e-08 0 9.980549049464693e-08 0 9.981549049464693e-08 0.00021 9.982549049464693e-08 0 9.993148588619161e-08 0 9.99414858861916e-08 0.00021 9.99514858861916e-08 0 9.99514858861916e-08 0 9.99614858861916e-08 0.00021 9.99714858861916e-08 0 1.0000288587301688e-07 0 1.0001288587301688e-07 0.00021 1.0002288587301688e-07 0 1.0002288587301688e-07 0 1.0003288587301687e-07 0.00021 1.0004288587301687e-07 0 1.0013011128063635e-07 0 1.0014011128063635e-07 0.00021 1.0015011128063635e-07 0 1.0018150015558177e-07 0 1.0019150015558177e-07 0.00021 1.0020150015558177e-07 0 1.0021194420932905e-07 0 1.0022194420932904e-07 0.00021 1.0023194420932904e-07 0 1.002380527874945e-07 0 1.002480527874945e-07 0.00021 1.002580527874945e-07 0 1.0028980981977584e-07 0 1.0029980981977584e-07 0.00021 1.0030980981977584e-07 0 1.0034318713723935e-07 0 1.0035318713723935e-07 0.00021 1.0036318713723935e-07 0 1.0038573207173278e-07 0 1.0039573207173277e-07 0.00021 1.0040573207173277e-07 0 1.0040573207173277e-07 0 1.0041573207173277e-07 0.00021 1.0042573207173277e-07 0 1.0042573207173277e-07 0 1.0043573207173277e-07 0.00021 1.0044573207173276e-07 0 1.0045301769098804e-07 0 1.0046301769098804e-07 0.00021 1.0047301769098804e-07 0 1.0047301769098804e-07 0 1.0048301769098803e-07 0.00021 1.0049301769098803e-07 0 1.0049684040127038e-07 0 1.0050684040127037e-07 0.00021 1.0051684040127037e-07 0 1.0053096042959653e-07 0 1.0054096042959653e-07 0.00021 1.0055096042959653e-07 0 1.005659703118279e-07 0 1.005759703118279e-07 0.00021 1.005859703118279e-07 0 1.005859703118279e-07 0 1.005959703118279e-07 0.00021 1.0060597031182789e-07 0 1.0060597031182789e-07 0 1.0061597031182789e-07 0.00021 1.0062597031182789e-07 0 1.0066460443504695e-07 0 1.0067460443504695e-07 0.00021 1.0068460443504695e-07 0 1.0068460443504695e-07 0 1.0069460443504694e-07 0.00021 1.0070460443504694e-07 0 1.0070460443504694e-07 0 1.0071460443504694e-07 0.00021 1.0072460443504694e-07 0 1.0075007966818307e-07 0 1.0076007966818307e-07 0.00021 1.0077007966818307e-07 0 1.0077647022095343e-07 0 1.0078647022095343e-07 0.00021 1.0079647022095342e-07 0 1.0079647022095342e-07 0 1.0080647022095342e-07 0.00021 1.0081647022095342e-07 0 1.0081647022095342e-07 0 1.0082647022095342e-07 0.00021 1.0083647022095342e-07 0 1.0091080916432679e-07 0 1.0092080916432679e-07 0.00021 1.0093080916432679e-07 0 1.0094469286146229e-07 0 1.0095469286146229e-07 0.00021 1.0096469286146228e-07 0 1.0099215497687287e-07 0 1.0100215497687286e-07 0.00021 1.0101215497687286e-07 0 1.0101215497687286e-07 0 1.0102215497687286e-07 0.00021 1.0103215497687286e-07 0 1.011107125253475e-07 0 1.011207125253475e-07 0.00021 1.011307125253475e-07 0 1.011307125253475e-07 0 1.011407125253475e-07 0.00021 1.011507125253475e-07 0 1.011507125253475e-07 0 1.0116071252534749e-07 0.00021 1.0117071252534749e-07 0 1.0117071252534749e-07 0 1.0118071252534749e-07 0.00021 1.0119071252534749e-07 0 1.0119071252534749e-07 0 1.0120071252534748e-07 0.00021 1.0121071252534748e-07 0 1.0121071252534748e-07 0 1.0122071252534748e-07 0.00021 1.0123071252534748e-07 0 1.0123071252534748e-07 0 1.0124071252534748e-07 0.00021 1.0125071252534747e-07 0 1.0125713633526466e-07 0 1.0126713633526466e-07 0.00021 1.0127713633526466e-07 0 1.0127713633526466e-07 0 1.0128713633526466e-07 0.00021 1.0129713633526465e-07 0 1.0133741558880444e-07 0 1.0134741558880444e-07 0.00021 1.0135741558880444e-07 0 1.0135741558880444e-07 0 1.0136741558880444e-07 0.00021 1.0137741558880444e-07 0 1.0137741558880444e-07 0 1.0138741558880443e-07 0.00021 1.0139741558880443e-07 0 1.0139741558880443e-07 0 1.0140741558880443e-07 0.00021 1.0141741558880443e-07 0 1.0141741558880443e-07 0 1.0142741558880443e-07 0.00021 1.0143741558880443e-07 0 1.0143741558880443e-07 0 1.0144741558880442e-07 0.00021 1.0145741558880442e-07 0 1.0145741558880442e-07 0 1.0146741558880442e-07 0.00021 1.0147741558880442e-07 0 1.0149194532950494e-07 0 1.0150194532950494e-07 0.00021 1.0151194532950494e-07 0 1.0151194532950494e-07 0 1.0152194532950494e-07 0.00021 1.0153194532950493e-07 0 1.0153194532950493e-07 0 1.0154194532950493e-07 0.00021 1.0155194532950493e-07 0 1.0155280273222875e-07 0 1.0156280273222875e-07 0.00021 1.0157280273222875e-07 0 1.0157391755768127e-07 0 1.0158391755768127e-07 0.00021 1.0159391755768127e-07 0 1.0159391755768127e-07 0 1.0160391755768127e-07 0.00021 1.0161391755768127e-07 0 1.0161391755768127e-07 0 1.0162391755768127e-07 0.00021 1.0163391755768126e-07 0 1.0163391755768126e-07 0 1.0164391755768126e-07 0.00021 1.0165391755768126e-07 0 1.0168633482322972e-07 0 1.0169633482322971e-07 0.00021 1.0170633482322971e-07 0 1.0171752651960466e-07 0 1.0172752651960466e-07 0.00021 1.0173752651960465e-07 0 1.0176534541772276e-07 0 1.0177534541772276e-07 0.00021 1.0178534541772276e-07 0 1.0178534541772276e-07 0 1.0179534541772276e-07 0.00021 1.0180534541772275e-07 0 1.0180534541772275e-07 0 1.0181534541772275e-07 0.00021 1.0182534541772275e-07 0 1.0193006865822353e-07 0 1.0194006865822353e-07 0.00021 1.0195006865822352e-07 0 1.0195006865822352e-07 0 1.0196006865822352e-07 0.00021 1.0197006865822352e-07 0 1.0197006865822352e-07 0 1.0198006865822352e-07 0.00021 1.0199006865822352e-07 0 1.0199006865822352e-07 0 1.0200006865822352e-07 0.00021 1.0201006865822351e-07 0 1.0209280339129114e-07 0 1.0210280339129114e-07 0.00021 1.0211280339129114e-07 0 1.0211280339129114e-07 0 1.0212280339129114e-07 0.00021 1.0213280339129114e-07 0 1.0213280339129114e-07 0 1.0214280339129114e-07 0.00021 1.0215280339129113e-07 0 1.022322549673968e-07 0 1.022422549673968e-07 0.00021 1.022522549673968e-07 0 1.022522549673968e-07 0 1.0226225496739679e-07 0.00021 1.0227225496739679e-07 0 1.0227225496739679e-07 0 1.0228225496739679e-07 0.00021 1.0229225496739679e-07 0 1.0229225496739679e-07 0 1.0230225496739679e-07 0.00021 1.0231225496739678e-07 0 1.0231225496739678e-07 0 1.0232225496739678e-07 0.00021 1.0233225496739678e-07 0 1.0237279756574917e-07 0 1.0238279756574916e-07 0.00021 1.0239279756574916e-07 0 1.0239279756574916e-07 0 1.0240279756574916e-07 0.00021 1.0241279756574916e-07 0 1.0241279756574916e-07 0 1.0242279756574916e-07 0.00021 1.0243279756574915e-07 0 1.0243279756574915e-07 0 1.0244279756574915e-07 0.00021 1.0245279756574915e-07 0 1.0245279756574915e-07 0 1.0246279756574915e-07 0.00021 1.0247279756574915e-07 0 1.0247279756574915e-07 0 1.0248279756574914e-07 0.00021 1.0249279756574914e-07 0 1.0249279756574914e-07 0 1.0250279756574914e-07 0.00021 1.0251279756574914e-07 0 1.0251279756574914e-07 0 1.0252279756574914e-07 0.00021 1.0253279756574913e-07 0 1.0253570322472506e-07 0 1.0254570322472506e-07 0.00021 1.0255570322472506e-07 0 1.0257288897319071e-07 0 1.0258288897319071e-07 0.00021 1.0259288897319071e-07 0 1.0264068099300922e-07 0 1.0265068099300922e-07 0.00021 1.0266068099300921e-07 0 1.0266068099300921e-07 0 1.0267068099300921e-07 0.00021 1.0268068099300921e-07 0 1.0271162788575962e-07 0 1.0272162788575962e-07 0.00021 1.0273162788575962e-07 0 1.0277360811780873e-07 0 1.0278360811780873e-07 0.00021 1.0279360811780873e-07 0 1.0279360811780873e-07 0 1.0280360811780872e-07 0.00021 1.0281360811780872e-07 0 1.0281360811780872e-07 0 1.0282360811780872e-07 0.00021 1.0283360811780872e-07 0 1.0283360811780872e-07 0 1.0284360811780872e-07 0.00021 1.0285360811780871e-07 0 1.0285360811780871e-07 0 1.0286360811780871e-07 0.00021 1.0287360811780871e-07 0 1.0290095169058486e-07 0 1.0291095169058486e-07 0.00021 1.0292095169058486e-07 0 1.0292095169058486e-07 0 1.0293095169058485e-07 0.00021 1.0294095169058485e-07 0 1.0294095169058485e-07 0 1.0295095169058485e-07 0.00021 1.0296095169058485e-07 0 1.0301504678812003e-07 0 1.0302504678812002e-07 0.00021 1.0303504678812002e-07 0 1.0306825077770412e-07 0 1.0307825077770412e-07 0.00021 1.0308825077770412e-07 0 1.0311077819719176e-07 0 1.0312077819719176e-07 0.00021 1.0313077819719176e-07 0 1.0313077819719176e-07 0 1.0314077819719176e-07 0.00021 1.0315077819719176e-07 0 1.0315077819719176e-07 0 1.0316077819719175e-07 0.00021 1.0317077819719175e-07 0 1.0322834596428572e-07 0 1.0323834596428571e-07 0.00021 1.0324834596428571e-07 0 1.0324834596428571e-07 0 1.0325834596428571e-07 0.00021 1.0326834596428571e-07 0 1.0326834596428571e-07 0 1.0327834596428571e-07 0.00021 1.032883459642857e-07 0 1.032883459642857e-07 0 1.032983459642857e-07 0.00021 1.033083459642857e-07 0 1.0332683195033328e-07 0 1.0333683195033328e-07 0.00021 1.0334683195033328e-07 0 1.0335114988370535e-07 0 1.0336114988370535e-07 0.00021 1.0337114988370535e-07 0 1.0337114988370535e-07 0 1.0338114988370535e-07 0.00021 1.0339114988370534e-07 0 1.0339114988370534e-07 0 1.0340114988370534e-07 0.00021 1.0341114988370534e-07 0 1.0341114988370534e-07 0 1.0342114988370534e-07 0.00021 1.0343114988370534e-07 0 1.0343114988370534e-07 0 1.0344114988370534e-07 0.00021 1.0345114988370533e-07 0 1.0345114988370533e-07 0 1.0346114988370533e-07 0.00021 1.0347114988370533e-07 0 1.0347114988370533e-07 0 1.0348114988370533e-07 0.00021 1.0349114988370533e-07 0 1.0349114988370533e-07 0 1.0350114988370532e-07 0.00021 1.0351114988370532e-07 0 1.0351114988370532e-07 0 1.0352114988370532e-07 0.00021 1.0353114988370532e-07 0 1.035341910437898e-07 0 1.035441910437898e-07 0.00021 1.035541910437898e-07 0 1.035541910437898e-07 0 1.035641910437898e-07 0.00021 1.0357419104378979e-07 0 1.0357419104378979e-07 0 1.0358419104378979e-07 0.00021 1.0359419104378979e-07 0 1.0359419104378979e-07 0 1.0360419104378979e-07 0.00021 1.0361419104378979e-07 0 1.0361419104378979e-07 0 1.0362419104378978e-07 0.00021 1.0363419104378978e-07 0 1.0365616138582875e-07 0 1.0366616138582875e-07 0.00021 1.0367616138582874e-07 0 1.0370112864067607e-07 0 1.0371112864067606e-07 0.00021 1.0372112864067606e-07 0 1.0372346409693773e-07 0 1.0373346409693773e-07 0.00021 1.0374346409693773e-07 0 1.0374346409693773e-07 0 1.0375346409693772e-07 0.00021 1.0376346409693772e-07 0 1.0376346409693772e-07 0 1.0377346409693772e-07 0.00021 1.0378346409693772e-07 0 1.0378346409693772e-07 0 1.0379346409693772e-07 0.00021 1.0380346409693772e-07 0 1.0380346409693772e-07 0 1.0381346409693771e-07 0.00021 1.0382346409693771e-07 0 1.0382346409693771e-07 0 1.0383346409693771e-07 0.00021 1.0384346409693771e-07 0 1.0384346409693771e-07 0 1.038534640969377e-07 0.00021 1.038634640969377e-07 0 1.038634640969377e-07 0 1.038734640969377e-07 0.00021 1.038834640969377e-07 0 1.038834640969377e-07 0 1.038934640969377e-07 0.00021 1.039034640969377e-07 0 1.039034640969377e-07 0 1.039134640969377e-07 0.00021 1.0392346409693769e-07 0 1.0392346409693769e-07 0 1.0393346409693769e-07 0.00021 1.0394346409693769e-07 0 1.0394346409693769e-07 0 1.0395346409693769e-07 0.00021 1.0396346409693768e-07 0 1.0396346409693768e-07 0 1.0397346409693768e-07 0.00021 1.0398346409693768e-07 0 1.0398346409693768e-07 0 1.0399346409693768e-07 0.00021 1.0400346409693768e-07 0 1.0400346409693768e-07 0 1.0401346409693768e-07 0.00021 1.0402346409693767e-07 0 1.0402346409693767e-07 0 1.0403346409693767e-07 0.00021 1.0404346409693767e-07 0 1.0404346409693767e-07 0 1.0405346409693767e-07 0.00021 1.0406346409693767e-07 0 1.0406346409693767e-07 0 1.0407346409693766e-07 0.00021 1.0408346409693766e-07 0 1.0408346409693766e-07 0 1.0409346409693766e-07 0.00021 1.0410346409693766e-07 0 1.0410346409693766e-07 0 1.0411346409693766e-07 0.00021 1.0412346409693765e-07 0 1.0412346409693765e-07 0 1.0413346409693765e-07 0.00021 1.0414346409693765e-07 0 1.0414431628718242e-07 0 1.0415431628718242e-07 0.00021 1.0416431628718242e-07 0 1.0416431628718242e-07 0 1.0417431628718242e-07 0.00021 1.0418431628718241e-07 0 1.0418431628718241e-07 0 1.0419431628718241e-07 0.00021 1.0420431628718241e-07 0 1.042303081256194e-07 0 1.042403081256194e-07 0.00021 1.042503081256194e-07 0 1.042503081256194e-07 0 1.042603081256194e-07 0.00021 1.0427030812561939e-07 0 1.0427492859265322e-07 0 1.0428492859265322e-07 0.00021 1.0429492859265322e-07 0 1.0429492859265322e-07 0 1.0430492859265321e-07 0.00021 1.0431492859265321e-07 0 1.0431999197864819e-07 0 1.0432999197864818e-07 0.00021 1.0433999197864818e-07 0 1.0436099638452881e-07 0 1.043709963845288e-07 0.00021 1.043809963845288e-07 0 1.043809963845288e-07 0 1.043909963845288e-07 0.00021 1.044009963845288e-07 0 1.0442650960311728e-07 0 1.0443650960311728e-07 0.00021 1.0444650960311728e-07 0 1.0444650960311728e-07 0 1.0445650960311728e-07 0.00021 1.0446650960311727e-07 0 1.0446650960311727e-07 0 1.0447650960311727e-07 0.00021 1.0448650960311727e-07 0 1.0448650960311727e-07 0 1.0449650960311727e-07 0.00021 1.0450650960311727e-07 0 1.0450845331432547e-07 0 1.0451845331432547e-07 0.00021 1.0452845331432547e-07 0 1.0452845331432547e-07 0 1.0453845331432546e-07 0.00021 1.0454845331432546e-07 0 1.0454845331432546e-07 0 1.0455845331432546e-07 0.00021 1.0456845331432546e-07 0 1.0457459344818195e-07 0 1.0458459344818195e-07 0.00021 1.0459459344818195e-07 0 1.0459459344818195e-07 0 1.0460459344818195e-07 0.00021 1.0461459344818195e-07 0 1.0461459344818195e-07 0 1.0462459344818195e-07 0.00021 1.0463459344818194e-07 0 1.0463459344818194e-07 0 1.0464459344818194e-07 0.00021 1.0465459344818194e-07 0 1.0465459344818194e-07 0 1.0466459344818194e-07 0.00021 1.0467459344818194e-07 0 1.0467459344818194e-07 0 1.0468459344818193e-07 0.00021 1.0469459344818193e-07 0 1.0477156678693566e-07 0 1.0478156678693566e-07 0.00021 1.0479156678693566e-07 0 1.0487227375569223e-07 0 1.0488227375569223e-07 0.00021 1.0489227375569223e-07 0 1.0489890028673877e-07 0 1.0490890028673877e-07 0.00021 1.0491890028673877e-07 0 1.0494131941276029e-07 0 1.0495131941276028e-07 0.00021 1.0496131941276028e-07 0 1.0496131941276028e-07 0 1.0497131941276028e-07 0.00021 1.0498131941276028e-07 0 1.0498131941276028e-07 0 1.0499131941276028e-07 0.00021 1.0500131941276027e-07 0 1.0500131941276027e-07 0 1.0501131941276027e-07 0.00021 1.0502131941276027e-07 0 1.0502131941276027e-07 0 1.0503131941276027e-07 0.00021 1.0504131941276027e-07 0 1.0504131941276027e-07 0 1.0505131941276026e-07 0.00021 1.0506131941276026e-07 0 1.0506417718148319e-07 0 1.0507417718148319e-07 0.00021 1.0508417718148318e-07 0 1.0508417718148318e-07 0 1.0509417718148318e-07 0.00021 1.0510417718148318e-07 0 1.0516345758673704e-07 0 1.0517345758673704e-07 0.00021 1.0518345758673704e-07 0 1.0518345758673704e-07 0 1.0519345758673703e-07 0.00021 1.0520345758673703e-07 0 1.0520548409635253e-07 0 1.0521548409635253e-07 0.00021 1.0522548409635253e-07 0 1.0523340201209377e-07 0 1.0524340201209376e-07 0.00021 1.0525340201209376e-07 0 1.053217506418044e-07 0 1.053317506418044e-07 0.00021 1.0534175064180439e-07 0 1.0534175064180439e-07 0 1.0535175064180439e-07 0.00021 1.0536175064180439e-07 0 1.0536175064180439e-07 0 1.0537175064180439e-07 0.00021 1.0538175064180438e-07 0 1.0538175064180438e-07 0 1.0539175064180438e-07 0.00021 1.0540175064180438e-07 0 1.0548758510407899e-07 0 1.0549758510407899e-07 0.00021 1.0550758510407899e-07 0 1.0550758510407899e-07 0 1.0551758510407898e-07 0.00021 1.0552758510407898e-07 0 1.0552758510407898e-07 0 1.0553758510407898e-07 0.00021 1.0554758510407898e-07 0 1.0554758510407898e-07 0 1.0555758510407898e-07 0.00021 1.0556758510407897e-07 0 1.0556758510407897e-07 0 1.0557758510407897e-07 0.00021 1.0558758510407897e-07 0 1.0558758510407897e-07 0 1.0559758510407897e-07 0.00021 1.0560758510407897e-07 0 1.056206102735834e-07 0 1.056306102735834e-07 0.00021 1.056406102735834e-07 0 1.056406102735834e-07 0 1.056506102735834e-07 0.00021 1.056606102735834e-07 0 1.057527246787183e-07 0 1.057627246787183e-07 0.00021 1.057727246787183e-07 0 1.0578404850336098e-07 0 1.0579404850336098e-07 0.00021 1.0580404850336098e-07 0 1.0580404850336098e-07 0 1.0581404850336097e-07 0.00021 1.0582404850336097e-07 0 1.058260231302361e-07 0 1.0583602313023609e-07 0.00021 1.0584602313023609e-07 0 1.0584602313023609e-07 0 1.0585602313023609e-07 0.00021 1.0586602313023609e-07 0 1.0593186837344788e-07 0 1.0594186837344787e-07 0.00021 1.0595186837344787e-07 0 1.0598739944670895e-07 0 1.0599739944670895e-07 0.00021 1.0600739944670895e-07 0 1.0623224252304609e-07 0 1.0624224252304608e-07 0.00021 1.0625224252304608e-07 0 1.0626378504321148e-07 0 1.0627378504321148e-07 0.00021 1.0628378504321148e-07 0 1.0634023694928742e-07 0 1.0635023694928742e-07 0.00021 1.0636023694928742e-07 0 1.0638954814354961e-07 0 1.0639954814354961e-07 0.00021 1.0640954814354961e-07 0 1.0640954814354961e-07 0 1.0641954814354961e-07 0.00021 1.0642954814354961e-07 0 1.0644171670586033e-07 0 1.0645171670586033e-07 0.00021 1.0646171670586033e-07 0 1.0646171670586033e-07 0 1.0647171670586033e-07 0.00021 1.0648171670586032e-07 0 1.0648190802475461e-07 0 1.0649190802475461e-07 0.00021 1.0650190802475461e-07 0 1.0650190802475461e-07 0 1.0651190802475461e-07 0.00021 1.0652190802475461e-07 0 1.0652992964685431e-07 0 1.065399296468543e-07 0.00021 1.065499296468543e-07 0 1.065499296468543e-07 0 1.065599296468543e-07 0.00021 1.065699296468543e-07 0 1.065699296468543e-07 0 1.065799296468543e-07 0.00021 1.065899296468543e-07 0 1.0660460433857749e-07 0 1.0661460433857749e-07 0.00021 1.0662460433857749e-07 0 1.0663378970718875e-07 0 1.0664378970718875e-07 0.00021 1.0665378970718875e-07 0 1.0673064045949032e-07 0 1.0674064045949031e-07 0.00021 1.0675064045949031e-07 0 1.067537356243792e-07 0 1.067637356243792e-07 0.00021 1.067737356243792e-07 0 1.0678132136758564e-07 0 1.0679132136758564e-07 0.00021 1.0680132136758564e-07 0 1.0682370848076569e-07 0 1.0683370848076569e-07 0.00021 1.0684370848076568e-07 0 1.0684370848076568e-07 0 1.0685370848076568e-07 0.00021 1.0686370848076568e-07 0 1.0690059201670606e-07 0 1.0691059201670606e-07 0.00021 1.0692059201670605e-07 0 1.0693433131314537e-07 0 1.0694433131314537e-07 0.00021 1.0695433131314537e-07 0 1.0695433131314537e-07 0 1.0696433131314537e-07 0.00021 1.0697433131314537e-07 0 1.0699902187355399e-07 0 1.0700902187355398e-07 0.00021 1.0701902187355398e-07 0 1.0704910558266938e-07 0 1.0705910558266937e-07 0.00021 1.0706910558266937e-07 0 1.0709168220046215e-07 0 1.0710168220046215e-07 0.00021 1.0711168220046215e-07 0 1.0711168220046215e-07 0 1.0712168220046215e-07 0.00021 1.0713168220046215e-07 0 1.0715045595560718e-07 0 1.0716045595560718e-07 0.00021 1.0717045595560717e-07 0 1.0717045595560717e-07 0 1.0718045595560717e-07 0.00021 1.0719045595560717e-07 0 1.0719045595560717e-07 0 1.0720045595560717e-07 0.00021 1.0721045595560717e-07 0 1.0721614094763738e-07 0 1.0722614094763738e-07 0.00021 1.0723614094763738e-07 0 1.0725421331102642e-07 0 1.0726421331102641e-07 0.00021 1.0727421331102641e-07 0 1.073449534594221e-07 0 1.073549534594221e-07 0.00021 1.0736495345942209e-07 0 1.0736495345942209e-07 0 1.0737495345942209e-07 0.00021 1.0738495345942209e-07 0 1.073987344735329e-07 0 1.074087344735329e-07 0.00021 1.074187344735329e-07 0 1.074187344735329e-07 0 1.074287344735329e-07 0.00021 1.074387344735329e-07 0 1.074387344735329e-07 0 1.074487344735329e-07 0.00021 1.0745873447353289e-07 0 1.0745873447353289e-07 0 1.0746873447353289e-07 0.00021 1.0747873447353289e-07 0 1.0747873447353289e-07 0 1.0748873447353289e-07 0.00021 1.0749873447353289e-07 0 1.0753696944756976e-07 0 1.0754696944756976e-07 0.00021 1.0755696944756976e-07 0 1.0755696944756976e-07 0 1.0756696944756975e-07 0.00021 1.0757696944756975e-07 0 1.0758833275858207e-07 0 1.0759833275858207e-07 0.00021 1.0760833275858207e-07 0 1.0760833275858207e-07 0 1.0761833275858207e-07 0.00021 1.0762833275858206e-07 0 1.0766024736231114e-07 0 1.0767024736231114e-07 0.00021 1.0768024736231113e-07 0 1.0768024736231113e-07 0 1.0769024736231113e-07 0.00021 1.0770024736231113e-07 0 1.0774338293907056e-07 0 1.0775338293907056e-07 0.00021 1.0776338293907056e-07 0 1.0778174518116738e-07 0 1.0779174518116738e-07 0.00021 1.0780174518116738e-07 0 1.0783979011425242e-07 0 1.0784979011425242e-07 0.00021 1.0785979011425242e-07 0 1.0787037793671708e-07 0 1.0788037793671708e-07 0.00021 1.0789037793671707e-07 0 1.0790507959335074e-07 0 1.0791507959335074e-07 0.00021 1.0792507959335074e-07 0 1.0792507959335074e-07 0 1.0793507959335074e-07 0.00021 1.0794507959335074e-07 0 1.0802051440067799e-07 0 1.0803051440067798e-07 0.00021 1.0804051440067798e-07 0 1.0804901207834607e-07 0 1.0805901207834607e-07 0.00021 1.0806901207834606e-07 0 1.0810204319362068e-07 0 1.0811204319362067e-07 0.00021 1.0812204319362067e-07 0 1.0812780785202916e-07 0 1.0813780785202916e-07 0.00021 1.0814780785202916e-07 0 1.0814780785202916e-07 0 1.0815780785202915e-07 0.00021 1.0816780785202915e-07 0 1.0816780785202915e-07 0 1.0817780785202915e-07 0.00021 1.0818780785202915e-07 0 1.0818780785202915e-07 0 1.0819780785202915e-07 0.00021 1.0820780785202914e-07 0 1.0820780785202914e-07 0 1.0821780785202914e-07 0.00021 1.0822780785202914e-07 0 1.0822780785202914e-07 0 1.0823780785202914e-07 0.00021 1.0824780785202914e-07 0 1.0824780785202914e-07 0 1.0825780785202914e-07 0.00021 1.0826780785202913e-07 0 1.0829557385937634e-07 0 1.0830557385937634e-07 0.00021 1.0831557385937634e-07 0 1.0831805296516034e-07 0 1.0832805296516034e-07 0.00021 1.0833805296516034e-07 0 1.0836292799039612e-07 0 1.0837292799039612e-07 0.00021 1.0838292799039612e-07 0 1.084237510504365e-07 0 1.084337510504365e-07 0.00021 1.084437510504365e-07 0 1.084484211706999e-07 0 1.084584211706999e-07 0.00021 1.084684211706999e-07 0 1.084684211706999e-07 0 1.084784211706999e-07 0.00021 1.0848842117069989e-07 0 1.0853229418532545e-07 0 1.0854229418532545e-07 0.00021 1.0855229418532545e-07 0 1.0855229418532545e-07 0 1.0856229418532545e-07 0.00021 1.0857229418532544e-07 0 1.0860832667471245e-07 0 1.0861832667471245e-07 0.00021 1.0862832667471245e-07 0 1.0863315865873946e-07 0 1.0864315865873946e-07 0.00021 1.0865315865873946e-07 0 1.0870334115225881e-07 0 1.0871334115225881e-07 0.00021 1.0872334115225881e-07 0 1.0872334115225881e-07 0 1.0873334115225881e-07 0.00021 1.0874334115225881e-07 0 1.0874334115225881e-07 0 1.087533411522588e-07 0.00021 1.087633411522588e-07 0 1.0882328576801921e-07 0 1.0883328576801921e-07 0.00021 1.088432857680192e-07 0 1.088432857680192e-07 0 1.088532857680192e-07 0.00021 1.088632857680192e-07 0 1.0890457052892386e-07 0 1.0891457052892386e-07 0.00021 1.0892457052892385e-07 0 1.0892457052892385e-07 0 1.0893457052892385e-07 0.00021 1.0894457052892385e-07 0 1.0894457052892385e-07 0 1.0895457052892385e-07 0.00021 1.0896457052892385e-07 0 1.0896457052892385e-07 0 1.0897457052892384e-07 0.00021 1.0898457052892384e-07 0 1.0898457052892384e-07 0 1.0899457052892384e-07 0.00021 1.0900457052892384e-07 0 1.0900457052892384e-07 0 1.0901457052892384e-07 0.00021 1.0902457052892383e-07 0 1.0905054307230877e-07 0 1.0906054307230876e-07 0.00021 1.0907054307230876e-07 0 1.0907054307230876e-07 0 1.0908054307230876e-07 0.00021 1.0909054307230876e-07 0 1.0917653871368201e-07 0 1.0918653871368201e-07 0.00021 1.0919653871368201e-07 0 1.0919653871368201e-07 0 1.0920653871368201e-07 0.00021 1.09216538713682e-07 0 1.0922090850240098e-07 0 1.0923090850240097e-07 0.00021 1.0924090850240097e-07 0 1.0927487296043375e-07 0 1.0928487296043375e-07 0.00021 1.0929487296043374e-07 0 1.0929649739864181e-07 0 1.093064973986418e-07 0.00021 1.093164973986418e-07 0 1.0933737911894105e-07 0 1.0934737911894105e-07 0.00021 1.0935737911894104e-07 0 1.0936828528352034e-07 0 1.0937828528352034e-07 0.00021 1.0938828528352034e-07 0 1.0940919490002571e-07 0 1.0941919490002571e-07 0.00021 1.094291949000257e-07 0 1.0943804039477004e-07 0 1.0944804039477004e-07 0.00021 1.0945804039477004e-07 0 1.0945804039477004e-07 0 1.0946804039477004e-07 0.00021 1.0947804039477004e-07 0 1.0947804039477004e-07 0 1.0948804039477004e-07 0.00021 1.0949804039477003e-07 0 1.0951529404745937e-07 0 1.0952529404745937e-07 0.00021 1.0953529404745936e-07 0 1.0953529404745936e-07 0 1.0954529404745936e-07 0.00021 1.0955529404745936e-07 0 1.0955529404745936e-07 0 1.0956529404745936e-07 0.00021 1.0957529404745936e-07 0 1.0957529404745936e-07 0 1.0958529404745935e-07 0.00021 1.0959529404745935e-07 0 1.0967839721863983e-07 0 1.0968839721863983e-07 0.00021 1.0969839721863983e-07 0 1.0969839721863983e-07 0 1.0970839721863983e-07 0.00021 1.0971839721863982e-07 0 1.0971839721863982e-07 0 1.0972839721863982e-07 0.00021 1.0973839721863982e-07 0 1.0973839721863982e-07 0 1.0974839721863982e-07 0.00021 1.0975839721863982e-07 0 1.0975839721863982e-07 0 1.0976839721863982e-07 0.00021 1.0977839721863981e-07 0 1.0977839721863981e-07 0 1.0978839721863981e-07 0.00021 1.0979839721863981e-07 0 1.0981441099842005e-07 0 1.0982441099842005e-07 0.00021 1.0983441099842004e-07 0 1.0983650657555387e-07 0 1.0984650657555387e-07 0.00021 1.0985650657555387e-07 0 1.0985650657555387e-07 0 1.0986650657555387e-07 0.00021 1.0987650657555386e-07 0 1.0987650657555386e-07 0 1.0988650657555386e-07 0.00021 1.0989650657555386e-07 0 1.0989650657555386e-07 0 1.0990650657555386e-07 0.00021 1.0991650657555386e-07 0 1.0992232140301782e-07 0 1.0993232140301782e-07 0.00021 1.0994232140301782e-07 0 1.0996460138993194e-07 0 1.0997460138993193e-07 0.00021 1.0998460138993193e-07 0 1.0998460138993193e-07 0 1.0999460138993193e-07 0.00021 1.1000460138993193e-07 0 1.1000916750587063e-07 0 1.1001916750587063e-07 0.00021 1.1002916750587062e-07 0 1.1007005166727651e-07 0 1.100800516672765e-07 0.00021 1.100900516672765e-07 0 1.1012128054457788e-07 0 1.1013128054457788e-07 0.00021 1.1014128054457788e-07 0 1.1015604265702632e-07 0 1.1016604265702632e-07 0.00021 1.1017604265702632e-07 0 1.1017604265702632e-07 0 1.1018604265702632e-07 0.00021 1.1019604265702631e-07 0 1.1024521817467226e-07 0 1.1025521817467226e-07 0.00021 1.1026521817467226e-07 0 1.1026521817467226e-07 0 1.1027521817467226e-07 0.00021 1.1028521817467226e-07 0 1.1028521817467226e-07 0 1.1029521817467226e-07 0.00021 1.1030521817467225e-07 0 1.1030521817467225e-07 0 1.1031521817467225e-07 0.00021 1.1032521817467225e-07 0 1.1035464748540725e-07 0 1.1036464748540725e-07 0.00021 1.1037464748540725e-07 0 1.1040742863688244e-07 0 1.1041742863688244e-07 0.00021 1.1042742863688244e-07 0 1.1047123611683053e-07 0 1.1048123611683053e-07 0.00021 1.1049123611683053e-07 0 1.1060867983643489e-07 0 1.1061867983643489e-07 0.00021 1.1062867983643489e-07 0 1.1062867983643489e-07 0 1.1063867983643489e-07 0.00021 1.1064867983643488e-07 0 1.1064867983643488e-07 0 1.1065867983643488e-07 0.00021 1.1066867983643488e-07 0 1.1068726217216143e-07 0 1.1069726217216143e-07 0.00021 1.1070726217216143e-07 0 1.1079996493733432e-07 0 1.1080996493733432e-07 0.00021 1.1081996493733432e-07 0 1.1089142385972755e-07 0 1.1090142385972754e-07 0.00021 1.1091142385972754e-07 0 1.1102206687141694e-07 0 1.1103206687141693e-07 0.00021 1.1104206687141693e-07 0 1.1104206687141693e-07 0 1.1105206687141693e-07 0.00021 1.1106206687141693e-07 0 1.1106206687141693e-07 0 1.1107206687141693e-07 0.00021 1.1108206687141692e-07 0 1.1108206687141692e-07 0 1.1109206687141692e-07 0.00021 1.1110206687141692e-07 0 1.1110489067664581e-07 0 1.1111489067664581e-07 0.00021 1.1112489067664581e-07 0 1.1112489067664581e-07 0 1.111348906766458e-07 0.00021 1.111448906766458e-07 0 1.111448906766458e-07 0 1.111548906766458e-07 0.00021 1.111648906766458e-07 0 1.111648906766458e-07 0 1.111748906766458e-07 0.00021 1.111848906766458e-07 0 1.111848906766458e-07 0 1.111948906766458e-07 0.00021 1.1120489067664579e-07 0 1.1120489067664579e-07 0 1.1121489067664579e-07 0.00021 1.1122489067664579e-07 0 1.1124529268788658e-07 0 1.1125529268788657e-07 0.00021 1.1126529268788657e-07 0 1.1133733102834643e-07 0 1.1134733102834643e-07 0.00021 1.1135733102834643e-07 0 1.1136559099716522e-07 0 1.1137559099716522e-07 0.00021 1.1138559099716522e-07 0 1.1138559099716522e-07 0 1.1139559099716522e-07 0.00021 1.1140559099716522e-07 0 1.1140559099716522e-07 0 1.1141559099716521e-07 0.00021 1.1142559099716521e-07 0 1.1143049692643441e-07 0 1.1144049692643441e-07 0.00021 1.114504969264344e-07 0 1.114504969264344e-07 0 1.114604969264344e-07 0.00021 1.114704969264344e-07 0 1.114704969264344e-07 0 1.114804969264344e-07 0.00021 1.114904969264344e-07 0 1.114904969264344e-07 0 1.115004969264344e-07 0.00021 1.115104969264344e-07 0 1.115104969264344e-07 0 1.1152049692643439e-07 0.00021 1.1153049692643439e-07 0 1.1153049692643439e-07 0 1.1154049692643439e-07 0.00021 1.1155049692643439e-07 0 1.1155049692643439e-07 0 1.1156049692643439e-07 0.00021 1.1157049692643438e-07 0 1.1157049692643438e-07 0 1.1158049692643438e-07 0.00021 1.1159049692643438e-07 0 1.1159049692643438e-07 0 1.1160049692643438e-07 0.00021 1.1161049692643438e-07 0 1.1161049692643438e-07 0 1.1162049692643437e-07 0.00021 1.1163049692643437e-07 0 1.1163049692643437e-07 0 1.1164049692643437e-07 0.00021 1.1165049692643437e-07 0 1.1170433770883064e-07 0 1.1171433770883064e-07 0.00021 1.1172433770883063e-07 0 1.1172433770883063e-07 0 1.1173433770883063e-07 0.00021 1.1174433770883063e-07 0 1.1180364156163476e-07 0 1.1181364156163476e-07 0.00021 1.1182364156163476e-07 0 1.1187247775749879e-07 0 1.1188247775749879e-07 0.00021 1.1189247775749879e-07 0 1.1189247775749879e-07 0 1.1190247775749879e-07 0.00021 1.1191247775749879e-07 0 1.1191755715447555e-07 0 1.1192755715447555e-07 0.00021 1.1193755715447554e-07 0 1.1194023577105997e-07 0 1.1195023577105997e-07 0.00021 1.1196023577105997e-07 0 1.1197927139379471e-07 0 1.1198927139379471e-07 0.00021 1.1199927139379471e-07 0 1.1200914525463723e-07 0 1.1201914525463723e-07 0.00021 1.1202914525463723e-07 0 1.1202914525463723e-07 0 1.1203914525463723e-07 0.00021 1.1204914525463722e-07 0 1.1207370254361715e-07 0 1.1208370254361715e-07 0.00021 1.1209370254361714e-07 0 1.1211310611586665e-07 0 1.1212310611586665e-07 0.00021 1.1213310611586665e-07 0 1.1213310611586665e-07 0 1.1214310611586664e-07 0.00021 1.1215310611586664e-07 0 1.1218835485962379e-07 0 1.1219835485962378e-07 0.00021 1.1220835485962378e-07 0 1.1225455876115234e-07 0 1.1226455876115233e-07 0.00021 1.1227455876115233e-07 0 1.1229889002304101e-07 0 1.12308890023041e-07 0.00021 1.12318890023041e-07 0 1.1236692513147591e-07 0 1.123769251314759e-07 0.00021 1.123869251314759e-07 0 1.1239983300440754e-07 0 1.1240983300440754e-07 0.00021 1.1241983300440754e-07 0 1.1241983300440754e-07 0 1.1242983300440753e-07 0.00021 1.1243983300440753e-07 0 1.1243983300440753e-07 0 1.1244983300440753e-07 0.00021 1.1245983300440753e-07 0 1.1245983300440753e-07 0 1.1246983300440753e-07 0.00021 1.1247983300440752e-07 0 1.1247983300440752e-07 0 1.1248983300440752e-07 0.00021 1.1249983300440752e-07 0 1.1249983300440752e-07 0 1.1250983300440752e-07 0.00021 1.1251983300440752e-07 0 1.1251983300440752e-07 0 1.1252983300440751e-07 0.00021 1.1253983300440751e-07 0 1.1253983300440751e-07 0 1.1254983300440751e-07 0.00021 1.1255983300440751e-07 0 1.1255983300440751e-07 0 1.1256983300440751e-07 0.00021 1.125798330044075e-07 0 1.1259407043096593e-07 0 1.1260407043096593e-07 0.00021 1.1261407043096592e-07 0 1.1263050439198961e-07 0 1.1264050439198961e-07 0.00021 1.1265050439198961e-07 0 1.1265050439198961e-07 0 1.1266050439198961e-07 0.00021 1.1267050439198961e-07 0 1.1267050439198961e-07 0 1.126805043919896e-07 0.00021 1.126905043919896e-07 0 1.126905043919896e-07 0 1.127005043919896e-07 0.00021 1.127105043919896e-07 0 1.127105043919896e-07 0 1.127205043919896e-07 0.00021 1.127305043919896e-07 0 1.1278164035844977e-07 0 1.1279164035844977e-07 0.00021 1.1280164035844977e-07 0 1.1280164035844977e-07 0 1.1281164035844977e-07 0.00021 1.1282164035844977e-07 0 1.1282430787214313e-07 0 1.1283430787214312e-07 0.00021 1.1284430787214312e-07 0 1.1285873709033819e-07 0 1.1286873709033818e-07 0.00021 1.1287873709033818e-07 0 1.1289048425931236e-07 0 1.1290048425931235e-07 0.00021 1.1291048425931235e-07 0 1.1291387108641038e-07 0 1.1292387108641038e-07 0.00021 1.1293387108641038e-07 0 1.1301951249414201e-07 0 1.13029512494142e-07 0.00021 1.13039512494142e-07 0 1.1305113348435948e-07 0 1.1306113348435947e-07 0.00021 1.1307113348435947e-07 0 1.1312232261566996e-07 0 1.1313232261566996e-07 0.00021 1.1314232261566996e-07 0 1.1323467400216117e-07 0 1.1324467400216117e-07 0.00021 1.1325467400216116e-07 0 1.1325467400216116e-07 0 1.1326467400216116e-07 0.00021 1.1327467400216116e-07 0 1.1327467400216116e-07 0 1.1328467400216116e-07 0.00021 1.1329467400216116e-07 0 1.1333439363143791e-07 0 1.1334439363143791e-07 0.00021 1.1335439363143791e-07 0 1.1339270100441712e-07 0 1.1340270100441712e-07 0.00021 1.1341270100441712e-07 0 1.1361908488700662e-07 0 1.1362908488700662e-07 0.00021 1.1363908488700662e-07 0 1.1363908488700662e-07 0 1.1364908488700662e-07 0.00021 1.1365908488700661e-07 0 1.1365908488700661e-07 0 1.1366908488700661e-07 0.00021 1.1367908488700661e-07 0 1.1367908488700661e-07 0 1.1368908488700661e-07 0.00021 1.1369908488700661e-07 0 1.1369908488700661e-07 0 1.137090848870066e-07 0.00021 1.137190848870066e-07 0 1.137190848870066e-07 0 1.137290848870066e-07 0.00021 1.137390848870066e-07 0 1.137390848870066e-07 0 1.137490848870066e-07 0.00021 1.137590848870066e-07 0 1.137590848870066e-07 0 1.137690848870066e-07 0.00021 1.1377908488700659e-07 0 1.1377908488700659e-07 0 1.1378908488700659e-07 0.00021 1.1379908488700659e-07 0 1.1379908488700659e-07 0 1.1380908488700659e-07 0.00021 1.1381908488700658e-07 0 1.1381908488700658e-07 0 1.1382908488700658e-07 0.00021 1.1383908488700658e-07 0 1.1383908488700658e-07 0 1.1384908488700658e-07 0.00021 1.1385908488700658e-07 0 1.1385908488700658e-07 0 1.1386908488700658e-07 0.00021 1.1387908488700657e-07 0 1.1387908488700657e-07 0 1.1388908488700657e-07 0.00021 1.1389908488700657e-07 0 1.1391324387293044e-07 0 1.1392324387293044e-07 0.00021 1.1393324387293044e-07 0 1.1393469267766232e-07 0 1.1394469267766232e-07 0.00021 1.1395469267766232e-07 0 1.1395469267766232e-07 0 1.1396469267766231e-07 0.00021 1.1397469267766231e-07 0 1.1397469267766231e-07 0 1.1398469267766231e-07 0.00021 1.1399469267766231e-07 0 1.1399469267766231e-07 0 1.140046926776623e-07 0.00021 1.140146926776623e-07 0 1.1409255238782116e-07 0 1.1410255238782116e-07 0.00021 1.1411255238782116e-07 0 1.1423659911600171e-07 0 1.1424659911600171e-07 0.00021 1.1425659911600171e-07 0 1.1428055842075204e-07 0 1.1429055842075203e-07 0.00021 1.1430055842075203e-07 0 1.1430055842075203e-07 0 1.1431055842075203e-07 0.00021 1.1432055842075203e-07 0 1.1432055842075203e-07 0 1.1433055842075203e-07 0.00021 1.1434055842075203e-07 0 1.1434055842075203e-07 0 1.1435055842075202e-07 0.00021 1.1436055842075202e-07 0 1.143707822011751e-07 0 1.143807822011751e-07 0.00021 1.143907822011751e-07 0 1.1444038403280297e-07 0 1.1445038403280296e-07 0.00021 1.1446038403280296e-07 0 1.144969682804377e-07 0 1.145069682804377e-07 0.00021 1.145169682804377e-07 0 1.145169682804377e-07 0 1.145269682804377e-07 0.00021 1.145369682804377e-07 0 1.145369682804377e-07 0 1.145469682804377e-07 0.00021 1.145569682804377e-07 0 1.145569682804377e-07 0 1.1456696828043769e-07 0.00021 1.1457696828043769e-07 0 1.1457696828043769e-07 0 1.1458696828043769e-07 0.00021 1.1459696828043769e-07 0 1.1459696828043769e-07 0 1.1460696828043768e-07 0.00021 1.1461696828043768e-07 0 1.1461696828043768e-07 0 1.1462696828043768e-07 0.00021 1.1463696828043768e-07 0 1.1463696828043768e-07 0 1.1464696828043768e-07 0.00021 1.1465696828043768e-07 0 1.146587820521746e-07 0 1.1466878205217459e-07 0.00021 1.1467878205217459e-07 0 1.1468632510078927e-07 0 1.1469632510078927e-07 0.00021 1.1470632510078927e-07 0 1.1471579709062506e-07 0 1.1472579709062506e-07 0.00021 1.1473579709062505e-07 0 1.1473769646452047e-07 0 1.1474769646452046e-07 0.00021 1.1475769646452046e-07 0 1.1475769646452046e-07 0 1.1476769646452046e-07 0.00021 1.1477769646452046e-07 0 1.1479054993117547e-07 0 1.1480054993117547e-07 0.00021 1.1481054993117547e-07 0 1.1481054993117547e-07 0 1.1482054993117546e-07 0.00021 1.1483054993117546e-07 0 1.1483054993117546e-07 0 1.1484054993117546e-07 0.00021 1.1485054993117546e-07 0 1.1488727582019118e-07 0 1.1489727582019118e-07 0.00021 1.1490727582019118e-07 0 1.1493865893526323e-07 0 1.1494865893526323e-07 0.00021 1.1495865893526323e-07 0 1.1495865893526323e-07 0 1.1496865893526323e-07 0.00021 1.1497865893526322e-07 0 1.1497865893526322e-07 0 1.1498865893526322e-07 0.00021 1.1499865893526322e-07 0 1.150887057651077e-07 0 1.150987057651077e-07 0.00021 1.151087057651077e-07 0 1.1520294773773667e-07 0 1.1521294773773667e-07 0.00021 1.1522294773773666e-07 0 1.1524507977723005e-07 0 1.1525507977723005e-07 0.00021 1.1526507977723005e-07 0 1.1530262766679224e-07 0 1.1531262766679224e-07 0.00021 1.1532262766679224e-07 0 1.1537177901670073e-07 0 1.1538177901670072e-07 0.00021 1.1539177901670072e-07 0 1.1556321836967359e-07 0 1.1557321836967359e-07 0.00021 1.1558321836967359e-07 0 1.155860678781018e-07 0 1.155960678781018e-07 0.00021 1.156060678781018e-07 0 1.1562126166262741e-07 0 1.1563126166262741e-07 0.00021 1.156412616626274e-07 0 1.156412616626274e-07 0 1.156512616626274e-07 0.00021 1.156612616626274e-07 0 1.156612616626274e-07 0 1.156712616626274e-07 0.00021 1.156812616626274e-07 0 1.156812616626274e-07 0 1.156912616626274e-07 0.00021 1.157012616626274e-07 0 1.157012616626274e-07 0 1.1571126166262739e-07 0.00021 1.1572126166262739e-07 0 1.1572126166262739e-07 0 1.1573126166262739e-07 0.00021 1.1574126166262739e-07 0 1.1574126166262739e-07 0 1.1575126166262739e-07 0.00021 1.1576126166262738e-07 0 1.1576126166262738e-07 0 1.1577126166262738e-07 0.00021 1.1578126166262738e-07 0 1.1578126166262738e-07 0 1.1579126166262738e-07 0.00021 1.1580126166262738e-07 0 1.1580126166262738e-07 0 1.1581126166262737e-07 0.00021 1.1582126166262737e-07 0 1.1582126166262737e-07 0 1.1583126166262737e-07 0.00021 1.1584126166262737e-07 0 1.1584126166262737e-07 0 1.1585126166262737e-07 0.00021 1.1586126166262736e-07 0 1.1586126166262736e-07 0 1.1587126166262736e-07 0.00021 1.1588126166262736e-07 0 1.1589583722386261e-07 0 1.1590583722386261e-07 0.00021 1.1591583722386261e-07 0 1.1594577333475483e-07 0 1.1595577333475483e-07 0.00021 1.1596577333475482e-07 0 1.1596577333475482e-07 0 1.1597577333475482e-07 0.00021 1.1598577333475482e-07 0 1.1601196111061036e-07 0 1.1602196111061036e-07 0.00021 1.1603196111061036e-07 0 1.1603196111061036e-07 0 1.1604196111061036e-07 0.00021 1.1605196111061036e-07 0 1.160943215085978e-07 0 1.161043215085978e-07 0.00021 1.161143215085978e-07 0 1.1612473375756804e-07 0 1.1613473375756804e-07 0.00021 1.1614473375756804e-07 0 1.1614473375756804e-07 0 1.1615473375756804e-07 0.00021 1.1616473375756804e-07 0 1.1616473375756804e-07 0 1.1617473375756803e-07 0.00021 1.1618473375756803e-07 0 1.1618473375756803e-07 0 1.1619473375756803e-07 0.00021 1.1620473375756803e-07 0 1.1620473375756803e-07 0 1.1621473375756803e-07 0.00021 1.1622473375756802e-07 0 1.1622473375756802e-07 0 1.1623473375756802e-07 0.00021 1.1624473375756802e-07 0 1.1624473375756802e-07 0 1.1625473375756802e-07 0.00021 1.1626473375756802e-07 0 1.1632354518677988e-07 0 1.1633354518677988e-07 0.00021 1.1634354518677987e-07 0 1.1638256984311373e-07 0 1.1639256984311373e-07 0.00021 1.1640256984311372e-07 0 1.1640992880849381e-07 0 1.164199288084938e-07 0.00021 1.164299288084938e-07 0 1.164299288084938e-07 0 1.164399288084938e-07 0.00021 1.164499288084938e-07 0 1.1671063174239957e-07 0 1.1672063174239956e-07 0.00021 1.1673063174239956e-07 0 1.1674668366628792e-07 0 1.1675668366628791e-07 0.00021 1.1676668366628791e-07 0 1.1677513100080183e-07 0 1.1678513100080183e-07 0.00021 1.1679513100080183e-07 0 1.1680427759504475e-07 0 1.1681427759504475e-07 0.00021 1.1682427759504475e-07 0 1.1682427759504475e-07 0 1.1683427759504475e-07 0.00021 1.1684427759504474e-07 0 1.1684427759504474e-07 0 1.1685427759504474e-07 0.00021 1.1686427759504474e-07 0 1.1688576359032141e-07 0 1.168957635903214e-07 0.00021 1.169057635903214e-07 0 1.1691878276518408e-07 0 1.1692878276518408e-07 0.00021 1.1693878276518408e-07 0 1.1693878276518408e-07 0 1.1694878276518407e-07 0.00021 1.1695878276518407e-07 0 1.1699939077593202e-07 0 1.1700939077593202e-07 0.00021 1.1701939077593202e-07 0 1.17026763080023e-07 0 1.1703676308002299e-07 0.00021 1.1704676308002299e-07 0 1.1704676308002299e-07 0 1.1705676308002299e-07 0.00021 1.1706676308002299e-07 0 1.1706676308002299e-07 0 1.1707676308002299e-07 0.00021 1.1708676308002298e-07 0 1.1708676308002298e-07 0 1.1709676308002298e-07 0.00021 1.1710676308002298e-07 0 1.1710676308002298e-07 0 1.1711676308002298e-07 0.00021 1.1712676308002298e-07 0 1.1715596441771067e-07 0 1.1716596441771067e-07 0.00021 1.1717596441771066e-07 0 1.1717650310128643e-07 0 1.1718650310128643e-07 0.00021 1.1719650310128642e-07 0 1.1719891693638256e-07 0 1.1720891693638256e-07 0.00021 1.1721891693638256e-07 0 1.1725023621290081e-07 0 1.172602362129008e-07 0.00021 1.172702362129008e-07 0 1.1745066318376108e-07 0 1.1746066318376108e-07 0.00021 1.1747066318376107e-07 0 1.1749202620969438e-07 0 1.1750202620969438e-07 0.00021 1.1751202620969438e-07 0 1.1755036681486856e-07 0 1.1756036681486856e-07 0.00021 1.1757036681486856e-07 0 1.1775366559025286e-07 0 1.1776366559025286e-07 0.00021 1.1777366559025285e-07 0 1.1783433767747811e-07 0 1.1784433767747811e-07 0.00021 1.1785433767747811e-07 0 1.1785433767747811e-07 0 1.1786433767747811e-07 0.00021 1.178743376774781e-07 0 1.178743376774781e-07 0 1.178843376774781e-07 0.00021 1.178943376774781e-07 0 1.178943376774781e-07 0 1.179043376774781e-07 0.00021 1.179143376774781e-07 0 1.1795313897781888e-07 0 1.1796313897781888e-07 0.00021 1.1797313897781888e-07 0 1.1800601837967879e-07 0 1.1801601837967879e-07 0.00021 1.1802601837967879e-07 0 1.18089540127885e-07 0 1.18099540127885e-07 0.00021 1.18109540127885e-07 0 1.1816762448914755e-07 0 1.1817762448914755e-07 0.00021 1.1818762448914755e-07 0 1.1823673316375336e-07 0 1.1824673316375336e-07 0.00021 1.1825673316375335e-07 0 1.1825673316375335e-07 0 1.1826673316375335e-07 0.00021 1.1827673316375335e-07 0 1.1827673316375335e-07 0 1.1828673316375335e-07 0.00021 1.1829673316375335e-07 0 1.1829871054021717e-07 0 1.1830871054021716e-07 0.00021 1.1831871054021716e-07 0 1.1831871054021716e-07 0 1.1832871054021716e-07 0.00021 1.1833871054021716e-07 0 1.1836099066343792e-07 0 1.1837099066343792e-07 0.00021 1.1838099066343792e-07 0 1.1838099066343792e-07 0 1.1839099066343792e-07 0.00021 1.1840099066343791e-07 0 1.1840099066343791e-07 0 1.1841099066343791e-07 0.00021 1.1842099066343791e-07 0 1.1842099066343791e-07 0 1.1843099066343791e-07 0.00021 1.184409906634379e-07 0 1.184409906634379e-07 0 1.184509906634379e-07 0.00021 1.184609906634379e-07 0 1.184609906634379e-07 0 1.184709906634379e-07 0.00021 1.184809906634379e-07 0 1.184809906634379e-07 0 1.184909906634379e-07 0.00021 1.185009906634379e-07 0 1.185009906634379e-07 0 1.1851099066343789e-07 0.00021 1.1852099066343789e-07 0 1.1852099066343789e-07 0 1.1853099066343789e-07 0.00021 1.1854099066343789e-07 0 1.1854099066343789e-07 0 1.1855099066343788e-07 0.00021 1.1856099066343788e-07 0 1.1856099066343788e-07 0 1.1857099066343788e-07 0.00021 1.1858099066343788e-07 0 1.1858099066343788e-07 0 1.1859099066343788e-07 0.00021 1.1860099066343788e-07 0 1.1860099066343788e-07 0 1.1861099066343787e-07 0.00021 1.1862099066343787e-07 0 1.1862717518996197e-07 0 1.1863717518996197e-07 0.00021 1.1864717518996196e-07 0 1.1864717518996196e-07 0 1.1865717518996196e-07 0.00021 1.1866717518996196e-07 0 1.1869218559338549e-07 0 1.1870218559338549e-07 0.00021 1.1871218559338548e-07 0 1.1872461518541917e-07 0 1.1873461518541917e-07 0.00021 1.1874461518541917e-07 0 1.1874909809096254e-07 0 1.1875909809096253e-07 0.00021 1.1876909809096253e-07 0 1.1876909809096253e-07 0 1.1877909809096253e-07 0.00021 1.1878909809096253e-07 0 1.1878909809096253e-07 0 1.1879909809096253e-07 0.00021 1.1880909809096252e-07 0 1.1881943748360262e-07 0 1.1882943748360262e-07 0.00021 1.1883943748360262e-07 0 1.1887761054945367e-07 0 1.1888761054945366e-07 0.00021 1.1889761054945366e-07 0 1.1889761054945366e-07 0 1.1890761054945366e-07 0.00021 1.1891761054945366e-07 0 1.1891761054945366e-07 0 1.1892761054945366e-07 0.00021 1.1893761054945365e-07 0 1.1893761054945365e-07 0 1.1894761054945365e-07 0.00021 1.1895761054945365e-07 0 1.1895761054945365e-07 0 1.1896761054945365e-07 0.00021 1.1897761054945365e-07 0 1.1897761054945365e-07 0 1.1898761054945364e-07 0.00021 1.1899761054945364e-07 0 1.1901698265010025e-07 0 1.1902698265010025e-07 0.00021 1.1903698265010025e-07 0 1.1903904151391892e-07 0 1.1904904151391892e-07 0.00021 1.1905904151391892e-07 0 1.190632288498569e-07 0 1.1907322884985689e-07 0.00021 1.1908322884985689e-07 0 1.1908322884985689e-07 0 1.1909322884985689e-07 0.00021 1.1910322884985689e-07 0 1.1910322884985689e-07 0 1.1911322884985688e-07 0.00021 1.1912322884985688e-07 0 1.1912322884985688e-07 0 1.1913322884985688e-07 0.00021 1.1914322884985688e-07 0 1.1914322884985688e-07 0 1.1915322884985688e-07 0.00021 1.1916322884985688e-07 0 1.1916322884985688e-07 0 1.1917322884985687e-07 0.00021 1.1918322884985687e-07 0 1.1918322884985687e-07 0 1.1919322884985687e-07 0.00021 1.1920322884985687e-07 0 1.1931652105054147e-07 0 1.1932652105054148e-07 0.00021 1.193365210505415e-07 0 1.1936937147556182e-07 0 1.1937937147556183e-07 0.00021 1.1938937147556184e-07 0 1.193893714755618e-07 0 1.1939937147556182e-07 0.00021 1.1940937147556183e-07 0 1.19424390298767e-07 0 1.1943439029876702e-07 0.00021 1.1944439029876703e-07 0 1.19444390298767e-07 0 1.1945439029876701e-07 0.00021 1.1946439029876702e-07 0 1.1947404338393272e-07 0 1.1948404338393273e-07 0.00021 1.1949404338393274e-07 0 1.194940433839327e-07 0 1.1950404338393272e-07 0.00021 1.1951404338393274e-07 0 1.195140433839327e-07 0 1.1952404338393272e-07 0.00021 1.1953404338393273e-07 0 1.1957156470678185e-07 0 1.1958156470678187e-07 0.00021 1.1959156470678188e-07 0 1.19665457826099e-07 0 1.19675457826099e-07 0.00021 1.1968545782609902e-07 0 1.19685457826099e-07 0 1.19695457826099e-07 0.00021 1.1970545782609902e-07 0 1.197178725520925e-07 0 1.197278725520925e-07 0.00021 1.1973787255209252e-07 0 1.1985546936738926e-07 0 1.1986546936738927e-07 0.00021 1.1987546936738928e-07 0 1.198963773084627e-07 0 1.1990637730846272e-07 0.00021 1.1991637730846274e-07 0 1.1998120791326476e-07 0 1.1999120791326477e-07 0.00021 1.2000120791326478e-07 0 1.2000120791326476e-07 0 1.2001120791326477e-07 0.00021 1.2002120791326478e-07 0 1.2002528753467015e-07 0 1.2003528753467016e-07 0.00021 1.2004528753467017e-07 0 1.201690408769031e-07 0 1.201790408769031e-07 0.00021 1.2018904087690312e-07 0 1.2019007919683896e-07 0 1.2020007919683897e-07 0.00021 1.2021007919683898e-07 0 1.2021783205913746e-07 0 1.2022783205913747e-07 0.00021 1.2023783205913748e-07 0 1.2025045245178104e-07 0 1.2026045245178105e-07 0.00021 1.2027045245178107e-07 0 1.2027045245178104e-07 0 1.2028045245178105e-07 0.00021 1.2029045245178106e-07 0 1.2029045245178104e-07 0 1.2030045245178105e-07 0.00021 1.2031045245178106e-07 0 1.2033406723931516e-07 0 1.2034406723931517e-07 0.00021 1.2035406723931518e-07 0 1.203696817587506e-07 0 1.203796817587506e-07 0.00021 1.203896817587506e-07 0 1.2045608463510895e-07 0 1.2046608463510896e-07 0.00021 1.2047608463510897e-07 0 1.2047608463510894e-07 0 1.2048608463510895e-07 0.00021 1.2049608463510897e-07 0 1.2049608463510894e-07 0 1.2050608463510895e-07 0.00021 1.2051608463510896e-07 0 1.2056508855428322e-07 0 1.2057508855428323e-07 0.00021 1.2058508855428324e-07 0 1.2061917124326756e-07 0 1.2062917124326757e-07 0.00021 1.2063917124326758e-07 0 1.2064471186412818e-07 0 1.206547118641282e-07 0.00021 1.206647118641282e-07 0 1.2066471186412818e-07 0 1.206747118641282e-07 0.00021 1.206847118641282e-07 0 1.2068471186412817e-07 0 1.2069471186412818e-07 0.00021 1.207047118641282e-07 0 1.2074888553336288e-07 0 1.207588855333629e-07 0.00021 1.207688855333629e-07 0 1.2078690418240958e-07 0 1.207969041824096e-07 0.00021 1.208069041824096e-07 0 1.2082580952426365e-07 0 1.2083580952426366e-07 0.00021 1.2084580952426368e-07 0 1.2084580952426365e-07 0 1.2085580952426366e-07 0.00021 1.2086580952426367e-07 0 1.2090028076570213e-07 0 1.2091028076570214e-07 0.00021 1.2092028076570215e-07 0 1.2092535571705126e-07 0 1.2093535571705128e-07 0.00021 1.209453557170513e-07 0 1.2096813592360834e-07 0 1.2097813592360835e-07 0.00021 1.2098813592360836e-07 0 1.2098813592360834e-07 0 1.2099813592360835e-07 0.00021 1.2100813592360836e-07 0 1.2100813592360833e-07 0 1.2101813592360834e-07 0.00021 1.2102813592360836e-07 0 1.2102813592360833e-07 0 1.2103813592360834e-07 0.00021 1.2104813592360835e-07 0 1.2108098906002397e-07 0 1.2109098906002398e-07 0.00021 1.21100989060024e-07 0 1.2110098906002396e-07 0 1.2111098906002398e-07 0.00021 1.21120989060024e-07 0 1.2112098906002396e-07 0 1.2113098906002397e-07 0.00021 1.2114098906002398e-07 0 1.2114098906002396e-07 0 1.2115098906002397e-07 0.00021 1.2116098906002398e-07 0 1.2118083510071776e-07 0 1.2119083510071778e-07 0.00021 1.212008351007178e-07 0 1.2123416340792357e-07 0 1.2124416340792358e-07 0.00021 1.212541634079236e-07 0 1.2125423556262897e-07 0 1.2126423556262898e-07 0.00021 1.21274235562629e-07 0 1.2129692353149953e-07 0 1.2130692353149954e-07 0.00021 1.2131692353149955e-07 0 1.2139079386188942e-07 0 1.2140079386188944e-07 0.00021 1.2141079386188945e-07 0 1.2148844208837507e-07 0 1.2149844208837509e-07 0.00021 1.215084420883751e-07 0 1.215311568447173e-07 0 1.2154115684471732e-07 0.00021 1.2155115684471733e-07 0 1.2158368250324977e-07 0 1.2159368250324978e-07 0.00021 1.216036825032498e-07 0 1.216364823078444e-07 0 1.2164648230784441e-07 0.00021 1.2165648230784443e-07 0 1.216564823078444e-07 0 1.216664823078444e-07 0.00021 1.2167648230784442e-07 0 1.216764823078444e-07 0 1.216864823078444e-07 0.00021 1.2169648230784442e-07 0 1.216964823078444e-07 0 1.217064823078444e-07 0.00021 1.2171648230784441e-07 0 1.217164823078444e-07 0 1.217264823078444e-07 0.00021 1.217364823078444e-07 0 1.2173648230784438e-07 0 1.217464823078444e-07 0.00021 1.217564823078444e-07 0 1.2175648230784438e-07 0 1.217664823078444e-07 0.00021 1.217764823078444e-07 0 1.2178754013696187e-07 0 1.2179754013696188e-07 0.00021 1.218075401369619e-07 0 1.2184591942366467e-07 0 1.2185591942366468e-07 0.00021 1.218659194236647e-07 0 1.2186591942366466e-07 0 1.2187591942366467e-07 0.00021 1.2188591942366469e-07 0 1.2188591942366466e-07 0 1.2189591942366467e-07 0.00021 1.2190591942366468e-07 0 1.2190591942366466e-07 0 1.2191591942366467e-07 0.00021 1.2192591942366468e-07 0 1.2192591942366465e-07 0 1.2193591942366466e-07 0.00021 1.2194591942366467e-07 0 1.2194591942366465e-07 0 1.2195591942366466e-07 0.00021 1.2196591942366467e-07 0 1.2196591942366464e-07 0 1.2197591942366466e-07 0.00021 1.2198591942366467e-07 0 1.2199785018397192e-07 0 1.2200785018397193e-07 0.00021 1.2201785018397194e-07 0 1.2204471002076844e-07 0 1.2205471002076845e-07 0.00021 1.2206471002076846e-07 0 1.2206471002076844e-07 0 1.2207471002076845e-07 0.00021 1.2208471002076846e-07 0 1.2220070000124018e-07 0 1.222107000012402e-07 0.00021 1.222207000012402e-07 0 1.2222070000124018e-07 0 1.222307000012402e-07 0.00021 1.222407000012402e-07 0 1.2224070000124017e-07 0 1.2225070000124019e-07 0.00021 1.222607000012402e-07 0 1.2227992243679664e-07 0 1.2228992243679665e-07 0.00021 1.2229992243679666e-07 0 1.2229992243679664e-07 0 1.2230992243679665e-07 0.00021 1.2231992243679666e-07 0 1.2231992243679663e-07 0 1.2232992243679665e-07 0.00021 1.2233992243679666e-07 0 1.223590722558109e-07 0 1.223690722558109e-07 0.00021 1.2237907225581092e-07 0 1.223790722558109e-07 0 1.223890722558109e-07 0.00021 1.2239907225581092e-07 0 1.2243200711635881e-07 0 1.2244200711635883e-07 0.00021 1.2245200711635884e-07 0 1.2254349949692733e-07 0 1.2255349949692735e-07 0.00021 1.2256349949692736e-07 0 1.2256349949692733e-07 0 1.2257349949692734e-07 0.00021 1.2258349949692735e-07 0 1.2258349949692733e-07 0 1.2259349949692734e-07 0.00021 1.2260349949692735e-07 0 1.2260349949692732e-07 0 1.2261349949692733e-07 0.00021 1.2262349949692735e-07 0 1.2262349949692732e-07 0 1.2263349949692733e-07 0.00021 1.2264349949692734e-07 0 1.2264349949692732e-07 0 1.2265349949692733e-07 0.00021 1.2266349949692734e-07 0 1.226634994969273e-07 0 1.2267349949692732e-07 0.00021 1.2268349949692733e-07 0 1.226834994969273e-07 0 1.2269349949692732e-07 0.00021 1.2270349949692733e-07 0 1.227034994969273e-07 0 1.2271349949692732e-07 0.00021 1.2272349949692733e-07 0 1.2275243647826533e-07 0 1.2276243647826534e-07 0.00021 1.2277243647826535e-07 0 1.2281291854457807e-07 0 1.2282291854457808e-07 0.00021 1.228329185445781e-07 0 1.2284504530011798e-07 0 1.22855045300118e-07 0.00021 1.22865045300118e-07 0 1.2297857007150393e-07 0 1.2298857007150395e-07 0.00021 1.2299857007150396e-07 0 1.2299857007150393e-07 0 1.2300857007150394e-07 0.00021 1.2301857007150395e-07 0 1.2301857007150393e-07 0 1.2302857007150394e-07 0.00021 1.2303857007150395e-07 0 1.2303857007150392e-07 0 1.2304857007150393e-07 0.00021 1.2305857007150395e-07 0 1.2305857007150392e-07 0 1.2306857007150393e-07 0.00021 1.2307857007150394e-07 0 1.230983287954641e-07 0 1.2310832879546412e-07 0.00021 1.2311832879546413e-07 0 1.2315499214286877e-07 0 1.2316499214286878e-07 0.00021 1.231749921428688e-07 0 1.2317623654488536e-07 0 1.2318623654488537e-07 0.00021 1.2319623654488539e-07 0 1.2319987484883632e-07 0 1.2320987484883633e-07 0.00021 1.2321987484883634e-07 0 1.2321987484883631e-07 0 1.2322987484883633e-07 0.00021 1.2323987484883634e-07 0 1.232398748488363e-07 0 1.2324987484883632e-07 0.00021 1.2325987484883633e-07 0 1.23260076087777e-07 0 1.2327007608777702e-07 0.00021 1.2328007608777703e-07 0 1.23280076087777e-07 0 1.2329007608777702e-07 0.00021 1.2330007608777703e-07 0 1.23300076087777e-07 0 1.2331007608777701e-07 0.00021 1.2332007608777702e-07 0 1.23320076087777e-07 0 1.23330076087777e-07 0.00021 1.2334007608777702e-07 0 1.23340076087777e-07 0 1.23350076087777e-07 0.00021 1.2336007608777702e-07 0 1.2339681278620638e-07 0 1.234068127862064e-07 0.00021 1.234168127862064e-07 0 1.234231638505904e-07 0 1.234331638505904e-07 0.00021 1.2344316385059042e-07 0 1.2349677073221808e-07 0 1.235067707322181e-07 0.00021 1.235167707322181e-07 0 1.2351677073221807e-07 0 1.2352677073221809e-07 0.00021 1.235367707322181e-07 0 1.2353677073221807e-07 0 1.2354677073221808e-07 0.00021 1.235567707322181e-07 0 1.2355836560722874e-07 0 1.2356836560722875e-07 0.00021 1.2357836560722876e-07 0 1.2357836560722873e-07 0 1.2358836560722874e-07 0.00021 1.2359836560722875e-07 0 1.2359836560722873e-07 0 1.2360836560722874e-07 0.00021 1.2361836560722875e-07 0 1.236463451101102e-07 0 1.2365634511011022e-07 0.00021 1.2366634511011023e-07 0 1.2370728474701827e-07 0 1.2371728474701828e-07 0.00021 1.237272847470183e-07 0 1.237390369315373e-07 0 1.237490369315373e-07 0.00021 1.237590369315373e-07 0 1.238191947447087e-07 0 1.238291947447087e-07 0.00021 1.238391947447087e-07 0 1.238606736014015e-07 0 1.238706736014015e-07 0.00021 1.2388067360140152e-07 0 1.238806736014015e-07 0 1.238906736014015e-07 0.00021 1.2390067360140152e-07 0 1.239006736014015e-07 0 1.239106736014015e-07 0.00021 1.239206736014015e-07 0 1.2392067360140149e-07 0 1.239306736014015e-07 0.00021 1.239406736014015e-07 0 1.2394067360140148e-07 0 1.239506736014015e-07 0.00021 1.239606736014015e-07 0 1.2404579348999815e-07 0 1.2405579348999816e-07 0.00021 1.2406579348999817e-07 0 1.2406579348999814e-07 0 1.2407579348999815e-07 0.00021 1.2408579348999816e-07 0 1.2408579348999814e-07 0 1.2409579348999815e-07 0.00021 1.2410579348999816e-07 0 1.2410579348999813e-07 0 1.2411579348999815e-07 0.00021 1.2412579348999816e-07 0 1.2412579348999813e-07 0 1.2413579348999814e-07 0.00021 1.2414579348999815e-07 0 1.2414579348999813e-07 0 1.2415579348999814e-07 0.00021 1.2416579348999815e-07 0 1.2416579348999812e-07 0 1.2417579348999813e-07 0.00021 1.2418579348999815e-07 0 1.2418579348999812e-07 0 1.2419579348999813e-07 0.00021 1.2420579348999814e-07 0 1.2420579348999812e-07 0 1.2421579348999813e-07 0.00021 1.2422579348999814e-07 0 1.242257934899981e-07 0 1.2423579348999812e-07 0.00021 1.2424579348999813e-07 0 1.242457934899981e-07 0 1.2425579348999812e-07 0.00021 1.2426579348999813e-07 0 1.242657934899981e-07 0 1.2427579348999812e-07 0.00021 1.2428579348999813e-07 0 1.242857934899981e-07 0 1.242957934899981e-07 0.00021 1.2430579348999812e-07 0 1.243057934899981e-07 0 1.243157934899981e-07 0.00021 1.2432579348999812e-07 0 1.243257934899981e-07 0 1.243357934899981e-07 0.00021 1.2434579348999812e-07 0 1.243457934899981e-07 0 1.243557934899981e-07 0.00021 1.243657934899981e-07 0 1.2436579348999808e-07 0 1.243757934899981e-07 0.00021 1.243857934899981e-07 0 1.2438579348999808e-07 0 1.243957934899981e-07 0.00021 1.244057934899981e-07 0 1.2440579348999808e-07 0 1.244157934899981e-07 0.00021 1.244257934899981e-07 0 1.244274202137608e-07 0 1.2443742021376081e-07 0.00021 1.2444742021376083e-07 0 1.244474202137608e-07 0 1.244574202137608e-07 0.00021 1.2446742021376082e-07 0 1.244674202137608e-07 0 1.244774202137608e-07 0.00021 1.2448742021376082e-07 0 1.244874202137608e-07 0 1.244974202137608e-07 0.00021 1.2450742021376081e-07 0 1.245074202137608e-07 0 1.245174202137608e-07 0.00021 1.245274202137608e-07 0 1.2452742021376078e-07 0 1.245374202137608e-07 0.00021 1.245474202137608e-07 0 1.2454742021376078e-07 0 1.245574202137608e-07 0.00021 1.245674202137608e-07 0 1.2456742021376078e-07 0 1.245774202137608e-07 0.00021 1.245874202137608e-07 0 1.2458742021376077e-07 0 1.2459742021376078e-07 0.00021 1.246074202137608e-07 0 1.2460742021376077e-07 0 1.2461742021376078e-07 0.00021 1.246274202137608e-07 0 1.2462742021376076e-07 0 1.2463742021376078e-07 0.00021 1.246474202137608e-07 0 1.2467219461030572e-07 0 1.2468219461030573e-07 0.00021 1.2469219461030575e-07 0 1.2469219461030572e-07 0 1.2470219461030573e-07 0.00021 1.2471219461030574e-07 0 1.247354877009338e-07 0 1.247454877009338e-07 0.00021 1.2475548770093382e-07 0 1.2477185004600126e-07 0 1.2478185004600127e-07 0.00021 1.2479185004600128e-07 0 1.2480369102623994e-07 0 1.2481369102623996e-07 0.00021 1.2482369102623997e-07 0 1.2482369102623994e-07 0 1.2483369102623995e-07 0.00021 1.2484369102623996e-07 0 1.2484369102623994e-07 0 1.2485369102623995e-07 0.00021 1.2486369102623996e-07 0 1.2486691801605987e-07 0 1.2487691801605988e-07 0.00021 1.248869180160599e-07 0 1.249338501320962e-07 0 1.249438501320962e-07 0.00021 1.2495385013209622e-07 0 1.249538501320962e-07 0 1.249638501320962e-07 0.00021 1.2497385013209622e-07 0 1.2503269936126177e-07 0 1.2504269936126179e-07 0.00021 1.250526993612618e-07 0 1.2507020282020001e-07 0 1.2508020282020003e-07 0.00021 1.2509020282020004e-07 0 1.2520027867464518e-07 0 1.252102786746452e-07 0.00021 1.252202786746452e-07 0 1.252629809998608e-07 0 1.2527298099986082e-07 0.00021 1.2528298099986083e-07 0 1.252829809998608e-07 0 1.2529298099986081e-07 0.00021 1.2530298099986083e-07 0 1.253108411814858e-07 0 1.253208411814858e-07 0.00021 1.2533084118148581e-07 0 1.2538216449148858e-07 0 1.253921644914886e-07 0.00021 1.254021644914886e-07 0 1.254291273314217e-07 0 1.254391273314217e-07 0.00021 1.2544912733142172e-07 0 1.254491273314217e-07 0 1.254591273314217e-07 0.00021 1.254691273314217e-07 0 1.2546912733142169e-07 0 1.254791273314217e-07 0.00021 1.254891273314217e-07 0 1.2548912733142168e-07 0 1.254991273314217e-07 0.00021 1.255091273314217e-07 0 1.2552114420450999e-07 0 1.2553114420451e-07 0.00021 1.2554114420451e-07 0 1.2554114420450998e-07 0 1.2555114420451e-07 0.00021 1.2556114420451e-07 0 1.2556114420450998e-07 0 1.2557114420451e-07 0.00021 1.2558114420451e-07 0 1.2558114420450997e-07 0 1.2559114420450999e-07 0.00021 1.2560114420451e-07 0 1.2569177831264878e-07 0 1.257017783126488e-07 0.00021 1.257117783126488e-07 0 1.2571177831264878e-07 0 1.257217783126488e-07 0.00021 1.257317783126488e-07 0 1.2574009458929925e-07 0 1.2575009458929927e-07 0.00021 1.2576009458929928e-07 0 1.258023356786955e-07 0 1.258123356786955e-07 0.00021 1.2582233567869552e-07 0 1.258223356786955e-07 0 1.258323356786955e-07 0.00021 1.2584233567869552e-07 0 1.258427482979929e-07 0 1.258527482979929e-07 0.00021 1.2586274829799292e-07 0 1.2586752581245777e-07 0 1.2587752581245779e-07 0.00021 1.258875258124578e-07 0 1.2597221349053067e-07 0 1.2598221349053068e-07 0.00021 1.259922134905307e-07 0 1.2599221349053066e-07 0 1.2600221349053067e-07 0.00021 1.2601221349053069e-07 0 1.2601221349053066e-07 0 1.2602221349053067e-07 0.00021 1.2603221349053068e-07 0 1.2609544077134507e-07 0 1.2610544077134509e-07 0.00021 1.261154407713451e-07 0 1.2615456368801944e-07 0 1.2616456368801945e-07 0.00021 1.2617456368801946e-07 0 1.2617456368801943e-07 0 1.2618456368801944e-07 0.00021 1.2619456368801945e-07 0 1.2623508324331302e-07 0 1.2624508324331303e-07 0.00021 1.2625508324331304e-07 0 1.2625508324331302e-07 0 1.2626508324331303e-07 0.00021 1.2627508324331304e-07 0 1.2632825276174965e-07 0 1.2633825276174966e-07 0.00021 1.2634825276174967e-07 0 1.2634825276174965e-07 0 1.2635825276174966e-07 0.00021 1.2636825276174967e-07 0 1.2636825276174964e-07 0 1.2637825276174966e-07 0.00021 1.2638825276174967e-07 0 1.2638825276174964e-07 0 1.2639825276174965e-07 0.00021 1.2640825276174966e-07 0 1.2640825276174964e-07 0 1.2641825276174965e-07 0.00021 1.2642825276174966e-07 0 1.2642825276174963e-07 0 1.2643825276174964e-07 0.00021 1.2644825276174966e-07 0 1.2644825276174963e-07 0 1.2645825276174964e-07 0.00021 1.2646825276174965e-07 0 1.2646825276174963e-07 0 1.2647825276174964e-07 0.00021 1.2648825276174965e-07 0 1.2648825276174962e-07 0 1.2649825276174963e-07 0.00021 1.2650825276174964e-07 0 1.2652265690749712e-07 0 1.2653265690749713e-07 0.00021 1.2654265690749714e-07 0 1.2654265690749712e-07 0 1.2655265690749713e-07 0.00021 1.2656265690749714e-07 0 1.2657277057535003e-07 0 1.2658277057535004e-07 0.00021 1.2659277057535005e-07 0 1.2659831307166143e-07 0 1.2660831307166144e-07 0.00021 1.2661831307166145e-07 0 1.2661831307166142e-07 0 1.2662831307166143e-07 0.00021 1.2663831307166145e-07 0 1.266423981069704e-07 0 1.2665239810697042e-07 0.00021 1.2666239810697043e-07 0 1.266836704136418e-07 0 1.2669367041364182e-07 0.00021 1.2670367041364183e-07 0 1.267036704136418e-07 0 1.2671367041364182e-07 0.00021 1.2672367041364183e-07 0 1.2672795669594704e-07 0 1.2673795669594705e-07 0.00021 1.2674795669594706e-07 0 1.2674795669594704e-07 0 1.2675795669594705e-07 0.00021 1.2676795669594706e-07 0 1.267794983050768e-07 0 1.267894983050768e-07 0.00021 1.267994983050768e-07 0 1.2680944972188997e-07 0 1.2681944972188998e-07 0.00021 1.2682944972189e-07 0 1.2682944972188996e-07 0 1.2683944972188997e-07 0.00021 1.2684944972188998e-07 0 1.268635996742059e-07 0 1.268735996742059e-07 0.00021 1.2688359967420592e-07 0 1.268835996742059e-07 0 1.268935996742059e-07 0.00021 1.2690359967420592e-07 0 1.269035996742059e-07 0 1.269135996742059e-07 0.00021 1.269235996742059e-07 0 1.2696924028405382e-07 0 1.2697924028405383e-07 0.00021 1.2698924028405385e-07 0 1.2703373385534145e-07 0 1.2704373385534146e-07 0.00021 1.2705373385534147e-07 0 1.2705373385534145e-07 0 1.2706373385534146e-07 0.00021 1.2707373385534147e-07 0 1.2710788329004658e-07 0 1.271178832900466e-07 0.00021 1.271278832900466e-07 0 1.2712979659658677e-07 0 1.2713979659658679e-07 0.00021 1.271497965965868e-07 0 1.2714979659658677e-07 0 1.2715979659658678e-07 0.00021 1.271697965965868e-07 0 1.2716979659658677e-07 0 1.2717979659658678e-07 0.00021 1.271897965965868e-07 0 1.2718979659658676e-07 0 1.2719979659658677e-07 0.00021 1.2720979659658679e-07 0 1.2720979659658676e-07 0 1.2721979659658677e-07 0.00021 1.2722979659658678e-07 0 1.272862401994398e-07 0 1.272962401994398e-07 0.00021 1.2730624019943982e-07 0 1.273062401994398e-07 0 1.273162401994398e-07 0.00021 1.2732624019943982e-07 0 1.273262401994398e-07 0 1.273362401994398e-07 0.00021 1.2734624019943981e-07 0 1.273462401994398e-07 0 1.273562401994398e-07 0.00021 1.273662401994398e-07 0 1.2736624019943978e-07 0 1.273762401994398e-07 0.00021 1.273862401994398e-07 0 1.2738624019943978e-07 0 1.273962401994398e-07 0.00021 1.274062401994398e-07 0 1.2740624019943978e-07 0 1.274162401994398e-07 0.00021 1.274262401994398e-07 0 1.2742624019943977e-07 0 1.2743624019943978e-07 0.00021 1.274462401994398e-07 0 1.2744624019943977e-07 0 1.2745624019943978e-07 0.00021 1.274662401994398e-07 0 1.2746624019943977e-07 0 1.2747624019943978e-07 0.00021 1.274862401994398e-07 0 1.2748624019943976e-07 0 1.2749624019943977e-07 0.00021 1.2750624019943978e-07 0 1.2750624019943976e-07 0 1.2751624019943977e-07 0.00021 1.2752624019943978e-07 0 1.2752624019943975e-07 0 1.2753624019943977e-07 0.00021 1.2754624019943978e-07 0 1.2754624019943975e-07 0 1.2755624019943976e-07 0.00021 1.2756624019943977e-07 0 1.2765237301065436e-07 0 1.2766237301065438e-07 0.00021 1.276723730106544e-07 0 1.2767237301065436e-07 0 1.2768237301065437e-07 0.00021 1.2769237301065438e-07 0 1.2769237301065436e-07 0 1.2770237301065437e-07 0.00021 1.2771237301065438e-07 0 1.2771237301065435e-07 0 1.2772237301065436e-07 0.00021 1.2773237301065438e-07 0 1.2777652544375237e-07 0 1.2778652544375238e-07 0.00021 1.277965254437524e-07 0 1.278388029850511e-07 0 1.278488029850511e-07 0.00021 1.2785880298505112e-07 0 1.2786735866922818e-07 0 1.278773586692282e-07 0.00021 1.278873586692282e-07 0 1.2788735866922817e-07 0 1.2789735866922818e-07 0.00021 1.279073586692282e-07 0 1.2790735866922817e-07 0 1.2791735866922818e-07 0.00021 1.279273586692282e-07 0 1.2792735866922816e-07 0 1.2793735866922818e-07 0.00021 1.279473586692282e-07 0 1.2794735866922816e-07 0 1.2795735866922817e-07 0.00021 1.2796735866922818e-07 0 1.280565056374539e-07 0 1.2806650563745392e-07 0.00021 1.2807650563745393e-07 0 1.2814636760906052e-07 0 1.2815636760906053e-07 0.00021 1.2816636760906054e-07 0 1.2820489770017564e-07 0 1.2821489770017566e-07 0.00021 1.2822489770017567e-07 0 1.2826556914715058e-07 0 1.282755691471506e-07 0.00021 1.282855691471506e-07 0 1.2833769701988323e-07 0 1.2834769701988324e-07 0.00021 1.2835769701988325e-07 0 1.2835769701988323e-07 0 1.2836769701988324e-07 0.00021 1.2837769701988325e-07 0 1.2839197903421384e-07 0 1.2840197903421385e-07 0.00021 1.2841197903421386e-07 0 1.2845212253998473e-07 0 1.2846212253998474e-07 0.00021 1.2847212253998475e-07 0 1.2849044733074592e-07 0 1.2850044733074593e-07 0.00021 1.2851044733074594e-07 0 1.286161567348054e-07 0 1.286261567348054e-07 0.00021 1.2863615673480542e-07 0 1.2866185259652685e-07 0 1.2867185259652687e-07 0.00021 1.2868185259652688e-07 0 1.2868185259652685e-07 0 1.2869185259652686e-07 0.00021 1.2870185259652687e-07 0 1.2870185259652685e-07 0 1.2871185259652686e-07 0.00021 1.2872185259652687e-07 0 1.2872185259652684e-07 0 1.2873185259652685e-07 0.00021 1.2874185259652687e-07 0 1.2874185259652684e-07 0 1.2875185259652685e-07 0.00021 1.2876185259652686e-07 0 1.2876185259652684e-07 0 1.2877185259652685e-07 0.00021 1.2878185259652686e-07 0 1.2878185259652683e-07 0 1.2879185259652684e-07 0.00021 1.2880185259652685e-07 0 1.2880345647800354e-07 0 1.2881345647800355e-07 0.00021 1.2882345647800356e-07 0 1.2882345647800354e-07 0 1.2883345647800355e-07 0.00021 1.2884345647800356e-07 0 1.2897311865830083e-07 0 1.2898311865830084e-07 0.00021 1.2899311865830085e-07 0 1.2899311865830082e-07 0 1.2900311865830084e-07 0.00021 1.2901311865830085e-07 0 1.2901464502340138e-07 0 1.290246450234014e-07 0.00021 1.290346450234014e-07 0 1.2903464502340138e-07 0 1.290446450234014e-07 0.00021 1.290546450234014e-07 0 1.2906998932818976e-07 0 1.2907998932818977e-07 0.00021 1.2908998932818978e-07 0 1.2910797850543448e-07 0 1.291179785054345e-07 0.00021 1.291279785054345e-07 0 1.2912797850543448e-07 0 1.2913797850543449e-07 0.00021 1.291479785054345e-07 0 1.2914797850543447e-07 0 1.2915797850543448e-07 0.00021 1.291679785054345e-07 0 1.291679892578043e-07 0 1.291779892578043e-07 0.00021 1.2918798925780432e-07 0 1.2924784533553727e-07 0 1.2925784533553728e-07 0.00021 1.292678453355373e-07 0 1.292773565338384e-07 0 1.2928735653383842e-07 0.00021 1.2929735653383843e-07 0 1.2931755416782935e-07 0 1.2932755416782936e-07 0.00021 1.2933755416782937e-07 0 1.294216894227944e-07 0 1.294316894227944e-07 0.00021 1.2944168942279442e-07 0 1.294416894227944e-07 0 1.294516894227944e-07 0.00021 1.294616894227944e-07 0 1.2947803664328003e-07 0 1.2948803664328004e-07 0.00021 1.2949803664328006e-07 0 1.2954756105152712e-07 0 1.2955756105152713e-07 0.00021 1.2956756105152714e-07 0 1.2956756105152711e-07 0 1.2957756105152712e-07 0.00021 1.2958756105152714e-07 0 1.295875610515271e-07 0 1.2959756105152712e-07 0.00021 1.2960756105152713e-07 0 1.2965966074943307e-07 0 1.2966966074943308e-07 0.00021 1.296796607494331e-07 0 1.2974426168816972e-07 0 1.2975426168816973e-07 0.00021 1.2976426168816974e-07 0 1.297642616881697e-07 0 1.2977426168816972e-07 0.00021 1.2978426168816973e-07 0 1.297842616881697e-07 0 1.2979426168816972e-07 0.00021 1.2980426168816973e-07 0 1.298042616881697e-07 0 1.2981426168816972e-07 0.00021 1.2982426168816973e-07 0 1.298242616881697e-07 0 1.298342616881697e-07 0.00021 1.2984426168816972e-07 0 1.2986971333526787e-07 0 1.2987971333526788e-07 0.00021 1.298897133352679e-07 0 1.2988971333526787e-07 0 1.2989971333526788e-07 0.00021 1.299097133352679e-07 0 1.2990971333526786e-07 0 1.2991971333526788e-07 0.00021 1.2992971333526789e-07 0 1.2992971333526786e-07 0 1.2993971333526787e-07 0.00021 1.2994971333526788e-07 0 1.2994971333526786e-07 0 1.2995971333526787e-07 0.00021 1.2996971333526788e-07 0 1.2996971333526785e-07 0 1.2997971333526786e-07 0.00021 1.2998971333526788e-07 0 1.2998971333526785e-07 0 1.2999971333526786e-07 0.00021 1.3000971333526787e-07 0 1.3000971333526785e-07 0 1.3001971333526786e-07 0.00021 1.3002971333526787e-07 0 1.300313331275905e-07 0 1.3004133312759051e-07 0.00021 1.3005133312759053e-07 0 1.3013124703612544e-07 0 1.3014124703612545e-07 0.00021 1.3015124703612546e-07 0 1.3016128323252173e-07 0 1.3017128323252174e-07 0.00021 1.3018128323252175e-07 0 1.3025960972776437e-07 0 1.3026960972776438e-07 0.00021 1.302796097277644e-07 0 1.3027960972776437e-07 0 1.3028960972776438e-07 0.00021 1.302996097277644e-07 0 1.3031289422347161e-07 0 1.3032289422347162e-07 0.00021 1.3033289422347164e-07 0 1.3034794539253186e-07 0 1.3035794539253187e-07 0.00021 1.3036794539253188e-07 0 1.3036794539253186e-07 0 1.3037794539253187e-07 0.00021 1.3038794539253188e-07 0 1.3038794539253185e-07 0 1.3039794539253186e-07 0.00021 1.3040794539253187e-07 0 1.3044184315543262e-07 0 1.3045184315543263e-07 0.00021 1.3046184315543264e-07 0 1.3046184315543262e-07 0 1.3047184315543263e-07 0.00021 1.3048184315543264e-07 0 1.3048184315543261e-07 0 1.3049184315543262e-07 0.00021 1.3050184315543264e-07 0 1.305018431554326e-07 0 1.3051184315543262e-07 0.00021 1.3052184315543263e-07 0 1.305218431554326e-07 0 1.3053184315543262e-07 0.00021 1.3054184315543263e-07 0 1.305418431554326e-07 0 1.3055184315543261e-07 0.00021 1.3056184315543262e-07 0 1.305618431554326e-07 0 1.305718431554326e-07 0.00021 1.3058184315543262e-07 0 1.305818431554326e-07 0 1.305918431554326e-07 0.00021 1.3060184315543262e-07 0 1.3065146118033384e-07 0 1.3066146118033386e-07 0.00021 1.3067146118033387e-07 0 1.3067146118033384e-07 0 1.3068146118033385e-07 0.00021 1.3069146118033386e-07 0 1.3069146118033384e-07 0 1.3070146118033385e-07 0.00021 1.3071146118033386e-07 0 1.3071882697769109e-07 0 1.307288269776911e-07 0.00021 1.307388269776911e-07 0 1.3082477092416045e-07 0 1.3083477092416046e-07 0.00021 1.3084477092416048e-07 0 1.3084477092416045e-07 0 1.3085477092416046e-07 0.00021 1.3086477092416047e-07 0 1.3086477092416045e-07 0 1.3087477092416046e-07 0.00021 1.3088477092416047e-07 0 1.3090452920555018e-07 0 1.309145292055502e-07 0.00021 1.309245292055502e-07 0 1.3094038998016386e-07 0 1.3095038998016387e-07 0.00021 1.3096038998016388e-07 0 1.3097377095635333e-07 0 1.3098377095635334e-07 0.00021 1.3099377095635335e-07 0 1.3099377095635332e-07 0 1.3100377095635333e-07 0.00021 1.3101377095635335e-07 0 1.3101377095635332e-07 0 1.3102377095635333e-07 0.00021 1.3103377095635334e-07 0 1.3103377095635332e-07 0 1.3104377095635333e-07 0.00021 1.3105377095635334e-07 0 1.310537709563533e-07 0 1.3106377095635332e-07 0.00021 1.3107377095635333e-07 0 1.3107810771455387e-07 0 1.3108810771455388e-07 0.00021 1.310981077145539e-07 0 1.311110367338767e-07 0 1.311210367338767e-07 0.00021 1.3113103673387671e-07 0 1.3120262976573757e-07 0 1.3121262976573759e-07 0.00021 1.312226297657376e-07 0 1.3122262976573757e-07 0 1.3123262976573758e-07 0.00021 1.312426297657376e-07 0 1.3124262976573757e-07 0 1.3125262976573758e-07 0.00021 1.312626297657376e-07 0 1.3126990903393875e-07 0 1.3127990903393877e-07 0.00021 1.3128990903393878e-07 0 1.31341076757207e-07 0 1.3135107675720702e-07 0.00021 1.3136107675720703e-07 0 1.313643030358446e-07 0 1.3137430303584462e-07 0.00021 1.3138430303584463e-07 0 1.313843030358446e-07 0 1.3139430303584461e-07 0.00021 1.3140430303584463e-07 0 1.314043030358446e-07 0 1.314143030358446e-07 0.00021 1.3142430303584462e-07 0 1.314243030358446e-07 0 1.314343030358446e-07 0.00021 1.3144430303584462e-07 0 1.3145422411468265e-07 0 1.3146422411468266e-07 0.00021 1.3147422411468267e-07 0 1.3147422411468264e-07 0 1.3148422411468266e-07 0.00021 1.3149422411468267e-07 0 1.3149422411468264e-07 0 1.3150422411468265e-07 0.00021 1.3151422411468266e-07 0 1.3156434402183267e-07 0 1.3157434402183269e-07 0.00021 1.315843440218327e-07 0 1.3158434402183267e-07 0 1.3159434402183268e-07 0.00021 1.316043440218327e-07 0 1.3160434402183267e-07 0 1.3161434402183268e-07 0.00021 1.316243440218327e-07 0 1.3164607678215742e-07 0 1.3165607678215743e-07 0.00021 1.3166607678215744e-07 0 1.3166607678215742e-07 0 1.3167607678215743e-07 0.00021 1.3168607678215744e-07 0 1.3169765938017848e-07 0 1.317076593801785e-07 0.00021 1.317176593801785e-07 0 1.317251087282794e-07 0 1.317351087282794e-07 0.00021 1.3174510872827942e-07 0 1.3176799455229094e-07 0 1.3177799455229095e-07 0.00021 1.3178799455229097e-07 0 1.3182724484602531e-07 0 1.3183724484602533e-07 0.00021 1.3184724484602534e-07 0 1.318472448460253e-07 0 1.3185724484602532e-07 0.00021 1.3186724484602533e-07 0 1.3187419968184176e-07 0 1.3188419968184177e-07 0.00021 1.3189419968184179e-07 0 1.3197206942838326e-07 0 1.3198206942838327e-07 0.00021 1.3199206942838328e-07 0 1.3199206942838325e-07 0 1.3200206942838327e-07 0.00021 1.3201206942838328e-07 0 1.3221893052909528e-07 0 1.322289305290953e-07 0.00021 1.322389305290953e-07 0 1.3223893052909527e-07 0 1.3224893052909529e-07 0.00021 1.322589305290953e-07 0 1.323162608999805e-07 0 1.323262608999805e-07 0.00021 1.3233626089998052e-07 0 1.323362608999805e-07 0 1.323462608999805e-07 0.00021 1.3235626089998051e-07 0 1.3248209585020065e-07 0 1.3249209585020066e-07 0.00021 1.3250209585020067e-07 0 1.325140497802547e-07 0 1.3252404978025472e-07 0.00021 1.3253404978025473e-07 0 1.325340497802547e-07 0 1.3254404978025471e-07 0.00021 1.3255404978025473e-07 0 1.325540497802547e-07 0 1.325640497802547e-07 0.00021 1.3257404978025472e-07 0 1.325740497802547e-07 0 1.325840497802547e-07 0.00021 1.3259404978025472e-07 0 1.325940497802547e-07 0 1.326040497802547e-07 0.00021 1.3261404978025471e-07 0 1.326140497802547e-07 0 1.326240497802547e-07 0.00021 1.326340497802547e-07 0 1.3263404978025468e-07 0 1.326440497802547e-07 0.00021 1.326540497802547e-07 0 1.3265404978025468e-07 0 1.326640497802547e-07 0.00021 1.326740497802547e-07 0 1.3267404978025468e-07 0 1.326840497802547e-07 0.00021 1.326940497802547e-07 0 1.3270066093356277e-07 0 1.3271066093356278e-07 0.00021 1.327206609335628e-07 0 1.3272066093356276e-07 0 1.3273066093356277e-07 0.00021 1.3274066093356278e-07 0 1.3274066093356276e-07 0 1.3275066093356277e-07 0.00021 1.3276066093356278e-07 0 1.3276944815075625e-07 0 1.3277944815075626e-07 0.00021 1.3278944815075627e-07 0 1.3281887215161316e-07 0 1.3282887215161317e-07 0.00021 1.3283887215161318e-07 0 1.3283887215161316e-07 0 1.3284887215161317e-07 0.00021 1.3285887215161318e-07 0 1.3288274524993786e-07 0 1.3289274524993788e-07 0.00021 1.3290274524993789e-07 0 1.3291091698410056e-07 0 1.3292091698410058e-07 0.00021 1.329309169841006e-07 0 1.3298718104519195e-07 0 1.3299718104519197e-07 0.00021 1.3300718104519198e-07 0 1.3300718104519195e-07 0 1.3301718104519196e-07 0.00021 1.3302718104519197e-07 0 1.3309624108751594e-07 0 1.3310624108751595e-07 0.00021 1.3311624108751596e-07 0 1.3311624108751593e-07 0 1.3312624108751594e-07 0.00021 1.3313624108751596e-07 0 1.331938572237811e-07 0 1.3320385722378112e-07 0.00021 1.3321385722378113e-07 0 1.3325434368907044e-07 0 1.3326434368907046e-07 0.00021 1.3327434368907047e-07 0 1.3329523207663888e-07 0 1.333052320766389e-07 0.00021 1.333152320766389e-07 0 1.3331523207663887e-07 0 1.3332523207663888e-07 0.00021 1.333352320766389e-07 0 1.3333523207663887e-07 0 1.3334523207663888e-07 0.00021 1.333552320766389e-07 0 1.3335523207663887e-07 0 1.3336523207663888e-07 0.00021 1.333752320766389e-07 0 1.3337523207663886e-07 0 1.3338523207663887e-07 0.00021 1.3339523207663888e-07 0 1.3346690548055354e-07 0 1.3347690548055355e-07 0.00021 1.3348690548055356e-07 0 1.3350973929579244e-07 0 1.3351973929579245e-07 0.00021 1.3352973929579247e-07 0 1.3352973929579244e-07 0 1.3353973929579245e-07 0.00021 1.3354973929579246e-07 0 1.3354973929579244e-07 0 1.3355973929579245e-07 0.00021 1.3356973929579246e-07 0 1.3358792180632308e-07 0 1.335979218063231e-07 0.00021 1.336079218063231e-07 0 1.3360792180632308e-07 0 1.336179218063231e-07 0.00021 1.336279218063231e-07 0 1.3362792180632308e-07 0 1.336379218063231e-07 0.00021 1.336479218063231e-07 0 1.3364792180632307e-07 0 1.3365792180632308e-07 0.00021 1.336679218063231e-07 0 1.337231945586698e-07 0 1.337331945586698e-07 0.00021 1.3374319455866982e-07 0 1.337841137814457e-07 0 1.337941137814457e-07 0.00021 1.3380411378144571e-07 0 1.3384927176681054e-07 0 1.3385927176681055e-07 0.00021 1.3386927176681056e-07 0 1.3386927176681053e-07 0 1.3387927176681054e-07 0.00021 1.3388927176681056e-07 0 1.339528867299008e-07 0 1.3396288672990081e-07 0.00021 1.3397288672990083e-07 0 1.339801053714804e-07 0 1.3399010537148042e-07 0.00021 1.3400010537148043e-07 0 1.3400503351216483e-07 0 1.3401503351216484e-07 0.00021 1.3402503351216485e-07 0 1.3402503351216482e-07 0 1.3403503351216483e-07 0.00021 1.3404503351216484e-07 0 1.3404503351216482e-07 0 1.3405503351216483e-07 0.00021 1.3406503351216484e-07 0 1.340703904373381e-07 0 1.3408039043733812e-07 0.00021 1.3409039043733814e-07 0 1.3409284959402107e-07 0 1.3410284959402108e-07 0.00021 1.341128495940211e-07 0 1.3411284959402107e-07 0 1.3412284959402108e-07 0.00021 1.341328495940211e-07 0 1.341996345917435e-07 0 1.3420963459174352e-07 0.00021 1.3421963459174353e-07 0 1.342196345917435e-07 0 1.3422963459174352e-07 0.00021 1.3423963459174353e-07 0 1.342396345917435e-07 0 1.3424963459174351e-07 0.00021 1.3425963459174352e-07 0 1.342596345917435e-07 0 1.342696345917435e-07 0.00021 1.3427963459174352e-07 0 1.342796345917435e-07 0 1.342896345917435e-07 0.00021 1.3429963459174352e-07 0 1.3431222077785364e-07 0 1.3432222077785366e-07 0.00021 1.3433222077785367e-07 0 1.343515982262768e-07 0 1.343615982262768e-07 0.00021 1.343715982262768e-07 0 1.3437159822627678e-07 0 1.343815982262768e-07 0.00021 1.343915982262768e-07 0 1.3439159822627678e-07 0 1.344015982262768e-07 0.00021 1.344115982262768e-07 0 1.3441159822627678e-07 0 1.344215982262768e-07 0.00021 1.344315982262768e-07 0 1.3443159822627677e-07 0 1.3444159822627678e-07 0.00021 1.344515982262768e-07 0 1.3448995925976724e-07 0 1.3449995925976725e-07 0.00021 1.3450995925976726e-07 0 1.3450995925976723e-07 0 1.3451995925976724e-07 0.00021 1.3452995925976725e-07 0 1.3455431983484152e-07 0 1.3456431983484153e-07 0.00021 1.3457431983484154e-07 0 1.345743198348415e-07 0 1.3458431983484152e-07 0.00021 1.3459431983484154e-07 0 1.345943198348415e-07 0 1.3460431983484152e-07 0.00021 1.3461431983484153e-07 0 1.346271199238009e-07 0 1.3463711992380092e-07 0.00021 1.3464711992380093e-07 0 1.346471199238009e-07 0 1.3465711992380091e-07 0.00021 1.3466711992380093e-07 0 1.3469536531025173e-07 0 1.3470536531025175e-07 0.00021 1.3471536531025176e-07 0 1.3471536531025173e-07 0 1.3472536531025174e-07 0.00021 1.3473536531025175e-07 0 1.3473536531025173e-07 0 1.3474536531025174e-07 0.00021 1.3475536531025175e-07 0 1.3475536531025172e-07 0 1.3476536531025173e-07 0.00021 1.3477536531025175e-07 0 1.348087029048127e-07 0 1.348187029048127e-07 0.00021 1.3482870290481272e-07 0 1.349204889205595e-07 0 1.349304889205595e-07 0.00021 1.3494048892055952e-07 0 1.350303405381673e-07 0 1.3504034053816732e-07 0.00021 1.3505034053816733e-07 0 1.350503405381673e-07 0 1.3506034053816732e-07 0.00021 1.3507034053816733e-07 0 1.350703405381673e-07 0 1.350803405381673e-07 0.00021 1.3509034053816732e-07 0 1.351411047611913e-07 0 1.3515110476119132e-07 0.00021 1.3516110476119133e-07 0 1.351611047611913e-07 0 1.351711047611913e-07 0.00021 1.3518110476119132e-07 0 1.3519352709742474e-07 0 1.3520352709742475e-07 0.00021 1.3521352709742476e-07 0 1.3526124497791406e-07 0 1.3527124497791408e-07 0.00021 1.3528124497791409e-07 0 1.354730211579197e-07 0 1.354830211579197e-07 0.00021 1.3549302115791972e-07 0 1.3550676834621575e-07 0 1.3551676834621576e-07 0.00021 1.3552676834621577e-07 0 1.3552676834621574e-07 0 1.3553676834621575e-07 0.00021 1.3554676834621577e-07 0 1.3554676834621574e-07 0 1.3555676834621575e-07 0.00021 1.3556676834621576e-07 0 1.3556676834621574e-07 0 1.3557676834621575e-07 0.00021 1.3558676834621576e-07 0 1.3558676834621573e-07 0 1.3559676834621574e-07 0.00021 1.3560676834621575e-07 0 1.3560676834621573e-07 0 1.3561676834621574e-07 0.00021 1.3562676834621575e-07 0 1.3565513356684227e-07 0 1.3566513356684228e-07 0.00021 1.356751335668423e-07 0 1.3567774781149583e-07 0 1.3568774781149584e-07 0.00021 1.3569774781149585e-07 0 1.3573310880842477e-07 0 1.3574310880842478e-07 0.00021 1.357531088084248e-07 0 1.3575310880842477e-07 0 1.3576310880842478e-07 0.00021 1.357731088084248e-07 0 1.35780326300104e-07 0 1.35790326300104e-07 0.00021 1.3580032630010401e-07 0 1.35800326300104e-07 0 1.35810326300104e-07 0.00021 1.35820326300104e-07 0 1.3590225195387107e-07 0 1.3591225195387108e-07 0.00021 1.359222519538711e-07 0 1.359485593102372e-07 0 1.3595855931023722e-07 0.00021 1.3596855931023723e-07 0 1.3596894988129945e-07 0 1.3597894988129946e-07 0.00021 1.3598894988129947e-07 0 1.3599575020065931e-07 0 1.3600575020065933e-07 0.00021 1.3601575020065934e-07 0 1.3605826461430537e-07 0 1.3606826461430538e-07 0.00021 1.360782646143054e-07 0 1.3607826461430537e-07 0 1.3608826461430538e-07 0.00021 1.360982646143054e-07 0 1.3609826461430536e-07 0 1.3610826461430537e-07 0.00021 1.3611826461430538e-07 0 1.36125973193554e-07 0 1.3613597319355402e-07 0.00021 1.3614597319355403e-07 0 1.36145973193554e-07 0 1.3615597319355402e-07 0.00021 1.3616597319355403e-07 0 1.36165973193554e-07 0 1.36175973193554e-07 0.00021 1.3618597319355402e-07 0 1.36185973193554e-07 0 1.36195973193554e-07 0.00021 1.3620597319355402e-07 0 1.3631967027767652e-07 0 1.3632967027767654e-07 0.00021 1.3633967027767655e-07 0 1.3633967027767652e-07 0 1.3634967027767653e-07 0.00021 1.3635967027767654e-07 0 1.3635967027767652e-07 0 1.3636967027767653e-07 0.00021 1.3637967027767654e-07 0 1.3640204338882023e-07 0 1.3641204338882025e-07 0.00021 1.3642204338882026e-07 0 1.3642204338882023e-07 0 1.3643204338882024e-07 0.00021 1.3644204338882025e-07 0 1.3644921475794556e-07 0 1.3645921475794557e-07 0.00021 1.3646921475794558e-07 0 1.3646921475794555e-07 0 1.3647921475794556e-07 0.00021 1.3648921475794558e-07 0 1.3649140440483613e-07 0 1.3650140440483614e-07 0.00021 1.3651140440483615e-07 0 1.3651307831987748e-07 0 1.365230783198775e-07 0.00021 1.365330783198775e-07 0 1.3653307831987748e-07 0 1.365430783198775e-07 0.00021 1.365530783198775e-07 0 1.3655307831987748e-07 0 1.365630783198775e-07 0.00021 1.365730783198775e-07 0 1.3657307831987747e-07 0 1.3658307831987748e-07 0.00021 1.365930783198775e-07 0 1.3659307831987747e-07 0 1.3660307831987748e-07 0.00021 1.366130783198775e-07 0 1.3661307831987747e-07 0 1.3662307831987748e-07 0.00021 1.366330783198775e-07 0 1.3663307831987746e-07 0 1.3664307831987747e-07 0.00021 1.3665307831987748e-07 0 1.3666417711433914e-07 0 1.3667417711433915e-07 0.00021 1.3668417711433917e-07 0 1.3672789587573714e-07 0 1.3673789587573715e-07 0.00021 1.3674789587573716e-07 0 1.368007339951101e-07 0 1.368107339951101e-07 0.00021 1.3682073399511012e-07 0 1.3684711186812043e-07 0 1.3685711186812044e-07 0.00021 1.3686711186812045e-07 0 1.369521819850626e-07 0 1.369621819850626e-07 0.00021 1.3697218198506262e-07 0 1.369721819850626e-07 0 1.369821819850626e-07 0.00021 1.369921819850626e-07 0 1.3699218198506259e-07 0 1.370021819850626e-07 0.00021 1.370121819850626e-07 0 1.3701218198506258e-07 0 1.370221819850626e-07 0.00021 1.370321819850626e-07 0 1.3703218198506258e-07 0 1.370421819850626e-07 0.00021 1.370521819850626e-07 0 1.3705218198506257e-07 0 1.3706218198506259e-07 0.00021 1.370721819850626e-07 0 1.3707218198506257e-07 0 1.3708218198506258e-07 0.00021 1.370921819850626e-07 0 1.3709218198506257e-07 0 1.3710218198506258e-07 0.00021 1.371121819850626e-07 0 1.3711218198506256e-07 0 1.3712218198506257e-07 0.00021 1.3713218198506259e-07 0 1.372064199355136e-07 0 1.372164199355136e-07 0.00021 1.372264199355136e-07 0 1.3722641993551358e-07 0 1.372364199355136e-07 0.00021 1.372464199355136e-07 0 1.3724641993551358e-07 0 1.372564199355136e-07 0.00021 1.372664199355136e-07 0 1.3726641993551358e-07 0 1.372764199355136e-07 0.00021 1.372864199355136e-07 0 1.3728641993551357e-07 0 1.3729641993551358e-07 0.00021 1.373064199355136e-07 0 1.3735053180702535e-07 0 1.3736053180702536e-07 0.00021 1.3737053180702537e-07 0 1.3737496134535245e-07 0 1.3738496134535246e-07 0.00021 1.3739496134535247e-07 0 1.3739903533451316e-07 0 1.3740903533451317e-07 0.00021 1.3741903533451318e-07 0 1.3742363080486596e-07 0 1.3743363080486597e-07 0.00021 1.3744363080486598e-07 0 1.3745101143114974e-07 0 1.3746101143114975e-07 0.00021 1.3747101143114976e-07 0 1.3747101143114974e-07 0 1.3748101143114975e-07 0.00021 1.3749101143114976e-07 0 1.3749101143114973e-07 0 1.3750101143114974e-07 0.00021 1.3751101143114976e-07 0 1.3751101143114973e-07 0 1.3752101143114974e-07 0.00021 1.3753101143114975e-07 0 1.3753599024637797e-07 0 1.3754599024637798e-07 0.00021 1.37555990246378e-07 0 1.3758363996339726e-07 0 1.3759363996339727e-07 0.00021 1.3760363996339728e-07 0 1.3760363996339725e-07 0 1.3761363996339727e-07 0.00021 1.3762363996339728e-07 0 1.3762845100013827e-07 0 1.3763845100013828e-07 0.00021 1.376484510001383e-07 0 1.3764845100013826e-07 0 1.3765845100013827e-07 0.00021 1.3766845100013829e-07 0 1.3771174380259948e-07 0 1.377217438025995e-07 0.00021 1.377317438025995e-07 0 1.3773174380259948e-07 0 1.377417438025995e-07 0.00021 1.377517438025995e-07 0 1.3775174380259947e-07 0 1.3776174380259949e-07 0.00021 1.377717438025995e-07 0 1.3779477610434345e-07 0 1.3780477610434346e-07 0.00021 1.3781477610434348e-07 0 1.3781477610434345e-07 0 1.3782477610434346e-07 0.00021 1.3783477610434347e-07 0 1.3783477610434345e-07 0 1.3784477610434346e-07 0.00021 1.3785477610434347e-07 0 1.378689820187637e-07 0 1.378789820187637e-07 0.00021 1.3788898201876372e-07 0 1.3791900514924273e-07 0 1.3792900514924274e-07 0.00021 1.3793900514924275e-07 0 1.3793900514924273e-07 0 1.3794900514924274e-07 0.00021 1.3795900514924275e-07 0 1.3797683948894274e-07 0 1.3798683948894276e-07 0.00021 1.3799683948894277e-07 0 1.3799683948894274e-07 0 1.3800683948894275e-07 0.00021 1.3801683948894276e-07 0 1.3802238428252922e-07 0 1.3803238428252923e-07 0.00021 1.3804238428252925e-07 0 1.3804238428252922e-07 0 1.3805238428252923e-07 0.00021 1.3806238428252924e-07 0 1.380754953188629e-07 0 1.380854953188629e-07 0.00021 1.3809549531886292e-07 0 1.3811511334837393e-07 0 1.3812511334837394e-07 0.00021 1.3813511334837396e-07 0 1.3813511334837393e-07 0 1.3814511334837394e-07 0.00021 1.3815511334837395e-07 0 1.3815511334837393e-07 0 1.3816511334837394e-07 0.00021 1.3817511334837395e-07 0 1.3817511334837392e-07 0 1.3818511334837393e-07 0.00021 1.3819511334837394e-07 0 1.3823251210381828e-07 0 1.382425121038183e-07 0.00021 1.382525121038183e-07 0 1.382537414524306e-07 0 1.3826374145243062e-07 0.00021 1.3827374145243063e-07 0 1.382737414524306e-07 0 1.3828374145243061e-07 0.00021 1.3829374145243063e-07 0 1.382937414524306e-07 0 1.383037414524306e-07 0.00021 1.3831374145243062e-07 0 1.383137414524306e-07 0 1.383237414524306e-07 0.00021 1.3833374145243062e-07 0 1.3837979709814603e-07 0 1.3838979709814604e-07 0.00021 1.3839979709814605e-07 0 1.3851161751672314e-07 0 1.3852161751672315e-07 0.00021 1.3853161751672316e-07 0 1.3855958723002625e-07 0 1.3856958723002626e-07 0.00021 1.3857958723002627e-07 0 1.3857958723002625e-07 0 1.3858958723002626e-07 0.00021 1.3859958723002627e-07 0 1.3859958723002624e-07 0 1.3860958723002626e-07 0.00021 1.3861958723002627e-07 0 1.3861958723002624e-07 0 1.3862958723002625e-07 0.00021 1.3863958723002626e-07 0 1.3863958723002624e-07 0 1.3864958723002625e-07 0.00021 1.3865958723002626e-07 0 1.386630196006818e-07 0 1.386730196006818e-07 0.00021 1.3868301960068182e-07 0 1.3870303334254214e-07 0 1.3871303334254216e-07 0.00021 1.3872303334254217e-07 0 1.3872303334254214e-07 0 1.3873303334254215e-07 0.00021 1.3874303334254216e-07 0 1.3874303334254214e-07 0 1.3875303334254215e-07 0.00021 1.3876303334254216e-07 0 1.3876303334254213e-07 0 1.3877303334254214e-07 0.00021 1.3878303334254216e-07 0 1.388055403018867e-07 0 1.3881554030188671e-07 0.00021 1.3882554030188673e-07 0 1.3883493070548302e-07 0 1.3884493070548303e-07 0.00021 1.3885493070548304e-07 0 1.3885493070548301e-07 0 1.3886493070548303e-07 0.00021 1.3887493070548304e-07 0 1.38874930705483e-07 0 1.3888493070548302e-07 0.00021 1.3889493070548303e-07 0 1.38894930705483e-07 0 1.3890493070548302e-07 0.00021 1.3891493070548303e-07 0 1.38914930705483e-07 0 1.3892493070548301e-07 0.00021 1.3893493070548303e-07 0 1.38934930705483e-07 0 1.38944930705483e-07 0.00021 1.3895493070548302e-07 0 1.38954930705483e-07 0 1.38964930705483e-07 0.00021 1.3897493070548302e-07 0 1.3902815747895375e-07 0 1.3903815747895377e-07 0.00021 1.3904815747895378e-07 0 1.3906078864047004e-07 0 1.3907078864047005e-07 0.00021 1.3908078864047006e-07 0 1.3908669067596693e-07 0 1.3909669067596695e-07 0.00021 1.3910669067596696e-07 0 1.391301580936364e-07 0 1.391401580936364e-07 0.00021 1.391501580936364e-07 0 1.391935765014831e-07 0 1.392035765014831e-07 0.00021 1.3921357650148312e-07 0 1.392200129255729e-07 0 1.392300129255729e-07 0.00021 1.3924001292557292e-07 0 1.392400129255729e-07 0 1.392500129255729e-07 0.00021 1.3926001292557292e-07 0 1.3927637969169034e-07 0 1.3928637969169035e-07 0.00021 1.3929637969169036e-07 0 1.3932918812268217e-07 0 1.3933918812268218e-07 0.00021 1.393491881226822e-07 0 1.3935942660555583e-07 0 1.3936942660555584e-07 0.00021 1.3937942660555585e-07 0 1.3939186065092682e-07 0 1.3940186065092684e-07 0.00021 1.3941186065092685e-07 0 1.3943547895046596e-07 0 1.3944547895046597e-07 0.00021 1.3945547895046598e-07 0 1.3946981519745514e-07 0 1.3947981519745515e-07 0.00021 1.3948981519745516e-07 0 1.3948981519745514e-07 0 1.3949981519745515e-07 0.00021 1.3950981519745516e-07 0 1.3950981519745513e-07 0 1.3951981519745514e-07 0.00021 1.3952981519745516e-07 0 1.3952981519745513e-07 0 1.3953981519745514e-07 0.00021 1.3954981519745515e-07 0 1.3954981519745513e-07 0 1.3955981519745514e-07 0.00021 1.3956981519745515e-07 0 1.396118464191636e-07 0 1.396218464191636e-07 0.00021 1.396318464191636e-07 0 1.3963184641916358e-07 0 1.396418464191636e-07 0.00021 1.396518464191636e-07 0 1.3965184641916358e-07 0 1.396618464191636e-07 0.00021 1.396718464191636e-07 0 1.3967184641916358e-07 0 1.396818464191636e-07 0.00021 1.396918464191636e-07 0 1.3969184641916357e-07 0 1.3970184641916358e-07 0.00021 1.397118464191636e-07 0 1.3971184641916357e-07 0 1.3972184641916358e-07 0.00021 1.397318464191636e-07 0 1.3973184641916357e-07 0 1.3974184641916358e-07 0.00021 1.397518464191636e-07 0 1.3975184641916356e-07 0 1.3976184641916357e-07 0.00021 1.3977184641916358e-07 0 1.397832869644915e-07 0 1.397932869644915e-07 0.00021 1.398032869644915e-07 0 1.398395028375574e-07 0 1.3984950283755742e-07 0.00021 1.3985950283755743e-07 0 1.3999574820529995e-07 0 1.4000574820529996e-07 0.00021 1.4001574820529997e-07 0 1.4003293167950564e-07 0 1.4004293167950565e-07 0.00021 1.4005293167950566e-07 0 1.4005293167950564e-07 0 1.4006293167950565e-07 0.00021 1.4007293167950566e-07 0 1.4007293167950563e-07 0 1.4008293167950564e-07 0.00021 1.4009293167950566e-07 0 1.4009293167950563e-07 0 1.4010293167950564e-07 0.00021 1.4011293167950565e-07 0 1.401244718367672e-07 0 1.4013447183676722e-07 0.00021 1.4014447183676723e-07 0 1.4019632536013984e-07 0 1.4020632536013985e-07 0.00021 1.4021632536013986e-07 0 1.4023233198786813e-07 0 1.4024233198786814e-07 0.00021 1.4025233198786815e-07 0 1.402563704128682e-07 0 1.4026637041286822e-07 0.00021 1.4027637041286823e-07 0 1.402763704128682e-07 0 1.4028637041286822e-07 0.00021 1.4029637041286823e-07 0 1.403177002469798e-07 0 1.403277002469798e-07 0.00021 1.4033770024697982e-07 0 1.403377002469798e-07 0 1.403477002469798e-07 0.00021 1.4035770024697981e-07 0 1.4037172494751801e-07 0 1.4038172494751802e-07 0.00021 1.4039172494751804e-07 0 1.404116951487269e-07 0 1.404216951487269e-07 0.00021 1.4043169514872692e-07 0 1.4044608884528688e-07 0 1.404560888452869e-07 0.00021 1.404660888452869e-07 0 1.4048423933567674e-07 0 1.4049423933567676e-07 0.00021 1.4050423933567677e-07 0 1.4052945401338273e-07 0 1.4053945401338274e-07 0.00021 1.4054945401338275e-07 0 1.4054945401338273e-07 0 1.4055945401338274e-07 0.00021 1.4056945401338275e-07 0 1.40627045314823e-07 0 1.40637045314823e-07 0.00021 1.4064704531482302e-07 0 1.40647045314823e-07 0 1.40657045314823e-07 0.00021 1.40667045314823e-07 0 1.4066704531482299e-07 0 1.40677045314823e-07 0.00021 1.40687045314823e-07 0 1.4068704531482298e-07 0 1.40697045314823e-07 0.00021 1.40707045314823e-07 0 1.4082102352498437e-07 0 1.4083102352498438e-07 0.00021 1.408410235249844e-07 0 1.4085760467867922e-07 0 1.4086760467867923e-07 0.00021 1.4087760467867924e-07 0 1.409320025330163e-07 0 1.4094200253301631e-07 0.00021 1.4095200253301632e-07 0 1.4103540146183642e-07 0 1.4104540146183643e-07 0.00021 1.4105540146183644e-07 0 1.4105540146183642e-07 0 1.4106540146183643e-07 0.00021 1.4107540146183644e-07 0 1.410754014618364e-07 0 1.4108540146183642e-07 0.00021 1.4109540146183644e-07 0 1.410954014618364e-07 0 1.4110540146183642e-07 0.00021 1.4111540146183643e-07 0 1.411154014618364e-07 0 1.4112540146183642e-07 0.00021 1.4113540146183643e-07 0 1.411354014618364e-07 0 1.411454014618364e-07 0.00021 1.4115540146183642e-07 0 1.4119060527356195e-07 0 1.4120060527356196e-07 0.00021 1.4121060527356197e-07 0 1.4123914975686255e-07 0 1.4124914975686257e-07 0.00021 1.4125914975686258e-07 0 1.4130261021320546e-07 0 1.4131261021320548e-07 0.00021 1.413226102132055e-07 0 1.4132261021320546e-07 0 1.4133261021320547e-07 0.00021 1.4134261021320548e-07 0 1.4134261021320546e-07 0 1.4135261021320547e-07 0.00021 1.4136261021320548e-07 0 1.4136261021320545e-07 0 1.4137261021320546e-07 0.00021 1.4138261021320548e-07 0 1.4138261021320545e-07 0 1.4139261021320546e-07 0.00021 1.4140261021320547e-07 0 1.4140261021320545e-07 0 1.4141261021320546e-07 0.00021 1.4142261021320547e-07 0 1.4142261021320544e-07 0 1.4143261021320545e-07 0.00021 1.4144261021320546e-07 0 1.4144261021320544e-07 0 1.4145261021320545e-07 0.00021 1.4146261021320546e-07 0 1.4146261021320543e-07 0 1.4147261021320545e-07 0.00021 1.4148261021320546e-07 0 1.4148261021320543e-07 0 1.4149261021320544e-07 0.00021 1.4150261021320545e-07 0 1.4150261021320543e-07 0 1.4151261021320544e-07 0.00021 1.4152261021320545e-07 0 1.4152261021320542e-07 0 1.4153261021320543e-07 0.00021 1.4154261021320545e-07 0 1.417301008980004e-07 0 1.4174010089800042e-07 0.00021 1.4175010089800043e-07 0 1.417776081066595e-07 0 1.417876081066595e-07 0.00021 1.4179760810665952e-07 0 1.4185404682448665e-07 0 1.4186404682448666e-07 0.00021 1.4187404682448668e-07 0 1.4187404682448665e-07 0 1.4188404682448666e-07 0.00021 1.4189404682448667e-07 0 1.4190115228035564e-07 0 1.4191115228035565e-07 0.00021 1.4192115228035566e-07 0 1.4192115228035564e-07 0 1.4193115228035565e-07 0.00021 1.4194115228035566e-07 0 1.4194278620135049e-07 0 1.419527862013505e-07 0.00021 1.419627862013505e-07 0 1.4196278620135048e-07 0 1.419727862013505e-07 0.00021 1.419827862013505e-07 0 1.4198278620135048e-07 0 1.419927862013505e-07 0.00021 1.420027862013505e-07 0 1.4200278620135047e-07 0 1.4201278620135049e-07 0.00021 1.420227862013505e-07 0 1.4202278620135047e-07 0 1.4203278620135048e-07 0.00021 1.420427862013505e-07 0 1.4204278620135047e-07 0 1.4205278620135048e-07 0.00021 1.420627862013505e-07 0 1.4206278620135046e-07 0 1.4207278620135047e-07 0.00021 1.4208278620135049e-07 0 1.4208278620135046e-07 0 1.4209278620135047e-07 0.00021 1.4210278620135048e-07 0 1.4210278620135046e-07 0 1.4211278620135047e-07 0.00021 1.4212278620135048e-07 0 1.4212278620135045e-07 0 1.4213278620135046e-07 0.00021 1.4214278620135047e-07 0 1.421673876310367e-07 0 1.421773876310367e-07 0.00021 1.4218738763103672e-07 0 1.421873876310367e-07 0 1.421973876310367e-07 0.00021 1.422073876310367e-07 0 1.4228718590385064e-07 0 1.4229718590385065e-07 0.00021 1.4230718590385066e-07 0 1.4230718590385063e-07 0 1.4231718590385065e-07 0.00021 1.4232718590385066e-07 0 1.4232718590385063e-07 0 1.4233718590385064e-07 0.00021 1.4234718590385065e-07 0 1.4234718590385063e-07 0 1.4235718590385064e-07 0.00021 1.4236718590385065e-07 0 1.4238545686277686e-07 0 1.4239545686277687e-07 0.00021 1.4240545686277688e-07 0 1.4240545686277685e-07 0 1.4241545686277686e-07 0.00021 1.4242545686277687e-07 0 1.4242545686277685e-07 0 1.4243545686277686e-07 0.00021 1.4244545686277687e-07 0 1.4245789727712437e-07 0 1.4246789727712438e-07 0.00021 1.424778972771244e-07 0 1.4247789727712436e-07 0 1.4248789727712437e-07 0.00021 1.4249789727712438e-07 0 1.4250148880448363e-07 0 1.4251148880448364e-07 0.00021 1.4252148880448366e-07 0 1.4252148880448363e-07 0 1.4253148880448364e-07 0.00021 1.4254148880448365e-07 0 1.4254148880448363e-07 0 1.4255148880448364e-07 0.00021 1.4256148880448365e-07 0 1.4256148880448362e-07 0 1.4257148880448363e-07 0.00021 1.4258148880448364e-07 0 1.4258148880448362e-07 0 1.4259148880448363e-07 0.00021 1.4260148880448364e-07 0 1.4260148880448361e-07 0 1.4261148880448363e-07 0.00021 1.4262148880448364e-07 0 1.426214888044836e-07 0 1.4263148880448362e-07 0.00021 1.4264148880448363e-07 0 1.426414888044836e-07 0 1.4265148880448362e-07 0.00021 1.4266148880448363e-07 0 1.4268811259721826e-07 0 1.4269811259721827e-07 0.00021 1.4270811259721828e-07 0 1.427513706016037e-07 0 1.427613706016037e-07 0.00021 1.4277137060160372e-07 0 1.427713706016037e-07 0 1.427813706016037e-07 0.00021 1.427913706016037e-07 0 1.4279137060160369e-07 0 1.428013706016037e-07 0.00021 1.428113706016037e-07 0 1.4281137060160368e-07 0 1.428213706016037e-07 0.00021 1.428313706016037e-07 0 1.4289602874811494e-07 0 1.4290602874811495e-07 0.00021 1.4291602874811496e-07 0 1.429481113395817e-07 0 1.429581113395817e-07 0.00021 1.4296811133958172e-07 0 1.4298376179048255e-07 0 1.4299376179048256e-07 0.00021 1.4300376179048257e-07 0 1.4300376179048255e-07 0 1.4301376179048256e-07 0.00021 1.4302376179048257e-07 0 1.4302376179048254e-07 0 1.4303376179048255e-07 0.00021 1.4304376179048257e-07 0 1.4305184097768752e-07 0 1.4306184097768753e-07 0.00021 1.4307184097768754e-07 0 1.4307184097768752e-07 0 1.4308184097768753e-07 0.00021 1.4309184097768754e-07 0 1.431060889568747e-07 0 1.4311608895687472e-07 0.00021 1.4312608895687473e-07 0 1.431260889568747e-07 0 1.4313608895687472e-07 0.00021 1.4314608895687473e-07 0 1.431460889568747e-07 0 1.4315608895687471e-07 0.00021 1.4316608895687473e-07 0 1.431660889568747e-07 0 1.431760889568747e-07 0.00021 1.4318608895687472e-07 0 1.4326417665802674e-07 0 1.4327417665802675e-07 0.00021 1.4328417665802676e-07 0 1.4330571644478576e-07 0 1.4331571644478578e-07 0.00021 1.4332571644478579e-07 0 1.4332571644478576e-07 0 1.4333571644478577e-07 0.00021 1.4334571644478578e-07 0 1.4341182115343552e-07 0 1.4342182115343553e-07 0.00021 1.4343182115343554e-07 0 1.4343182115343551e-07 0 1.4344182115343553e-07 0.00021 1.4345182115343554e-07 0 1.434518211534355e-07 0 1.4346182115343552e-07 0.00021 1.4347182115343553e-07 0 1.4349070269516934e-07 0 1.4350070269516935e-07 0.00021 1.4351070269516936e-07 0 1.4351070269516933e-07 0 1.4352070269516935e-07 0.00021 1.4353070269516936e-07 0 1.4355132802295908e-07 0 1.435613280229591e-07 0.00021 1.435713280229591e-07 0 1.4363378900354963e-07 0 1.4364378900354964e-07 0.00021 1.4365378900354965e-07 0 1.4366154946063995e-07 0 1.4367154946063997e-07 0.00021 1.4368154946063998e-07 0 1.436885116842105e-07 0 1.436985116842105e-07 0.00021 1.437085116842105e-07 0 1.4370851168421048e-07 0 1.437185116842105e-07 0.00021 1.437285116842105e-07 0 1.4373096159152776e-07 0 1.4374096159152777e-07 0.00021 1.4375096159152778e-07 0 1.4378834770207705e-07 0 1.4379834770207707e-07 0.00021 1.4380834770207708e-07 0 1.43833772969117e-07 0 1.4384377296911702e-07 0.00021 1.4385377296911703e-07 0 1.43853772969117e-07 0 1.4386377296911701e-07 0.00021 1.4387377296911703e-07 0 1.439516905558862e-07 0 1.4396169055588622e-07 0.00021 1.4397169055588623e-07 0 1.439716905558862e-07 0 1.4398169055588622e-07 0.00021 1.4399169055588623e-07 0 1.439916905558862e-07 0 1.440016905558862e-07 0.00021 1.4401169055588622e-07 0 1.4402403918910826e-07 0 1.4403403918910827e-07 0.00021 1.4404403918910828e-07 0 1.4404857314181945e-07 0 1.4405857314181946e-07 0.00021 1.4406857314181947e-07 0 1.4415555201302072e-07 0 1.4416555201302073e-07 0.00021 1.4417555201302075e-07 0 1.4417555201302072e-07 0 1.4418555201302073e-07 0.00021 1.4419555201302074e-07 0 1.442058247203234e-07 0 1.442158247203234e-07 0.00021 1.4422582472032342e-07 0 1.4423403085554083e-07 0 1.4424403085554084e-07 0.00021 1.4425403085554086e-07 0 1.4425403085554083e-07 0 1.4426403085554084e-07 0.00021 1.4427403085554085e-07 0 1.4427403085554083e-07 0 1.4428403085554084e-07 0.00021 1.4429403085554085e-07 0 1.4429403085554082e-07 0 1.4430403085554083e-07 0.00021 1.4431403085554084e-07 0 1.4431403085554082e-07 0 1.4432403085554083e-07 0.00021 1.4433403085554084e-07 0 1.4435673335420584e-07 0 1.4436673335420585e-07 0.00021 1.4437673335420587e-07 0 1.443787701958705e-07 0 1.4438877019587052e-07 0.00021 1.4439877019587053e-07 0 1.4444140803755671e-07 0 1.4445140803755672e-07 0.00021 1.4446140803755674e-07 0 1.4446391507714294e-07 0 1.4447391507714295e-07 0.00021 1.4448391507714296e-07 0 1.4448391507714294e-07 0 1.4449391507714295e-07 0.00021 1.4450391507714296e-07 0 1.4450391507714293e-07 0 1.4451391507714295e-07 0.00021 1.4452391507714296e-07 0 1.4452653721237815e-07 0 1.4453653721237817e-07 0.00021 1.4454653721237818e-07 0 1.4462428869799673e-07 0 1.4463428869799674e-07 0.00021 1.4464428869799675e-07 0 1.4464428869799673e-07 0 1.4465428869799674e-07 0.00021 1.4466428869799675e-07 0 1.4466428869799672e-07 0 1.4467428869799673e-07 0.00021 1.4468428869799675e-07 0 1.4468428869799672e-07 0 1.4469428869799673e-07 0.00021 1.4470428869799674e-07 0 1.4470428869799672e-07 0 1.4471428869799673e-07 0.00021 1.4472428869799674e-07 0 1.447242886979967e-07 0 1.4473428869799672e-07 0.00021 1.4474428869799673e-07 0 1.447442886979967e-07 0 1.4475428869799672e-07 0.00021 1.4476428869799673e-07 0 1.447642886979967e-07 0 1.4477428869799672e-07 0.00021 1.4478428869799673e-07 0 1.447842886979967e-07 0 1.447942886979967e-07 0.00021 1.4480428869799672e-07 0 1.4482621675079073e-07 0 1.4483621675079074e-07 0.00021 1.4484621675079075e-07 0 1.4487027220403666e-07 0 1.4488027220403668e-07 0.00021 1.448902722040367e-07 0 1.449100782533926e-07 0 1.449200782533926e-07 0.00021 1.449300782533926e-07 0 1.4493448046027457e-07 0 1.4494448046027458e-07 0.00021 1.449544804602746e-07 0 1.4495448046027456e-07 0 1.4496448046027457e-07 0.00021 1.4497448046027459e-07 0 1.4497448046027456e-07 0 1.4498448046027457e-07 0.00021 1.4499448046027458e-07 0 1.4499448046027456e-07 0 1.4500448046027457e-07 0.00021 1.4501448046027458e-07 0 1.4507389143091133e-07 0 1.4508389143091134e-07 0.00021 1.4509389143091135e-07 0 1.4509389143091133e-07 0 1.4510389143091134e-07 0.00021 1.4511389143091135e-07 0 1.451236630598729e-07 0 1.4513366305987292e-07 0.00021 1.4514366305987294e-07 0 1.451436630598729e-07 0 1.4515366305987292e-07 0.00021 1.4516366305987293e-07 0 1.4518221974149755e-07 0 1.4519221974149756e-07 0.00021 1.4520221974149757e-07 0 1.4520221974149754e-07 0 1.4521221974149756e-07 0.00021 1.4522221974149757e-07 0 1.4524098125493845e-07 0 1.4525098125493846e-07 0.00021 1.4526098125493847e-07 0 1.4529395834812753e-07 0 1.4530395834812755e-07 0.00021 1.4531395834812756e-07 0 1.4533070886931875e-07 0 1.4534070886931876e-07 0.00021 1.4535070886931877e-07 0 1.4535070886931874e-07 0 1.4536070886931875e-07 0.00021 1.4537070886931877e-07 0 1.4537070886931874e-07 0 1.4538070886931875e-07 0.00021 1.4539070886931876e-07 0 1.4539070886931874e-07 0 1.4540070886931875e-07 0.00021 1.4541070886931876e-07 0 1.4541070886931873e-07 0 1.4542070886931874e-07 0.00021 1.4543070886931875e-07 0 1.4543070886931873e-07 0 1.4544070886931874e-07 0.00021 1.4545070886931875e-07 0 1.4545070886931872e-07 0 1.4546070886931874e-07 0.00021 1.4547070886931875e-07 0 1.4547070886931872e-07 0 1.4548070886931873e-07 0.00021 1.4549070886931874e-07 0 1.4549070886931872e-07 0 1.4550070886931873e-07 0.00021 1.4551070886931874e-07 0 1.455107088693187e-07 0 1.4552070886931872e-07 0.00021 1.4553070886931874e-07 0 1.455307088693187e-07 0 1.4554070886931872e-07 0.00021 1.4555070886931873e-07 0 1.455507088693187e-07 0 1.4556070886931872e-07 0.00021 1.4557070886931873e-07 0 1.455707088693187e-07 0 1.455807088693187e-07 0.00021 1.4559070886931872e-07 0 1.455907088693187e-07 0 1.456007088693187e-07 0.00021 1.4561070886931872e-07 0 1.456107088693187e-07 0 1.456207088693187e-07 0.00021 1.4563070886931872e-07 0 1.456307088693187e-07 0 1.456407088693187e-07 0.00021 1.456507088693187e-07 0 1.4565070886931869e-07 0 1.456607088693187e-07 0.00021 1.456707088693187e-07 0 1.4567070886931868e-07 0 1.456807088693187e-07 0.00021 1.456907088693187e-07 0 1.4569070886931868e-07 0 1.457007088693187e-07 0.00021 1.457107088693187e-07 0 1.4571070886931868e-07 0 1.4572070886931869e-07 0.00021 1.457307088693187e-07 0 1.4573070886931867e-07 0 1.4574070886931868e-07 0.00021 1.457507088693187e-07 0 1.4575070886931867e-07 0 1.4576070886931868e-07 0.00021 1.457707088693187e-07 0 1.4577070886931866e-07 0 1.4578070886931868e-07 0.00021 1.4579070886931869e-07 0 1.4579070886931866e-07 0 1.4580070886931867e-07 0.00021 1.4581070886931868e-07 0 1.4582051517208296e-07 0 1.4583051517208297e-07 0.00021 1.4584051517208298e-07 0 1.4584051517208295e-07 0 1.4585051517208296e-07 0.00021 1.4586051517208297e-07 0 1.4586051517208295e-07 0 1.4587051517208296e-07 0.00021 1.4588051517208297e-07 0 1.4588051517208294e-07 0 1.4589051517208296e-07 0.00021 1.4590051517208297e-07 0 1.4590051517208294e-07 0 1.4591051517208295e-07 0.00021 1.4592051517208296e-07 0 1.4592581811489696e-07 0 1.4593581811489697e-07 0.00021 1.4594581811489698e-07 0 1.4594581811489695e-07 0 1.4595581811489696e-07 0.00021 1.4596581811489698e-07 0 1.4596581811489695e-07 0 1.4597581811489696e-07 0.00021 1.4598581811489697e-07 0 1.4601226755291363e-07 0 1.4602226755291365e-07 0.00021 1.4603226755291366e-07 0 1.4603226755291363e-07 0 1.4604226755291364e-07 0.00021 1.4605226755291365e-07 0 1.4605226755291363e-07 0 1.4606226755291364e-07 0.00021 1.4607226755291365e-07 0 1.4607226755291362e-07 0 1.4608226755291363e-07 0.00021 1.4609226755291365e-07 0 1.4609404807067084e-07 0 1.4610404807067086e-07 0.00021 1.4611404807067087e-07 0 1.4612625453586895e-07 0 1.4613625453586896e-07 0.00021 1.4614625453586897e-07 0 1.4615132073873507e-07 0 1.4616132073873508e-07 0.00021 1.461713207387351e-07 0 1.462124851551758e-07 0 1.462224851551758e-07 0.00021 1.4623248515517582e-07 0 1.4623721675275308e-07 0 1.4624721675275309e-07 0.00021 1.462572167527531e-07 0 1.4625889944438407e-07 0 1.4626889944438409e-07 0.00021 1.462788994443841e-07 0 1.4628097992387857e-07 0 1.4629097992387858e-07 0.00021 1.463009799238786e-07 0 1.4632260259108626e-07 0 1.4633260259108628e-07 0.00021 1.4634260259108629e-07 0 1.4634260259108626e-07 0 1.4635260259108627e-07 0.00021 1.4636260259108628e-07 0 1.4636260259108626e-07 0 1.4637260259108627e-07 0.00021 1.4638260259108628e-07 0 1.4638260259108625e-07 0 1.4639260259108626e-07 0.00021 1.4640260259108628e-07 0 1.4640260259108625e-07 0 1.4641260259108626e-07 0.00021 1.4642260259108627e-07 0 1.4642889184981563e-07 0 1.4643889184981564e-07 0.00021 1.4644889184981565e-07 0 1.464491886886563e-07 0 1.464591886886563e-07 0.00021 1.4646918868865632e-07 0 1.46472678065759e-07 0 1.46482678065759e-07 0.00021 1.4649267806575902e-07 0 1.4656201899790023e-07 0 1.4657201899790024e-07 0.00021 1.4658201899790026e-07 0 1.4658710541986023e-07 0 1.4659710541986024e-07 0.00021 1.4660710541986025e-07 0 1.4665007163346934e-07 0 1.4666007163346935e-07 0.00021 1.4667007163346936e-07 0 1.466731788087903e-07 0 1.466831788087903e-07 0.00021 1.4669317880879032e-07 0 1.4672935056325548e-07 0 1.467393505632555e-07 0.00021 1.467493505632555e-07 0 1.4676931396966498e-07 0 1.46779313969665e-07 0.00021 1.46789313969665e-07 0 1.4678931396966498e-07 0 1.46799313969665e-07 0.00021 1.46809313969665e-07 0 1.4680931396966497e-07 0 1.4681931396966498e-07 0.00021 1.46829313969665e-07 0 1.4685790776927033e-07 0 1.4686790776927034e-07 0.00021 1.4687790776927035e-07 0 1.468959400683794e-07 0 1.469059400683794e-07 0.00021 1.4691594006837942e-07 0 1.469159400683794e-07 0 1.469259400683794e-07 0.00021 1.4693594006837942e-07 0 1.469558811039411e-07 0 1.4696588110394112e-07 0.00021 1.4697588110394113e-07 0 1.469758811039411e-07 0 1.4698588110394112e-07 0.00021 1.4699588110394113e-07 0 1.469958811039411e-07 0 1.470058811039411e-07 0.00021 1.4701588110394112e-07 0 1.470158811039411e-07 0 1.470258811039411e-07 0.00021 1.4703588110394112e-07 0 1.470358811039411e-07 0 1.470458811039411e-07 0.00021 1.4705588110394112e-07 0 1.470558811039411e-07 0 1.470658811039411e-07 0.00021 1.470758811039411e-07 0 1.47189123091595e-07 0 1.47199123091595e-07 0.00021 1.4720912309159502e-07 0 1.47209123091595e-07 0 1.47219123091595e-07 0.00021 1.4722912309159502e-07 0 1.4731233610804905e-07 0 1.4732233610804906e-07 0.00021 1.4733233610804907e-07 0 1.475104763714259e-07 0 1.475204763714259e-07 0.00021 1.475304763714259e-07 0 1.4753047637142588e-07 0 1.475404763714259e-07 0.00021 1.475504763714259e-07 0 1.4755047637142588e-07 0 1.475604763714259e-07 0.00021 1.475704763714259e-07 0 1.4757047637142588e-07 0 1.475804763714259e-07 0.00021 1.475904763714259e-07 0 1.476037122060535e-07 0 1.4761371220605352e-07 0.00021 1.4762371220605354e-07 0 1.4762612344082178e-07 0 1.476361234408218e-07 0.00021 1.476461234408218e-07 0 1.4765687315284466e-07 0 1.4766687315284467e-07 0.00021 1.4767687315284468e-07 0 1.4767687315284466e-07 0 1.4768687315284467e-07 0.00021 1.4769687315284468e-07 0 1.4769687315284465e-07 0 1.4770687315284466e-07 0.00021 1.4771687315284467e-07 0 1.4771687315284465e-07 0 1.4772687315284466e-07 0.00021 1.4773687315284467e-07 0 1.4774269803386156e-07 0 1.4775269803386157e-07 0.00021 1.4776269803386159e-07 0 1.4776269803386156e-07 0 1.4777269803386157e-07 0.00021 1.4778269803386158e-07 0 1.477844085131324e-07 0 1.477944085131324e-07 0.00021 1.4780440851313242e-07 0 1.478044085131324e-07 0 1.478144085131324e-07 0.00021 1.478244085131324e-07 0 1.4782440851313239e-07 0 1.478344085131324e-07 0.00021 1.478444085131324e-07 0 1.4784440851313238e-07 0 1.478544085131324e-07 0.00021 1.478644085131324e-07 0 1.4786440851313238e-07 0 1.478744085131324e-07 0.00021 1.478844085131324e-07 0 1.4788440851313237e-07 0 1.4789440851313239e-07 0.00021 1.479044085131324e-07 0 1.4790440851313237e-07 0 1.4791440851313238e-07 0.00021 1.479244085131324e-07 0 1.4792440851313237e-07 0 1.4793440851313238e-07 0.00021 1.479444085131324e-07 0 1.4794440851313236e-07 0 1.4795440851313237e-07 0.00021 1.4796440851313239e-07 0 1.480444698839466e-07 0 1.480544698839466e-07 0.00021 1.4806446988394662e-07 0 1.481356969599517e-07 0 1.4814569695995172e-07 0.00021 1.4815569695995173e-07 0 1.481556969599517e-07 0 1.4816569695995172e-07 0.00021 1.4817569695995173e-07 0 1.481756969599517e-07 0 1.4818569695995171e-07 0.00021 1.4819569695995172e-07 0 1.481956969599517e-07 0 1.482056969599517e-07 0.00021 1.4821569695995172e-07 0 1.4823759544947287e-07 0 1.4824759544947288e-07 0.00021 1.482575954494729e-07 0 1.4825759544947286e-07 0 1.4826759544947287e-07 0.00021 1.4827759544947288e-07 0 1.4832679651183628e-07 0 1.483367965118363e-07 0.00021 1.483467965118363e-07 0 1.4834679651183628e-07 0 1.483567965118363e-07 0.00021 1.483667965118363e-07 0 1.4836679651183628e-07 0 1.483767965118363e-07 0.00021 1.483867965118363e-07 0 1.4838679651183627e-07 0 1.4839679651183628e-07 0.00021 1.484067965118363e-07 0 1.4840679651183627e-07 0 1.4841679651183628e-07 0.00021 1.484267965118363e-07 0 1.4842679651183627e-07 0 1.4843679651183628e-07 0.00021 1.484467965118363e-07 0 1.4844679651183626e-07 0 1.4845679651183627e-07 0.00021 1.4846679651183628e-07 0 1.4846679651183626e-07 0 1.4847679651183627e-07 0.00021 1.4848679651183628e-07 0 1.4848679651183625e-07 0 1.4849679651183627e-07 0.00021 1.4850679651183628e-07 0 1.4850679651183625e-07 0 1.4851679651183626e-07 0.00021 1.4852679651183627e-07 0 1.4852679651183625e-07 0 1.4853679651183626e-07 0.00021 1.4854679651183627e-07 0 1.4854679651183624e-07 0 1.4855679651183625e-07 0.00021 1.4856679651183627e-07 0 1.4856679651183624e-07 0 1.4857679651183625e-07 0.00021 1.4858679651183626e-07 0 1.4858679651183624e-07 0 1.4859679651183625e-07 0.00021 1.4860679651183626e-07 0 1.4860679651183623e-07 0 1.4861679651183624e-07 0.00021 1.4862679651183625e-07 0 1.486550846990365e-07 0 1.4866508469903652e-07 0.00021 1.4867508469903653e-07 0 1.4876372731945404e-07 0 1.4877372731945405e-07 0.00021 1.4878372731945406e-07 0 1.4882654263898545e-07 0 1.4883654263898546e-07 0.00021 1.4884654263898547e-07 0 1.4884654263898544e-07 0 1.4885654263898546e-07 0.00021 1.4886654263898547e-07 0 1.489081702306592e-07 0 1.489181702306592e-07 0.00021 1.4892817023065922e-07 0 1.489281763748442e-07 0 1.4893817637484422e-07 0.00021 1.4894817637484423e-07 0 1.489481763748442e-07 0 1.4895817637484422e-07 0.00021 1.4896817637484423e-07 0 1.489681763748442e-07 0 1.4897817637484422e-07 0.00021 1.4898817637484423e-07 0 1.489881763748442e-07 0 1.489981763748442e-07 0.00021 1.4900817637484422e-07 0 1.490081763748442e-07 0 1.490181763748442e-07 0.00021 1.4902817637484422e-07 0 1.490281763748442e-07 0 1.490381763748442e-07 0.00021 1.4904817637484422e-07 0 1.490481763748442e-07 0 1.490581763748442e-07 0.00021 1.490681763748442e-07 0 1.4906817637484419e-07 0 1.490781763748442e-07 0.00021 1.490881763748442e-07 0 1.4909959622799554e-07 0 1.4910959622799555e-07 0.00021 1.4911959622799556e-07 0 1.4911959622799553e-07 0 1.4912959622799554e-07 0.00021 1.4913959622799555e-07 0 1.491722566980044e-07 0 1.491822566980044e-07 0.00021 1.4919225669800441e-07 0 1.4924537037118522e-07 0 1.4925537037118523e-07 0.00021 1.4926537037118524e-07 0 1.4936794764702288e-07 0 1.493779476470229e-07 0.00021 1.493879476470229e-07 0 1.4938794764702288e-07 0 1.493979476470229e-07 0.00021 1.494079476470229e-07 0 1.4941466758436292e-07 0 1.4942466758436293e-07 0.00021 1.4943466758436295e-07 0 1.4944546497189359e-07 0 1.494554649718936e-07 0.00021 1.494654649718936e-07 0 1.4946546497189358e-07 0 1.494754649718936e-07 0.00021 1.494854649718936e-07 0 1.4950274437510432e-07 0 1.4951274437510433e-07 0.00021 1.4952274437510434e-07 0 1.4971131078356225e-07 0 1.4972131078356226e-07 0.00021 1.4973131078356227e-07 0 1.4983385036483377e-07 0 1.4984385036483378e-07 0.00021 1.498538503648338e-07 0 1.4985385036483376e-07 0 1.4986385036483378e-07 0.00021 1.498738503648338e-07 0 1.4988493070948685e-07 0 1.4989493070948686e-07 0.00021 1.4990493070948687e-07 0 1.4990493070948684e-07 0 1.4991493070948685e-07 0.00021 1.4992493070948687e-07 0 1.499374557535569e-07 0 1.499474557535569e-07 0.00021 1.499574557535569e-07 0 1.5000489254479362e-07 0 1.5001489254479363e-07 0.00021 1.5002489254479365e-07 0 1.5004912613525436e-07 0 1.5005912613525437e-07 0.00021 1.5006912613525438e-07 0 1.5006912613525435e-07 0 1.5007912613525436e-07 0.00021 1.5008912613525438e-07 0 1.5008912613525435e-07 0 1.5009912613525436e-07 0.00021 1.5010912613525437e-07 0 1.5010912613525434e-07 0 1.5011912613525436e-07 0.00021 1.5012912613525437e-07 0 1.5012912613525434e-07 0 1.5013912613525435e-07 0.00021 1.5014912613525436e-07 0 1.5014912613525434e-07 0 1.5015912613525435e-07 0.00021 1.5016912613525436e-07 0 1.5016912613525433e-07 0 1.5017912613525434e-07 0.00021 1.5018912613525436e-07 0 1.5018912613525433e-07 0 1.5019912613525434e-07 0.00021 1.5020912613525435e-07 0 1.5025245732085243e-07 0 1.5026245732085244e-07 0.00021 1.5027245732085245e-07 0 1.5030684075654677e-07 0 1.5031684075654678e-07 0.00021 1.503268407565468e-07 0 1.5032684075654677e-07 0 1.5033684075654678e-07 0.00021 1.503468407565468e-07 0 1.5034684075654676e-07 0 1.5035684075654678e-07 0.00021 1.503668407565468e-07 0 1.5036684075654676e-07 0 1.5037684075654677e-07 0.00021 1.5038684075654678e-07 0 1.5038684075654676e-07 0 1.5039684075654677e-07 0.00021 1.5040684075654678e-07 0 1.5040684075654675e-07 0 1.5041684075654676e-07 0.00021 1.5042684075654678e-07 0 1.5042684075654675e-07 0 1.5043684075654676e-07 0.00021 1.5044684075654677e-07 0 1.5045337254245398e-07 0 1.50463372542454e-07 0.00021 1.50473372542454e-07 0 1.5049604452095854e-07 0 1.5050604452095855e-07 0.00021 1.5051604452095856e-07 0 1.5051604452095853e-07 0 1.5052604452095854e-07 0.00021 1.5053604452095855e-07 0 1.5053772117569646e-07 0 1.5054772117569647e-07 0.00021 1.5055772117569648e-07 0 1.5055772117569646e-07 0 1.5056772117569647e-07 0.00021 1.5057772117569648e-07 0 1.5057772117569645e-07 0 1.5058772117569646e-07 0.00021 1.5059772117569647e-07 0 1.5059772117569645e-07 0 1.5060772117569646e-07 0.00021 1.5061772117569647e-07 0 1.5061772117569644e-07 0 1.5062772117569646e-07 0.00021 1.5063772117569647e-07 0 1.5063772117569644e-07 0 1.5064772117569645e-07 0.00021 1.5065772117569646e-07 0 1.5065772117569644e-07 0 1.5066772117569645e-07 0.00021 1.5067772117569646e-07 0 1.5073886617892287e-07 0 1.5074886617892288e-07 0.00021 1.507588661789229e-07 0 1.5077156237401737e-07 0 1.5078156237401738e-07 0.00021 1.507915623740174e-07 0 1.5086251009289682e-07 0 1.5087251009289683e-07 0.00021 1.5088251009289684e-07 0 1.509071909593506e-07 0 1.509171909593506e-07 0.00021 1.5092719095935061e-07 0 1.509271909593506e-07 0 1.509371909593506e-07 0.00021 1.509471909593506e-07 0 1.5094719095935058e-07 0 1.509571909593506e-07 0.00021 1.509671909593506e-07 0 1.510576161166931e-07 0 1.510676161166931e-07 0.00021 1.5107761611669312e-07 0 1.510776161166931e-07 0 1.510876161166931e-07 0.00021 1.510976161166931e-07 0 1.5109761611669309e-07 0 1.511076161166931e-07 0.00021 1.511176161166931e-07 0 1.5111761611669308e-07 0 1.511276161166931e-07 0.00021 1.511376161166931e-07 0 1.512300567227558e-07 0 1.512400567227558e-07 0.00021 1.5125005672275582e-07 0 1.512500567227558e-07 0 1.512600567227558e-07 0.00021 1.5127005672275582e-07 0 1.5128076325608787e-07 0 1.5129076325608788e-07 0.00021 1.513007632560879e-07 0 1.514349908663047e-07 0 1.514449908663047e-07 0.00021 1.514549908663047e-07 0 1.5145499086630469e-07 0 1.514649908663047e-07 0.00021 1.514749908663047e-07 0 1.514771597707497e-07 0 1.5148715977074972e-07 0.00021 1.5149715977074973e-07 0 1.5150857925007313e-07 0 1.5151857925007314e-07 0.00021 1.5152857925007315e-07 0 1.516671238770423e-07 0 1.516771238770423e-07 0.00021 1.5168712387704232e-07 0 1.5171663527736553e-07 0 1.5172663527736554e-07 0.00021 1.5173663527736555e-07 0 1.517847733171063e-07 0 1.517947733171063e-07 0.00021 1.5180477331710632e-07 0 1.518047733171063e-07 0 1.518147733171063e-07 0.00021 1.5182477331710631e-07 0 1.518247733171063e-07 0 1.518347733171063e-07 0.00021 1.518447733171063e-07 0 1.5184477331710628e-07 0 1.518547733171063e-07 0.00021 1.518647733171063e-07 0 1.5186477331710628e-07 0 1.518747733171063e-07 0.00021 1.518847733171063e-07 0 1.5188477331710628e-07 0 1.518947733171063e-07 0.00021 1.519047733171063e-07 0 1.519977039149356e-07 0 1.520077039149356e-07 0.00021 1.5201770391493562e-07 0 1.5207448020343546e-07 0 1.5208448020343547e-07 0.00021 1.5209448020343548e-07 0 1.5209448020343546e-07 0 1.5210448020343547e-07 0.00021 1.5211448020343548e-07 0 1.5211448020343545e-07 0 1.5212448020343546e-07 0.00021 1.5213448020343547e-07 0 1.5213448020343545e-07 0 1.5214448020343546e-07 0.00021 1.5215448020343547e-07 0 1.5215448020343544e-07 0 1.5216448020343546e-07 0.00021 1.5217448020343547e-07 0 1.5217448020343544e-07 0 1.5218448020343545e-07 0.00021 1.5219448020343546e-07 0 1.5219448020343544e-07 0 1.5220448020343545e-07 0.00021 1.5221448020343546e-07 0 1.5222007103444273e-07 0 1.5223007103444274e-07 0.00021 1.5224007103444275e-07 0 1.5224007103444273e-07 0 1.5225007103444274e-07 0.00021 1.5226007103444275e-07 0 1.5226007103444272e-07 0 1.5227007103444273e-07 0.00021 1.5228007103444275e-07 0 1.52281332584341e-07 0 1.5229133258434101e-07 0.00021 1.5230133258434103e-07 0 1.5230877414851115e-07 0 1.5231877414851116e-07 0.00021 1.5232877414851117e-07 0 1.5233249636467028e-07 0 1.523424963646703e-07 0.00021 1.523524963646703e-07 0 1.5235249636467028e-07 0 1.5236249636467029e-07 0.00021 1.523724963646703e-07 0 1.5237249636467027e-07 0 1.5238249636467028e-07 0.00021 1.523924963646703e-07 0 1.5239249636467027e-07 0 1.5240249636467028e-07 0.00021 1.524124963646703e-07 0 1.5241249636467026e-07 0 1.5242249636467027e-07 0.00021 1.5243249636467029e-07 0 1.5243249636467026e-07 0 1.5244249636467027e-07 0.00021 1.5245249636467028e-07 0 1.525033033404143e-07 0 1.525133033404143e-07 0.00021 1.5252330334041432e-07 0 1.5259215930477237e-07 0 1.5260215930477238e-07 0.00021 1.526121593047724e-07 0 1.526537184253136e-07 0 1.5266371842531362e-07 0.00021 1.5267371842531363e-07 0 1.5282547397745581e-07 0 1.5283547397745582e-07 0.00021 1.5284547397745584e-07 0 1.528454739774558e-07 0 1.5285547397745582e-07 0.00021 1.5286547397745583e-07 0 1.5288711226953782e-07 0 1.5289711226953783e-07 0.00021 1.5290711226953784e-07 0 1.529071122695378e-07 0 1.5291711226953782e-07 0.00021 1.5292711226953783e-07 0 1.529271122695378e-07 0 1.5293711226953782e-07 0.00021 1.5294711226953783e-07 0 1.529471122695378e-07 0 1.5295711226953782e-07 0.00021 1.5296711226953783e-07 0 1.529671122695378e-07 0 1.529771122695378e-07 0.00021 1.5298711226953782e-07 0 1.5299657119817496e-07 0 1.5300657119817497e-07 0.00021 1.5301657119817498e-07 0 1.5301657119817496e-07 0 1.5302657119817497e-07 0.00021 1.5303657119817498e-07 0 1.5303657119817495e-07 0 1.5304657119817496e-07 0.00021 1.5305657119817498e-07 0 1.5305657119817495e-07 0 1.5306657119817496e-07 0.00021 1.5307657119817497e-07 0 1.5312219715216154e-07 0 1.5313219715216155e-07 0.00021 1.5314219715216156e-07 0 1.532002450556019e-07 0 1.532102450556019e-07 0.00021 1.5322024505560192e-07 0 1.532202450556019e-07 0 1.532302450556019e-07 0.00021 1.5324024505560192e-07 0 1.532402450556019e-07 0 1.532502450556019e-07 0.00021 1.5326024505560192e-07 0 1.532602450556019e-07 0 1.532702450556019e-07 0.00021 1.532802450556019e-07 0 1.5328024505560189e-07 0 1.532902450556019e-07 0.00021 1.533002450556019e-07 0 1.533106802744541e-07 0 1.533206802744541e-07 0.00021 1.5333068027445412e-07 0 1.5333358463888526e-07 0 1.5334358463888527e-07 0.00021 1.5335358463888528e-07 0 1.5335358463888525e-07 0 1.5336358463888526e-07 0.00021 1.5337358463888527e-07 0 1.5337358463888525e-07 0 1.5338358463888526e-07 0.00021 1.5339358463888527e-07 0 1.5340768688797552e-07 0 1.5341768688797553e-07 0.00021 1.5342768688797554e-07 0 1.5342768688797552e-07 0 1.5343768688797553e-07 0.00021 1.5344768688797554e-07 0 1.5346742095308136e-07 0 1.5347742095308137e-07 0.00021 1.5348742095308138e-07 0 1.5350859143136903e-07 0 1.5351859143136904e-07 0.00021 1.5352859143136905e-07 0 1.5353316528869998e-07 0 1.535431652887e-07 0.00021 1.535531652887e-07 0 1.5363082227848826e-07 0 1.5364082227848827e-07 0.00021 1.5365082227848828e-07 0 1.5365082227848825e-07 0 1.5366082227848826e-07 0.00021 1.5367082227848828e-07 0 1.5367082227848825e-07 0 1.5368082227848826e-07 0.00021 1.5369082227848827e-07 0 1.5369082227848825e-07 0 1.5370082227848826e-07 0.00021 1.5371082227848827e-07 0 1.5371895275477598e-07 0 1.53728952754776e-07 0.00021 1.53738952754776e-07 0 1.537850971916499e-07 0 1.537950971916499e-07 0.00021 1.5380509719164991e-07 0 1.538287492041861e-07 0 1.538387492041861e-07 0.00021 1.538487492041861e-07 0 1.5384874920418609e-07 0 1.538587492041861e-07 0.00021 1.538687492041861e-07 0 1.5386874920418608e-07 0 1.538787492041861e-07 0.00021 1.538887492041861e-07 0 1.5388874920418608e-07 0 1.538987492041861e-07 0.00021 1.539087492041861e-07 0 1.5392758211839315e-07 0 1.5393758211839316e-07 0.00021 1.5394758211839317e-07 0 1.5394758211839315e-07 0 1.5395758211839316e-07 0.00021 1.5396758211839317e-07 0 1.5396987509167175e-07 0 1.5397987509167176e-07 0.00021 1.5398987509167177e-07 0 1.5398987509167174e-07 0 1.5399987509167175e-07 0.00021 1.5400987509167177e-07 0 1.5400987509167174e-07 0 1.5401987509167175e-07 0.00021 1.5402987509167176e-07 0 1.5402987509167174e-07 0 1.5403987509167175e-07 0.00021 1.5404987509167176e-07 0 1.5404987509167173e-07 0 1.5405987509167174e-07 0.00021 1.5406987509167175e-07 0 1.5406987509167173e-07 0 1.5407987509167174e-07 0.00021 1.5408987509167175e-07 0 1.5408987509167172e-07 0 1.5409987509167174e-07 0.00021 1.5410987509167175e-07 0 1.5410987509167172e-07 0 1.5411987509167173e-07 0.00021 1.5412987509167174e-07 0 1.5412987509167172e-07 0 1.5413987509167173e-07 0.00021 1.5414987509167174e-07 0 1.541739796973689e-07 0 1.541839796973689e-07 0.00021 1.541939796973689e-07 0 1.5419444874251932e-07 0 1.5420444874251933e-07 0.00021 1.5421444874251934e-07 0 1.5421444874251932e-07 0 1.5422444874251933e-07 0.00021 1.5423444874251934e-07 0 1.542344487425193e-07 0 1.5424444874251932e-07 0.00021 1.5425444874251934e-07 0 1.542544487425193e-07 0 1.5426444874251932e-07 0.00021 1.5427444874251933e-07 0 1.542744487425193e-07 0 1.5428444874251932e-07 0.00021 1.5429444874251933e-07 0 1.542944487425193e-07 0 1.543044487425193e-07 0.00021 1.5431444874251932e-07 0 1.5440213055401045e-07 0 1.5441213055401046e-07 0.00021 1.5442213055401048e-07 0 1.5442213055401045e-07 0 1.5443213055401046e-07 0.00021 1.5444213055401047e-07 0 1.5444732695043608e-07 0 1.544573269504361e-07 0.00021 1.544673269504361e-07 0 1.5446732695043608e-07 0 1.544773269504361e-07 0.00021 1.544873269504361e-07 0 1.5448732695043607e-07 0 1.5449732695043608e-07 0.00021 1.545073269504361e-07 0 1.545150071069534e-07 0 1.545250071069534e-07 0.00021 1.5453500710695342e-07 0 1.5467996364949094e-07 0 1.5468996364949096e-07 0.00021 1.5469996364949097e-07 0 1.5472422895179103e-07 0 1.5473422895179104e-07 0.00021 1.5474422895179105e-07 0 1.5474422895179102e-07 0 1.5475422895179103e-07 0.00021 1.5476422895179105e-07 0 1.5476422895179102e-07 0 1.5477422895179103e-07 0.00021 1.5478422895179104e-07 0 1.5479286692253132e-07 0 1.5480286692253133e-07 0.00021 1.5481286692253134e-07 0 1.548128669225313e-07 0 1.5482286692253132e-07 0.00021 1.5483286692253133e-07 0 1.548328669225313e-07 0 1.5484286692253132e-07 0.00021 1.5485286692253133e-07 0 1.548528669225313e-07 0 1.5486286692253132e-07 0.00021 1.5487286692253133e-07 0 1.548728669225313e-07 0 1.548828669225313e-07 0.00021 1.5489286692253132e-07 0 1.548928669225313e-07 0 1.549028669225313e-07 0.00021 1.5491286692253132e-07 0 1.5492884413684144e-07 0 1.5493884413684145e-07 0.00021 1.5494884413684146e-07 0 1.550427477112121e-07 0 1.550527477112121e-07 0.00021 1.550627477112121e-07 0 1.5510700835463863e-07 0 1.5511700835463864e-07 0.00021 1.5512700835463865e-07 0 1.5525418073287918e-07 0 1.552641807328792e-07 0.00021 1.552741807328792e-07 0 1.5527418073287917e-07 0 1.5528418073287918e-07 0.00021 1.552941807328792e-07 0 1.5529418073287917e-07 0 1.5530418073287918e-07 0.00021 1.553141807328792e-07 0 1.5534608484472958e-07 0 1.553560848447296e-07 0.00021 1.553660848447296e-07 0 1.5540462548069397e-07 0 1.5541462548069399e-07 0.00021 1.55424625480694e-07 0 1.5545642588524921e-07 0 1.5546642588524922e-07 0.00021 1.5547642588524924e-07 0 1.554764258852492e-07 0 1.5548642588524922e-07 0.00021 1.5549642588524923e-07 0 1.554964258852492e-07 0 1.5550642588524922e-07 0.00021 1.5551642588524923e-07 0 1.555164258852492e-07 0 1.5552642588524921e-07 0.00021 1.5553642588524922e-07 0 1.555364258852492e-07 0 1.555464258852492e-07 0.00021 1.5555642588524922e-07 0 1.5555966061433021e-07 0 1.5556966061433023e-07 0.00021 1.5557966061433024e-07 0 1.555796606143302e-07 0 1.5558966061433022e-07 0.00021 1.5559966061433023e-07 0 1.5563968894470708e-07 0 1.556496889447071e-07 0.00021 1.556596889447071e-07 0 1.5565968894470708e-07 0 1.556696889447071e-07 0.00021 1.556796889447071e-07 0 1.5568436261769295e-07 0 1.5569436261769296e-07 0.00021 1.5570436261769297e-07 0 1.5571714103046624e-07 0 1.5572714103046625e-07 0.00021 1.5573714103046626e-07 0 1.5579608939271466e-07 0 1.5580608939271467e-07 0.00021 1.5581608939271468e-07 0 1.5586631526912027e-07 0 1.5587631526912028e-07 0.00021 1.558863152691203e-07 0 1.5588631526912026e-07 0 1.5589631526912027e-07 0.00021 1.5590631526912029e-07 0 1.5590631526912026e-07 0 1.5591631526912027e-07 0.00021 1.5592631526912028e-07 0 1.5592631526912025e-07 0 1.5593631526912027e-07 0.00021 1.5594631526912028e-07 0 1.5594631526912025e-07 0 1.5595631526912026e-07 0.00021 1.5596631526912027e-07 0 1.560262726206928e-07 0 1.5603627262069282e-07 0.00021 1.5604627262069283e-07 0 1.560462726206928e-07 0 1.560562726206928e-07 0.00021 1.5606627262069282e-07 0 1.560662726206928e-07 0 1.560762726206928e-07 0.00021 1.5608627262069282e-07 0 1.560862726206928e-07 0 1.560962726206928e-07 0.00021 1.5610627262069282e-07 0 1.561256826436909e-07 0 1.561356826436909e-07 0.00021 1.5614568264369092e-07 0 1.5616574134559925e-07 0 1.5617574134559926e-07 0.00021 1.5618574134559927e-07 0 1.561901622962155e-07 0 1.562001622962155e-07 0.00021 1.5621016229621552e-07 0 1.5626664665616253e-07 0 1.5627664665616255e-07 0.00021 1.5628664665616256e-07 0 1.562895650345829e-07 0 1.562995650345829e-07 0.00021 1.563095650345829e-07 0 1.5630956503458288e-07 0 1.563195650345829e-07 0.00021 1.563295650345829e-07 0 1.5632956503458288e-07 0 1.563395650345829e-07 0.00021 1.563495650345829e-07 0 1.5634956503458288e-07 0 1.563595650345829e-07 0.00021 1.563695650345829e-07 0 1.5636956503458287e-07 0 1.5637956503458288e-07 0.00021 1.563895650345829e-07 0 1.5638956503458287e-07 0 1.5639956503458288e-07 0.00021 1.564095650345829e-07 0 1.5640956503458287e-07 0 1.5641956503458288e-07 0.00021 1.564295650345829e-07 0 1.5642956503458286e-07 0 1.5643956503458287e-07 0.00021 1.5644956503458288e-07 0 1.5644956503458286e-07 0 1.5645956503458287e-07 0.00021 1.5646956503458288e-07 0 1.565698647336834e-07 0 1.5657986473368342e-07 0.00021 1.5658986473368343e-07 0 1.5662794078686122e-07 0 1.5663794078686123e-07 0.00021 1.5664794078686124e-07 0 1.5667219239464308e-07 0 1.566821923946431e-07 0.00021 1.566921923946431e-07 0 1.5669219239464307e-07 0 1.5670219239464308e-07 0.00021 1.567121923946431e-07 0 1.5671219239464307e-07 0 1.5672219239464308e-07 0.00021 1.567321923946431e-07 0 1.5673219239464306e-07 0 1.5674219239464308e-07 0.00021 1.567521923946431e-07 0 1.5675219239464306e-07 0 1.5676219239464307e-07 0.00021 1.5677219239464308e-07 0 1.5677219239464306e-07 0 1.5678219239464307e-07 0.00021 1.5679219239464308e-07 0 1.5679219239464305e-07 0 1.5680219239464306e-07 0.00021 1.5681219239464308e-07 0 1.5681219239464305e-07 0 1.5682219239464306e-07 0.00021 1.5683219239464307e-07 0 1.5683219239464305e-07 0 1.5684219239464306e-07 0.00021 1.5685219239464307e-07 0 1.5685219239464304e-07 0 1.5686219239464305e-07 0.00021 1.5687219239464306e-07 0 1.5687219239464304e-07 0 1.5688219239464305e-07 0.00021 1.5689219239464306e-07 0 1.5689219239464303e-07 0 1.5690219239464305e-07 0.00021 1.5691219239464306e-07 0 1.5691219239464303e-07 0 1.5692219239464304e-07 0.00021 1.5693219239464305e-07 0 1.5693219239464303e-07 0 1.5694219239464304e-07 0.00021 1.5695219239464305e-07 0 1.5695219239464302e-07 0 1.5696219239464303e-07 0.00021 1.5697219239464305e-07 0 1.5697219239464302e-07 0 1.5698219239464303e-07 0.00021 1.5699219239464304e-07 0 1.5699219239464302e-07 0 1.5700219239464303e-07 0.00021 1.5701219239464304e-07 0 1.57012192394643e-07 0 1.5702219239464302e-07 0.00021 1.5703219239464303e-07 0 1.57032192394643e-07 0 1.5704219239464302e-07 0.00021 1.5705219239464303e-07 0 1.57052192394643e-07 0 1.5706219239464302e-07 0.00021 1.5707219239464303e-07 0 1.57072192394643e-07 0 1.57082192394643e-07 0.00021 1.5709219239464302e-07 0 1.571306240414838e-07 0 1.571406240414838e-07 0.00021 1.5715062404148382e-07 0 1.5723790826794435e-07 0 1.5724790826794436e-07 0.00021 1.5725790826794437e-07 0 1.572595425079306e-07 0 1.5726954250793062e-07 0.00021 1.5727954250793063e-07 0 1.572795425079306e-07 0 1.5728954250793062e-07 0.00021 1.5729954250793063e-07 0 1.572995425079306e-07 0 1.5730954250793062e-07 0.00021 1.5731954250793063e-07 0 1.573195425079306e-07 0 1.573295425079306e-07 0.00021 1.5733954250793062e-07 0 1.573395425079306e-07 0 1.573495425079306e-07 0.00021 1.5735954250793062e-07 0 1.573647243051705e-07 0 1.573747243051705e-07 0.00021 1.5738472430517052e-07 0 1.5743596532199774e-07 0 1.5744596532199775e-07 0.00021 1.5745596532199776e-07 0 1.5745596532199773e-07 0 1.5746596532199774e-07 0.00021 1.5747596532199775e-07 0 1.5747596532199773e-07 0 1.5748596532199774e-07 0.00021 1.5749596532199775e-07 0 1.5749596532199772e-07 0 1.5750596532199774e-07 0.00021 1.5751596532199775e-07 0 1.5757650883474602e-07 0 1.5758650883474603e-07 0.00021 1.5759650883474604e-07 0 1.5764366649476238e-07 0 1.576536664947624e-07 0.00021 1.576636664947624e-07 0 1.576737074209295e-07 0 1.5768370742092952e-07 0.00021 1.5769370742092953e-07 0 1.576937074209295e-07 0 1.5770370742092952e-07 0.00021 1.5771370742092953e-07 0 1.577137074209295e-07 0 1.5772370742092952e-07 0.00021 1.5773370742092953e-07 0 1.577337074209295e-07 0 1.577437074209295e-07 0.00021 1.5775370742092952e-07 0 1.577888703791865e-07 0 1.577988703791865e-07 0.00021 1.5780887037918651e-07 0 1.5788408440389146e-07 0 1.5789408440389147e-07 0.00021 1.5790408440389148e-07 0 1.5790408440389146e-07 0 1.5791408440389147e-07 0.00021 1.5792408440389148e-07 0 1.5793068042046e-07 0 1.5794068042046e-07 0.00021 1.5795068042046002e-07 0 1.5797654167438507e-07 0 1.5798654167438508e-07 0.00021 1.579965416743851e-07 0 1.5799654167438506e-07 0 1.5800654167438508e-07 0.00021 1.580165416743851e-07 0 1.5801654167438506e-07 0 1.5802654167438507e-07 0.00021 1.5803654167438508e-07 0 1.5803891104227142e-07 0 1.5804891104227143e-07 0.00021 1.5805891104227144e-07 0 1.580589110422714e-07 0 1.5806891104227142e-07 0.00021 1.5807891104227143e-07 0 1.5816680593332734e-07 0 1.5817680593332735e-07 0.00021 1.5818680593332736e-07 0 1.581906580604287e-07 0 1.582006580604287e-07 0.00021 1.5821065806042872e-07 0 1.582106580604287e-07 0 1.582206580604287e-07 0.00021 1.5823065806042872e-07 0 1.582306580604287e-07 0 1.582406580604287e-07 0.00021 1.5825065806042872e-07 0 1.582506580604287e-07 0 1.582606580604287e-07 0.00021 1.582706580604287e-07 0 1.5827065806042869e-07 0 1.582806580604287e-07 0.00021 1.582906580604287e-07 0 1.5829065806042868e-07 0 1.583006580604287e-07 0.00021 1.583106580604287e-07 0 1.5831065806042868e-07 0 1.583206580604287e-07 0.00021 1.583306580604287e-07 0 1.5833065806042867e-07 0 1.5834065806042869e-07 0.00021 1.583506580604287e-07 0 1.5846406764489686e-07 0 1.5847406764489687e-07 0.00021 1.5848406764489688e-07 0 1.585016547287732e-07 0 1.5851165472877322e-07 0.00021 1.5852165472877324e-07 0 1.586058962747677e-07 0 1.586158962747677e-07 0.00021 1.5862589627476772e-07 0 1.5868006727553997e-07 0 1.5869006727553998e-07 0.00021 1.5870006727554e-07 0 1.5870006727553997e-07 0 1.5871006727553998e-07 0.00021 1.5872006727554e-07 0 1.5872006727553996e-07 0 1.5873006727553997e-07 0.00021 1.5874006727553999e-07 0 1.5877683425280376e-07 0 1.5878683425280377e-07 0.00021 1.5879683425280378e-07 0 1.5883114600401308e-07 0 1.588411460040131e-07 0.00021 1.588511460040131e-07 0 1.5885114600401308e-07 0 1.588611460040131e-07 0.00021 1.588711460040131e-07 0 1.5888782224838167e-07 0 1.5889782224838168e-07 0.00021 1.589078222483817e-07 0 1.5890782224838166e-07 0 1.5891782224838168e-07 0.00021 1.5892782224838169e-07 0 1.5892782224838166e-07 0 1.5893782224838167e-07 0.00021 1.5894782224838168e-07 0 1.5894782224838166e-07 0 1.5895782224838167e-07 0.00021 1.5896782224838168e-07 0 1.589796412770213e-07 0 1.5898964127702132e-07 0.00021 1.5899964127702133e-07 0 1.590497172128788e-07 0 1.590597172128788e-07 0.00021 1.5906971721287882e-07 0 1.590697172128788e-07 0 1.590797172128788e-07 0.00021 1.5908971721287882e-07 0 1.5909239592347225e-07 0 1.5910239592347227e-07 0.00021 1.5911239592347228e-07 0 1.5919312548675557e-07 0 1.5920312548675559e-07 0.00021 1.592131254867556e-07 0 1.5921312548675557e-07 0 1.5922312548675558e-07 0.00021 1.592331254867556e-07 0 1.5927988631151182e-07 0 1.5928988631151183e-07 0.00021 1.5929988631151184e-07 0 1.592998863115118e-07 0 1.5930988631151182e-07 0.00021 1.5931988631151183e-07 0 1.5935391684429727e-07 0 1.5936391684429728e-07 0.00021 1.593739168442973e-07 0 1.5944040118820757e-07 0 1.5945040118820758e-07 0.00021 1.594604011882076e-07 0 1.5946040118820757e-07 0 1.5947040118820758e-07 0.00021 1.594804011882076e-07 0 1.5948040118820757e-07 0 1.5949040118820758e-07 0.00021 1.595004011882076e-07 0 1.5955435384175917e-07 0 1.5956435384175918e-07 0.00021 1.595743538417592e-07 0 1.5957809201944151e-07 0 1.5958809201944153e-07 0.00021 1.5959809201944154e-07 0 1.596002814717764e-07 0 1.596102814717764e-07 0.00021 1.5962028147177642e-07 0 1.596202814717764e-07 0 1.596302814717764e-07 0.00021 1.5964028147177642e-07 0 1.596402814717764e-07 0 1.596502814717764e-07 0.00021 1.5966028147177642e-07 0 1.596602814717764e-07 0 1.596702814717764e-07 0.00021 1.596802814717764e-07 0 1.597077814638056e-07 0 1.5971778146380562e-07 0.00021 1.5972778146380563e-07 0 1.597327645133717e-07 0 1.597427645133717e-07 0.00021 1.5975276451337172e-07 0 1.597527645133717e-07 0 1.597627645133717e-07 0.00021 1.5977276451337172e-07 0 1.597727645133717e-07 0 1.597827645133717e-07 0.00021 1.597927645133717e-07 0 1.5981653131611055e-07 0 1.5982653131611056e-07 0.00021 1.5983653131611057e-07 0 1.5983653131611055e-07 0 1.5984653131611056e-07 0.00021 1.5985653131611057e-07 0 1.5985653131611054e-07 0 1.5986653131611056e-07 0.00021 1.5987653131611057e-07 0 1.5987653131611054e-07 0 1.5988653131611055e-07 0.00021 1.5989653131611056e-07 0 1.5990358437649053e-07 0 1.5991358437649054e-07 0.00021 1.5992358437649055e-07 0 1.5994261966884206e-07 0 1.5995261966884207e-07 0.00021 1.5996261966884208e-07 0 1.5996261966884205e-07 0 1.5997261966884206e-07 0.00021 1.5998261966884208e-07 0 1.600763525249534e-07 0 1.600863525249534e-07 0.00021 1.6009635252495342e-07 0 1.6010830581279054e-07 0 1.6011830581279055e-07 0.00021 1.6012830581279057e-07 0 1.6012830581279054e-07 0 1.6013830581279055e-07 0.00021 1.6014830581279056e-07 0 1.602322398141148e-07 0 1.6024223981411482e-07 0.00021 1.6025223981411483e-07 0 1.602522398141148e-07 0 1.6026223981411481e-07 0.00021 1.6027223981411483e-07 0 1.6027541108136787e-07 0 1.6028541108136788e-07 0.00021 1.602954110813679e-07 0 1.603065354991269e-07 0 1.6031653549912692e-07 0.00021 1.6032653549912693e-07 0 1.6035759954881058e-07 0 1.603675995488106e-07 0.00021 1.603775995488106e-07 0 1.604269091626214e-07 0 1.6043690916262142e-07 0.00021 1.6044690916262143e-07 0 1.604469091626214e-07 0 1.604569091626214e-07 0.00021 1.6046690916262142e-07 0 1.604669091626214e-07 0 1.604769091626214e-07 0.00021 1.6048690916262142e-07 0 1.604869091626214e-07 0 1.604969091626214e-07 0.00021 1.6050690916262142e-07 0 1.6052713134434702e-07 0 1.6053713134434703e-07 0.00021 1.6054713134434704e-07 0 1.6058254415562834e-07 0 1.6059254415562836e-07 0.00021 1.6060254415562837e-07 0 1.6060254415562834e-07 0 1.6061254415562835e-07 0.00021 1.6062254415562836e-07 0 1.6062254415562834e-07 0 1.6063254415562835e-07 0.00021 1.6064254415562836e-07 0 1.606477928257242e-07 0 1.6065779282572421e-07 0.00021 1.6066779282572423e-07 0 1.6069692468001098e-07 0 1.60706924680011e-07 0.00021 1.60716924680011e-07 0 1.6075019036065915e-07 0 1.6076019036065916e-07 0.00021 1.6077019036065917e-07 0 1.6077575106352168e-07 0 1.607857510635217e-07 0.00021 1.607957510635217e-07 0 1.6088352300637945e-07 0 1.6089352300637946e-07 0.00021 1.6090352300637947e-07 0 1.609302822587873e-07 0 1.609402822587873e-07 0.00021 1.6095028225878732e-07 0 1.609502822587873e-07 0 1.609602822587873e-07 0.00021 1.6097028225878731e-07 0 1.6099282622493997e-07 0 1.6100282622493998e-07 0.00021 1.6101282622494e-07 0 1.6108517603498928e-07 0 1.610951760349893e-07 0.00021 1.611051760349893e-07 0 1.611474153085319e-07 0 1.611574153085319e-07 0.00021 1.611674153085319e-07 0 1.6116741530853188e-07 0 1.611774153085319e-07 0.00021 1.611874153085319e-07 0 1.6118741530853188e-07 0 1.611974153085319e-07 0.00021 1.612074153085319e-07 0 1.6123011817341163e-07 0 1.6124011817341164e-07 0.00021 1.6125011817341165e-07 0 1.6125011817341162e-07 0 1.6126011817341163e-07 0.00021 1.6127011817341164e-07 0 1.6127011817341162e-07 0 1.6128011817341163e-07 0.00021 1.6129011817341164e-07 0 1.6129011817341161e-07 0 1.6130011817341163e-07 0.00021 1.6131011817341164e-07 0 1.613101181734116e-07 0 1.6132011817341162e-07 0.00021 1.6133011817341163e-07 0 1.613301181734116e-07 0 1.6134011817341162e-07 0.00021 1.6135011817341163e-07 0 1.6137503592518973e-07 0 1.6138503592518974e-07 0.00021 1.6139503592518975e-07 0 1.6141968739246306e-07 0 1.6142968739246307e-07 0.00021 1.6143968739246308e-07 0 1.6143968739246305e-07 0 1.6144968739246306e-07 0.00021 1.6145968739246308e-07 0 1.6145968739246305e-07 0 1.6146968739246306e-07 0.00021 1.6147968739246307e-07 0 1.6149834436199519e-07 0 1.615083443619952e-07 0.00021 1.615183443619952e-07 0 1.6154386964460497e-07 0 1.6155386964460498e-07 0.00021 1.61563869644605e-07 0 1.615959464332873e-07 0 1.616059464332873e-07 0.00021 1.6161594643328732e-07 0 1.616159464332873e-07 0 1.616259464332873e-07 0.00021 1.616359464332873e-07 0 1.6163594643328728e-07 0 1.616459464332873e-07 0.00021 1.616559464332873e-07 0 1.6165594643328728e-07 0 1.616659464332873e-07 0.00021 1.616759464332873e-07 0 1.6167594643328728e-07 0 1.616859464332873e-07 0.00021 1.616959464332873e-07 0 1.6176508801160924e-07 0 1.6177508801160925e-07 0.00021 1.6178508801160927e-07 0 1.6182648960401537e-07 0 1.6183648960401538e-07 0.00021 1.618464896040154e-07 0 1.6184648960401536e-07 0 1.6185648960401537e-07 0.00021 1.6186648960401539e-07 0 1.6186648960401536e-07 0 1.6187648960401537e-07 0.00021 1.6188648960401538e-07 0 1.6188648960401535e-07 0 1.6189648960401537e-07 0.00021 1.6190648960401538e-07 0 1.6190648960401535e-07 0 1.6191648960401536e-07 0.00021 1.6192648960401537e-07 0 1.6192648960401535e-07 0 1.6193648960401536e-07 0.00021 1.6194648960401537e-07 0 1.6194648960401534e-07 0 1.6195648960401535e-07 0.00021 1.6196648960401537e-07 0 1.6196648960401534e-07 0 1.6197648960401535e-07 0.00021 1.6198648960401536e-07 0 1.6198648960401534e-07 0 1.6199648960401535e-07 0.00021 1.6200648960401536e-07 0 1.6200648960401533e-07 0 1.6201648960401534e-07 0.00021 1.6202648960401535e-07 0 1.6204177619211922e-07 0 1.6205177619211923e-07 0.00021 1.6206177619211924e-07 0 1.6210589269659906e-07 0 1.6211589269659907e-07 0.00021 1.6212589269659909e-07 0 1.6212589269659906e-07 0 1.6213589269659907e-07 0.00021 1.6214589269659908e-07 0 1.6214589269659906e-07 0 1.6215589269659907e-07 0.00021 1.6216589269659908e-07 0 1.6216589269659905e-07 0 1.6217589269659906e-07 0.00021 1.6218589269659907e-07 0 1.622893460610444e-07 0 1.6229934606104442e-07 0.00021 1.6230934606104443e-07 0 1.62328280499556e-07 0 1.6233828049955602e-07 0.00021 1.6234828049955603e-07 0 1.62348280499556e-07 0 1.62358280499556e-07 0.00021 1.6236828049955602e-07 0 1.6244006154880496e-07 0 1.6245006154880497e-07 0.00021 1.6246006154880498e-07 0 1.6246006154880495e-07 0 1.6247006154880496e-07 0.00021 1.6248006154880497e-07 0 1.6248006154880495e-07 0 1.6249006154880496e-07 0.00021 1.6250006154880497e-07 0 1.6250006154880494e-07 0 1.6251006154880496e-07 0.00021 1.6252006154880497e-07 0 1.6252006154880494e-07 0 1.6253006154880495e-07 0.00021 1.6254006154880496e-07 0 1.6254006154880494e-07 0 1.6255006154880495e-07 0.00021 1.6256006154880496e-07 0 1.6256006154880493e-07 0 1.6257006154880494e-07 0.00021 1.6258006154880496e-07 0 1.6258006154880493e-07 0 1.6259006154880494e-07 0.00021 1.6260006154880495e-07 0 1.6260006154880492e-07 0 1.6261006154880494e-07 0.00021 1.6262006154880495e-07 0 1.6266059507716948e-07 0 1.626705950771695e-07 0.00021 1.626805950771695e-07 0 1.6268059507716948e-07 0 1.626905950771695e-07 0.00021 1.627005950771695e-07 0 1.6270059507716947e-07 0 1.6271059507716949e-07 0.00021 1.627205950771695e-07 0 1.6273164918192783e-07 0 1.6274164918192784e-07 0.00021 1.6275164918192785e-07 0 1.6276953401305778e-07 0 1.627795340130578e-07 0.00021 1.627895340130578e-07 0 1.628297913487838e-07 0 1.6283979134878382e-07 0.00021 1.6284979134878383e-07 0 1.628497913487838e-07 0 1.6285979134878382e-07 0.00021 1.6286979134878383e-07 0 1.6290556840429818e-07 0 1.629155684042982e-07 0.00021 1.629255684042982e-07 0 1.629318264971605e-07 0 1.6294182649716052e-07 0.00021 1.6295182649716053e-07 0 1.6298941247454633e-07 0 1.6299941247454635e-07 0.00021 1.6300941247454636e-07 0 1.6301136931207464e-07 0 1.6302136931207465e-07 0.00021 1.6303136931207467e-07 0 1.6303136931207464e-07 0 1.6304136931207465e-07 0.00021 1.6305136931207466e-07 0 1.6305136931207464e-07 0 1.6306136931207465e-07 0.00021 1.6307136931207466e-07 0 1.6308044286263e-07 0 1.6309044286263e-07 0.00021 1.6310044286263001e-07 0 1.6310044286263e-07 0 1.6311044286263e-07 0.00021 1.6312044286263e-07 0 1.632319822243993e-07 0 1.6324198222439932e-07 0.00021 1.6325198222439933e-07 0 1.6327929005523556e-07 0 1.6328929005523557e-07 0.00021 1.6329929005523558e-07 0 1.6333782616702455e-07 0 1.6334782616702457e-07 0.00021 1.6335782616702458e-07 0 1.6336928045642984e-07 0 1.6337928045642985e-07 0.00021 1.6338928045642986e-07 0 1.6338928045642984e-07 0 1.6339928045642985e-07 0.00021 1.6340928045642986e-07 0 1.6342555686365181e-07 0 1.6343555686365183e-07 0.00021 1.6344555686365184e-07 0 1.6348014789995303e-07 0 1.6349014789995305e-07 0.00021 1.6350014789995306e-07 0 1.6350014789995303e-07 0 1.6351014789995304e-07 0.00021 1.6352014789995305e-07 0 1.6352014789995303e-07 0 1.6353014789995304e-07 0.00021 1.6354014789995305e-07 0 1.6360592570469e-07 0 1.6361592570469e-07 0.00021 1.6362592570469002e-07 0 1.636678722253537e-07 0 1.636778722253537e-07 0.00021 1.636878722253537e-07 0 1.6368787222535369e-07 0 1.636978722253537e-07 0.00021 1.637078722253537e-07 0 1.6372557537035336e-07 0 1.6373557537035338e-07 0.00021 1.6374557537035339e-07 0 1.6374557537035336e-07 0 1.6375557537035337e-07 0.00021 1.6376557537035338e-07 0 1.6376557537035336e-07 0 1.6377557537035337e-07 0.00021 1.6378557537035338e-07 0 1.6378557537035335e-07 0 1.6379557537035336e-07 0.00021 1.6380557537035338e-07 0 1.6381873735708462e-07 0 1.6382873735708464e-07 0.00021 1.6383873735708465e-07 0 1.6383873735708462e-07 0 1.6384873735708463e-07 0.00021 1.6385873735708464e-07 0 1.6385873735708462e-07 0 1.6386873735708463e-07 0.00021 1.6387873735708464e-07 0 1.6390307097310101e-07 0 1.6391307097310103e-07 0.00021 1.6392307097310104e-07 0 1.63923070973101e-07 0 1.6393307097310102e-07 0.00021 1.6394307097310103e-07 0 1.6399850540363821e-07 0 1.6400850540363823e-07 0.00021 1.6401850540363824e-07 0 1.6411121267879892e-07 0 1.6412121267879894e-07 0.00021 1.6413121267879895e-07 0 1.6413121267879892e-07 0 1.6414121267879893e-07 0.00021 1.6415121267879894e-07 0 1.6415121267879892e-07 0 1.6416121267879893e-07 0.00021 1.6417121267879894e-07 0 1.641712126787989e-07 0 1.6418121267879892e-07 0.00021 1.6419121267879894e-07 0 1.6426003892479345e-07 0 1.6427003892479346e-07 0.00021 1.6428003892479348e-07 0 1.6430442325922545e-07 0 1.6431442325922546e-07 0.00021 1.6432442325922547e-07 0 1.6432783948661814e-07 0 1.6433783948661815e-07 0.00021 1.6434783948661816e-07 0 1.6434783948661813e-07 0 1.6435783948661815e-07 0.00021 1.6436783948661816e-07 0 1.6439570083287165e-07 0 1.6440570083287166e-07 0.00021 1.6441570083287167e-07 0 1.6441617631433412e-07 0 1.6442617631433413e-07 0.00021 1.6443617631433415e-07 0 1.6450584028331927e-07 0 1.6451584028331928e-07 0.00021 1.645258402833193e-07 0 1.6456892171005033e-07 0 1.6457892171005034e-07 0.00021 1.6458892171005035e-07 0 1.646094615905113e-07 0 1.646194615905113e-07 0.00021 1.646294615905113e-07 0 1.646641526661708e-07 0 1.6467415266617082e-07 0.00021 1.6468415266617084e-07 0 1.646841526661708e-07 0 1.6469415266617082e-07 0.00021 1.6470415266617083e-07 0 1.647041526661708e-07 0 1.6471415266617082e-07 0.00021 1.6472415266617083e-07 0 1.647241526661708e-07 0 1.647341526661708e-07 0.00021 1.6474415266617082e-07 0 1.6482044415177638e-07 0 1.648304441517764e-07 0.00021 1.648404441517764e-07 0 1.6484044415177637e-07 0 1.6485044415177639e-07 0.00021 1.648604441517764e-07 0 1.6486044415177637e-07 0 1.6487044415177638e-07 0.00021 1.648804441517764e-07 0 1.6488044415177637e-07 0 1.6489044415177638e-07 0.00021 1.649004441517764e-07 0 1.6490044415177636e-07 0 1.6491044415177637e-07 0.00021 1.6492044415177639e-07 0 1.6492044415177636e-07 0 1.6493044415177637e-07 0.00021 1.6494044415177638e-07 0 1.6494044415177636e-07 0 1.6495044415177637e-07 0.00021 1.6496044415177638e-07 0 1.6496044415177635e-07 0 1.6497044415177636e-07 0.00021 1.6498044415177637e-07 0 1.6498044415177635e-07 0 1.6499044415177636e-07 0.00021 1.6500044415177637e-07 0 1.6500044415177634e-07 0 1.6501044415177636e-07 0.00021 1.6502044415177637e-07 0 1.6502044415177634e-07 0 1.6503044415177635e-07 0.00021 1.6504044415177636e-07 0 1.6504044415177634e-07 0 1.6505044415177635e-07 0.00021 1.6506044415177636e-07 0 1.6506044415177633e-07 0 1.6507044415177634e-07 0.00021 1.6508044415177636e-07 0 1.6508044415177633e-07 0 1.6509044415177634e-07 0.00021 1.6510044415177635e-07 0 1.6514633569875333e-07 0 1.6515633569875334e-07 0.00021 1.6516633569875335e-07 0 1.6519647466927775e-07 0 1.6520647466927777e-07 0.00021 1.6521647466927778e-07 0 1.6521647466927775e-07 0 1.6522647466927776e-07 0.00021 1.6523647466927777e-07 0 1.6523647466927775e-07 0 1.6524647466927776e-07 0.00021 1.6525647466927777e-07 0 1.652625326920485e-07 0 1.6527253269204852e-07 0.00021 1.6528253269204853e-07 0 1.652825326920485e-07 0 1.6529253269204852e-07 0.00021 1.6530253269204853e-07 0 1.653025326920485e-07 0 1.653125326920485e-07 0.00021 1.6532253269204852e-07 0 1.654129706056667e-07 0 1.654229706056667e-07 0.00021 1.6543297060566672e-07 0 1.654378182481529e-07 0 1.654478182481529e-07 0.00021 1.654578182481529e-07 0 1.6545781824815289e-07 0 1.654678182481529e-07 0.00021 1.654778182481529e-07 0 1.6552369945008593e-07 0 1.6553369945008594e-07 0.00021 1.6554369945008595e-07 0 1.6559225263601296e-07 0 1.6560225263601297e-07 0.00021 1.6561225263601298e-07 0 1.6561225263601295e-07 0 1.6562225263601297e-07 0.00021 1.6563225263601298e-07 0 1.6563329743857048e-07 0 1.656432974385705e-07 0.00021 1.656532974385705e-07 0 1.6565329743857047e-07 0 1.6566329743857048e-07 0.00021 1.656732974385705e-07 0 1.6567329743857047e-07 0 1.6568329743857048e-07 0.00021 1.656932974385705e-07 0 1.6569329743857046e-07 0 1.6570329743857048e-07 0.00021 1.657132974385705e-07 0 1.6571329743857046e-07 0 1.6572329743857047e-07 0.00021 1.6573329743857048e-07 0 1.6573329743857046e-07 0 1.6574329743857047e-07 0.00021 1.6575329743857048e-07 0 1.6575329743857045e-07 0 1.6576329743857046e-07 0.00021 1.6577329743857048e-07 0 1.6577329743857045e-07 0 1.6578329743857046e-07 0.00021 1.6579329743857047e-07 0 1.6579329743857045e-07 0 1.6580329743857046e-07 0.00021 1.6581329743857047e-07 0 1.6581329743857044e-07 0 1.6582329743857045e-07 0.00021 1.6583329743857046e-07 0 1.6584458527407267e-07 0 1.6585458527407268e-07 0.00021 1.658645852740727e-07 0 1.6586458527407266e-07 0 1.6587458527407268e-07 0.00021 1.6588458527407269e-07 0 1.6588458527407266e-07 0 1.6589458527407267e-07 0.00021 1.6590458527407268e-07 0 1.6590458527407266e-07 0 1.6591458527407267e-07 0.00021 1.6592458527407268e-07 0 1.6592458527407265e-07 0 1.6593458527407266e-07 0.00021 1.6594458527407268e-07 0 1.6594458527407265e-07 0 1.6595458527407266e-07 0.00021 1.6596458527407267e-07 0 1.659745322389843e-07 0 1.6598453223898432e-07 0.00021 1.6599453223898433e-07 0 1.659945322389843e-07 0 1.6600453223898432e-07 0.00021 1.6601453223898433e-07 0 1.660145322389843e-07 0 1.6602453223898431e-07 0.00021 1.6603453223898432e-07 0 1.660345322389843e-07 0 1.660445322389843e-07 0.00021 1.6605453223898432e-07 0 1.660545322389843e-07 0 1.660645322389843e-07 0.00021 1.6607453223898432e-07 0 1.660745322389843e-07 0 1.660845322389843e-07 0.00021 1.6609453223898431e-07 0 1.660945322389843e-07 0 1.661045322389843e-07 0.00021 1.661145322389843e-07 0 1.6611453223898428e-07 0 1.661245322389843e-07 0.00021 1.661345322389843e-07 0 1.6613453223898428e-07 0 1.661445322389843e-07 0.00021 1.661545322389843e-07 0 1.6615453223898428e-07 0 1.661645322389843e-07 0.00021 1.661745322389843e-07 0 1.6617453223898427e-07 0 1.6618453223898428e-07 0.00021 1.661945322389843e-07 0 1.6619453223898427e-07 0 1.6620453223898428e-07 0.00021 1.662145322389843e-07 0 1.6621453223898426e-07 0 1.6622453223898428e-07 0.00021 1.662345322389843e-07 0 1.6623453223898426e-07 0 1.6624453223898427e-07 0.00021 1.6625453223898428e-07 0 1.6625453223898426e-07 0 1.6626453223898427e-07 0.00021 1.6627453223898428e-07 0 1.6627453223898425e-07 0 1.6628453223898426e-07 0.00021 1.6629453223898428e-07 0 1.6629453223898425e-07 0 1.6630453223898426e-07 0.00021 1.6631453223898427e-07 0 1.6631453223898425e-07 0 1.6632453223898426e-07 0.00021 1.6633453223898427e-07 0 1.6633453223898424e-07 0 1.6634453223898425e-07 0.00021 1.6635453223898426e-07 0 1.6635453223898424e-07 0 1.6636453223898425e-07 0.00021 1.6637453223898426e-07 0 1.6637453223898423e-07 0 1.6638453223898425e-07 0.00021 1.6639453223898426e-07 0 1.6639453223898423e-07 0 1.6640453223898424e-07 0.00021 1.6641453223898425e-07 0 1.6641453223898423e-07 0 1.6642453223898424e-07 0.00021 1.6643453223898425e-07 0 1.6643453223898422e-07 0 1.6644453223898423e-07 0.00021 1.6645453223898425e-07 0 1.6645453223898422e-07 0 1.6646453223898423e-07 0.00021 1.6647453223898424e-07 0 1.6647453223898421e-07 0 1.6648453223898423e-07 0.00021 1.6649453223898424e-07 0 1.664945322389842e-07 0 1.6650453223898422e-07 0.00021 1.6651453223898423e-07 0 1.665145322389842e-07 0 1.6652453223898422e-07 0.00021 1.6653453223898423e-07 0 1.665345322389842e-07 0 1.6654453223898421e-07 0.00021 1.6655453223898423e-07 0 1.665545322389842e-07 0 1.665645322389842e-07 0.00021 1.6657453223898422e-07 0 1.665745322389842e-07 0 1.665845322389842e-07 0.00021 1.6659453223898422e-07 0 1.665945322389842e-07 0 1.666045322389842e-07 0.00021 1.6661453223898421e-07 0 1.6669746881436636e-07 0 1.6670746881436637e-07 0.00021 1.6671746881436638e-07 0 1.6674470913093354e-07 0 1.6675470913093355e-07 0.00021 1.6676470913093356e-07 0 1.66776429807635e-07 0 1.66786429807635e-07 0.00021 1.66796429807635e-07 0 1.668040961080412e-07 0 1.668140961080412e-07 0.00021 1.668240961080412e-07 0 1.668354829595433e-07 0 1.668454829595433e-07 0.00021 1.6685548295954332e-07 0 1.668554829595433e-07 0 1.668654829595433e-07 0.00021 1.6687548295954332e-07 0 1.668754829595433e-07 0 1.668854829595433e-07 0.00021 1.6689548295954332e-07 0 1.668954829595433e-07 0 1.669054829595433e-07 0.00021 1.669154829595433e-07 0 1.6693352673268006e-07 0 1.6694352673268008e-07 0.00021 1.6695352673268009e-07 0 1.6710858940676236e-07 0 1.6711858940676237e-07 0.00021 1.6712858940676238e-07 0 1.6712858940676235e-07 0 1.6713858940676236e-07 0.00021 1.6714858940676238e-07 0 1.6714858940676235e-07 0 1.6715858940676236e-07 0.00021 1.6716858940676237e-07 0 1.6716858940676234e-07 0 1.6717858940676236e-07 0.00021 1.6718858940676237e-07 0 1.6723603818096209e-07 0 1.672460381809621e-07 0.00021 1.672560381809621e-07 0 1.672583587574337e-07 0 1.672683587574337e-07 0.00021 1.6727835875743372e-07 0 1.6729248779771282e-07 0 1.6730248779771283e-07 0.00021 1.6731248779771284e-07 0 1.6731943860686127e-07 0 1.6732943860686128e-07 0.00021 1.673394386068613e-07 0 1.6733943860686127e-07 0 1.6734943860686128e-07 0.00021 1.673594386068613e-07 0 1.6738108624644466e-07 0 1.6739108624644467e-07 0.00021 1.6740108624644468e-07 0 1.6740108624644466e-07 0 1.6741108624644467e-07 0.00021 1.6742108624644468e-07 0 1.6742108624644465e-07 0 1.6743108624644467e-07 0.00021 1.6744108624644468e-07 0 1.6744108624644465e-07 0 1.6745108624644466e-07 0.00021 1.6746108624644467e-07 0 1.6746108624644465e-07 0 1.6747108624644466e-07 0.00021 1.6748108624644467e-07 0 1.6750231453469861e-07 0 1.6751231453469863e-07 0.00021 1.6752231453469864e-07 0 1.6754607671156262e-07 0 1.6755607671156263e-07 0.00021 1.6756607671156264e-07 0 1.6756607671156262e-07 0 1.6757607671156263e-07 0.00021 1.6758607671156264e-07 0 1.6758607671156261e-07 0 1.6759607671156263e-07 0.00021 1.6760607671156264e-07 0 1.676069994513924e-07 0 1.6761699945139241e-07 0.00021 1.6762699945139243e-07 0 1.6771226778300583e-07 0 1.6772226778300585e-07 0.00021 1.6773226778300586e-07 0 1.6774925126333694e-07 0 1.6775925126333696e-07 0.00021 1.6776925126333697e-07 0 1.6789463725246745e-07 0 1.6790463725246746e-07 0.00021 1.6791463725246747e-07 0 1.6791463725246745e-07 0 1.6792463725246746e-07 0.00021 1.6793463725246747e-07 0 1.6804557915540223e-07 0 1.6805557915540224e-07 0.00021 1.6806557915540225e-07 0 1.681892931128658e-07 0 1.681992931128658e-07 0.00021 1.6820929311286582e-07 0 1.6827987886689894e-07 0 1.6828987886689895e-07 0.00021 1.6829987886689897e-07 0 1.6830055973111904e-07 0 1.6831055973111905e-07 0.00021 1.6832055973111906e-07 0 1.6841831162141557e-07 0 1.6842831162141558e-07 0.00021 1.684383116214156e-07 0 1.684596447734277e-07 0 1.6846964477342772e-07 0.00021 1.6847964477342773e-07 0 1.684796447734277e-07 0 1.6848964477342772e-07 0.00021 1.6849964477342773e-07 0 1.684996447734277e-07 0 1.6850964477342771e-07 0.00021 1.6851964477342772e-07 0 1.685196447734277e-07 0 1.685296447734277e-07 0.00021 1.6853964477342772e-07 0 1.685396447734277e-07 0 1.685496447734277e-07 0.00021 1.6855964477342772e-07 0 1.685596447734277e-07 0 1.685696447734277e-07 0.00021 1.6857964477342771e-07 0 1.685796447734277e-07 0 1.685896447734277e-07 0.00021 1.685996447734277e-07 0 1.6861539045171776e-07 0 1.6862539045171778e-07 0.00021 1.6863539045171779e-07 0 1.6872013372291837e-07 0 1.6873013372291838e-07 0.00021 1.687401337229184e-07 0 1.688782439674175e-07 0 1.688882439674175e-07 0.00021 1.6889824396741752e-07 0 1.688982439674175e-07 0 1.689082439674175e-07 0.00021 1.6891824396741752e-07 0 1.689182439674175e-07 0 1.689282439674175e-07 0.00021 1.6893824396741751e-07 0 1.6903906945957138e-07 0 1.690490694595714e-07 0.00021 1.690590694595714e-07 0 1.6905906945957137e-07 0 1.6906906945957139e-07 0.00021 1.690790694595714e-07 0 1.6907906945957137e-07 0 1.6908906945957138e-07 0.00021 1.690990694595714e-07 0 1.6913967789087242e-07 0 1.6914967789087243e-07 0.00021 1.6915967789087244e-07 0 1.6928102180002674e-07 0 1.6929102180002675e-07 0.00021 1.6930102180002676e-07 0 1.6931637544515133e-07 0 1.6932637544515134e-07 0.00021 1.6933637544515135e-07 0 1.6935010689723082e-07 0 1.6936010689723084e-07 0.00021 1.6937010689723085e-07 0 1.6939411784413563e-07 0 1.6940411784413564e-07 0.00021 1.6941411784413566e-07 0 1.6942321083331942e-07 0 1.6943321083331943e-07 0.00021 1.6944321083331944e-07 0 1.6944321083331942e-07 0 1.6945321083331943e-07 0.00021 1.6946321083331944e-07 0 1.694632108333194e-07 0 1.6947321083331942e-07 0.00021 1.6948321083331943e-07 0 1.6949491231844942e-07 0 1.6950491231844943e-07 0.00021 1.6951491231844944e-07 0 1.695149123184494e-07 0 1.6952491231844942e-07 0.00021 1.6953491231844944e-07 0 1.6956670671486393e-07 0 1.6957670671486394e-07 0.00021 1.6958670671486395e-07 0 1.6958670671486393e-07 0 1.6959670671486394e-07 0.00021 1.6960670671486395e-07 0 1.6966530693475668e-07 0 1.696753069347567e-07 0.00021 1.696853069347567e-07 0 1.6968530693475668e-07 0 1.696953069347567e-07 0.00021 1.697053069347567e-07 0 1.6970547697038813e-07 0 1.6971547697038814e-07 0.00021 1.6972547697038815e-07 0 1.6974659694084582e-07 0 1.6975659694084584e-07 0.00021 1.6976659694084585e-07 0 1.6976659694084582e-07 0 1.6977659694084583e-07 0.00021 1.6978659694084584e-07 0 1.697944952571702e-07 0 1.698044952571702e-07 0.00021 1.6981449525717022e-07 0 1.698144952571702e-07 0 1.698244952571702e-07 0.00021 1.6983449525717022e-07 0 1.698344952571702e-07 0 1.698444952571702e-07 0.00021 1.6985449525717022e-07 0 1.698670576213518e-07 0 1.6987705762135182e-07 0.00021 1.6988705762135183e-07 0 1.699187399091339e-07 0 1.699287399091339e-07 0.00021 1.699387399091339e-07 0 1.6998124203779778e-07 0 1.699912420377978e-07 0.00021 1.700012420377978e-07 0 1.7000124203779778e-07 0 1.700112420377978e-07 0.00021 1.700212420377978e-07 0 1.7002124203779778e-07 0 1.7003124203779779e-07 0.00021 1.700412420377978e-07 0 1.7004124203779777e-07 0 1.7005124203779778e-07 0.00021 1.700612420377978e-07 0 1.7006124203779777e-07 0 1.7007124203779778e-07 0.00021 1.700812420377978e-07 0 1.7008124203779776e-07 0 1.7009124203779778e-07 0.00021 1.7010124203779779e-07 0 1.7010124203779776e-07 0 1.7011124203779777e-07 0.00021 1.7012124203779778e-07 0 1.701691459106098e-07 0 1.701791459106098e-07 0.00021 1.7018914591060982e-07 0 1.701891459106098e-07 0 1.701991459106098e-07 0.00021 1.7020914591060982e-07 0 1.702091459106098e-07 0 1.702191459106098e-07 0.00021 1.7022914591060982e-07 0 1.702291459106098e-07 0 1.702391459106098e-07 0.00021 1.702491459106098e-07 0 1.7024914591060979e-07 0 1.702591459106098e-07 0.00021 1.702691459106098e-07 0 1.7029086045910625e-07 0 1.7030086045910626e-07 0.00021 1.7031086045910627e-07 0 1.7031086045910625e-07 0 1.7032086045910626e-07 0.00021 1.7033086045910627e-07 0 1.703659938721187e-07 0 1.7037599387211872e-07 0.00021 1.7038599387211873e-07 0 1.70435476162847e-07 0 1.70445476162847e-07 0.00021 1.7045547616284701e-07 0 1.70455476162847e-07 0 1.70465476162847e-07 0.00021 1.70475476162847e-07 0 1.704818575247566e-07 0 1.704918575247566e-07 0.00021 1.7050185752475662e-07 0 1.7053194405205776e-07 0 1.7054194405205777e-07 0.00021 1.7055194405205778e-07 0 1.7058291715035142e-07 0 1.7059291715035143e-07 0.00021 1.7060291715035144e-07 0 1.7060291715035142e-07 0 1.7061291715035143e-07 0.00021 1.7062291715035144e-07 0 1.706271907349008e-07 0 1.7063719073490082e-07 0.00021 1.7064719073490083e-07 0 1.7067098177577235e-07 0 1.7068098177577236e-07 0.00021 1.7069098177577237e-07 0 1.7069098177577234e-07 0 1.7070098177577235e-07 0.00021 1.7071098177577237e-07 0 1.7071098177577234e-07 0 1.7072098177577235e-07 0.00021 1.7073098177577236e-07 0 1.7073098177577234e-07 0 1.7074098177577235e-07 0.00021 1.7075098177577236e-07 0 1.7075098177577233e-07 0 1.7076098177577234e-07 0.00021 1.7077098177577235e-07 0 1.7077098177577233e-07 0 1.7078098177577234e-07 0.00021 1.7079098177577235e-07 0 1.7079098177577232e-07 0 1.7080098177577234e-07 0.00021 1.7081098177577235e-07 0 1.7081098177577232e-07 0 1.7082098177577233e-07 0.00021 1.7083098177577234e-07 0 1.7083098177577232e-07 0 1.7084098177577233e-07 0.00021 1.7085098177577234e-07 0 1.708509817757723e-07 0 1.7086098177577232e-07 0.00021 1.7087098177577234e-07 0 1.708709817757723e-07 0 1.7088098177577232e-07 0.00021 1.7089098177577233e-07 0 1.708909817757723e-07 0 1.7090098177577232e-07 0.00021 1.7091098177577233e-07 0 1.709109817757723e-07 0 1.709209817757723e-07 0.00021 1.7093098177577232e-07 0 1.7094219594964748e-07 0 1.709521959496475e-07 0.00021 1.709621959496475e-07 0 1.7096219594964748e-07 0 1.709721959496475e-07 0.00021 1.709821959496475e-07 0 1.7099746409874302e-07 0 1.7100746409874303e-07 0.00021 1.7101746409874304e-07 0 1.7105951800758618e-07 0 1.710695180075862e-07 0.00021 1.710795180075862e-07 0 1.7107951800758618e-07 0 1.710895180075862e-07 0.00021 1.710995180075862e-07 0 1.7119111205579157e-07 0 1.7120111205579158e-07 0.00021 1.712111120557916e-07 0 1.712372811729788e-07 0 1.712472811729788e-07 0.00021 1.7125728117297882e-07 0 1.712572811729788e-07 0 1.712672811729788e-07 0.00021 1.712772811729788e-07 0 1.712837186505308e-07 0 1.7129371865053081e-07 0.00021 1.7130371865053083e-07 0 1.713037186505308e-07 0 1.713137186505308e-07 0.00021 1.7132371865053082e-07 0 1.713237186505308e-07 0 1.713337186505308e-07 0.00021 1.7134371865053082e-07 0 1.713437186505308e-07 0 1.713537186505308e-07 0.00021 1.7136371865053081e-07 0 1.713735503552747e-07 0 1.713835503552747e-07 0.00021 1.7139355035527472e-07 0 1.7141437694767617e-07 0 1.7142437694767619e-07 0.00021 1.714343769476762e-07 0 1.7143924043831607e-07 0 1.7144924043831608e-07 0.00021 1.714592404383161e-07 0 1.7145924043831607e-07 0 1.7146924043831608e-07 0.00021 1.714792404383161e-07 0 1.7147924043831607e-07 0 1.7148924043831608e-07 0.00021 1.714992404383161e-07 0 1.7149924043831606e-07 0 1.7150924043831607e-07 0.00021 1.7151924043831608e-07 0 1.715580745770142e-07 0 1.7156807457701422e-07 0.00021 1.7157807457701423e-07 0 1.7160079840635904e-07 0 1.7161079840635905e-07 0.00021 1.7162079840635906e-07 0 1.716255533214434e-07 0 1.716355533214434e-07 0.00021 1.716455533214434e-07 0 1.7164555332144339e-07 0 1.716555533214434e-07 0.00021 1.716655533214434e-07 0 1.7166555332144338e-07 0 1.716755533214434e-07 0.00021 1.716855533214434e-07 0 1.7168555332144338e-07 0 1.716955533214434e-07 0.00021 1.717055533214434e-07 0 1.7170555332144337e-07 0 1.7171555332144339e-07 0.00021 1.717255533214434e-07 0 1.7172555332144337e-07 0 1.7173555332144338e-07 0.00021 1.717455533214434e-07 0 1.7174555332144337e-07 0 1.7175555332144338e-07 0.00021 1.717655533214434e-07 0 1.7176555332144336e-07 0 1.7177555332144337e-07 0.00021 1.7178555332144339e-07 0 1.7178555332144336e-07 0 1.7179555332144337e-07 0.00021 1.7180555332144338e-07 0 1.718149940860826e-07 0 1.718249940860826e-07 0.00021 1.7183499408608262e-07 0 1.718349940860826e-07 0 1.718449940860826e-07 0.00021 1.718549940860826e-07 0 1.719008963324338e-07 0 1.719108963324338e-07 0.00021 1.7192089633243382e-07 0 1.719401470672299e-07 0 1.719501470672299e-07 0.00021 1.7196014706722992e-07 0 1.719601470672299e-07 0 1.719701470672299e-07 0.00021 1.7198014706722992e-07 0 1.720160740879003e-07 0 1.720260740879003e-07 0.00021 1.720360740879003e-07 0 1.7209153800601583e-07 0 1.7210153800601585e-07 0.00021 1.7211153800601586e-07 0 1.721774016432954e-07 0 1.721874016432954e-07 0.00021 1.721974016432954e-07 0 1.7226422291082268e-07 0 1.722742229108227e-07 0.00021 1.722842229108227e-07 0 1.7228422291082267e-07 0 1.7229422291082269e-07 0.00021 1.723042229108227e-07 0 1.7230422291082267e-07 0 1.7231422291082268e-07 0.00021 1.723242229108227e-07 0 1.7232422291082267e-07 0 1.7233422291082268e-07 0.00021 1.723442229108227e-07 0 1.7234422291082266e-07 0 1.7235422291082267e-07 0.00021 1.7236422291082269e-07 0 1.7236422291082266e-07 0 1.7237422291082267e-07 0.00021 1.7238422291082268e-07 0 1.7238422291082266e-07 0 1.7239422291082267e-07 0.00021 1.7240422291082268e-07 0 1.7240422291082265e-07 0 1.7241422291082266e-07 0.00021 1.7242422291082267e-07 0 1.7243846659250478e-07 0 1.724484665925048e-07 0.00021 1.724584665925048e-07 0 1.7245846659250478e-07 0 1.724684665925048e-07 0.00021 1.724784665925048e-07 0 1.7247846659250478e-07 0 1.7248846659250479e-07 0.00021 1.724984665925048e-07 0 1.7249846659250477e-07 0 1.7250846659250478e-07 0.00021 1.725184665925048e-07 0 1.7251846659250477e-07 0 1.7252846659250478e-07 0.00021 1.725384665925048e-07 0 1.7253846659250476e-07 0 1.7254846659250478e-07 0.00021 1.7255846659250479e-07 0 1.7255846659250476e-07 0 1.7256846659250477e-07 0.00021 1.7257846659250478e-07 0 1.7257846659250476e-07 0 1.7258846659250477e-07 0.00021 1.7259846659250478e-07 0 1.7259846659250475e-07 0 1.7260846659250476e-07 0.00021 1.7261846659250477e-07 0 1.7261846659250475e-07 0 1.7262846659250476e-07 0.00021 1.7263846659250477e-07 0 1.7263846659250474e-07 0 1.7264846659250476e-07 0.00021 1.7265846659250477e-07 0 1.7265846659250474e-07 0 1.7266846659250475e-07 0.00021 1.7267846659250476e-07 0 1.7267846659250474e-07 0 1.7268846659250475e-07 0.00021 1.7269846659250476e-07 0 1.7269846659250473e-07 0 1.7270846659250474e-07 0.00021 1.7271846659250476e-07 0 1.727618842069627e-07 0 1.7277188420696272e-07 0.00021 1.7278188420696273e-07 0 1.727818842069627e-07 0 1.727918842069627e-07 0.00021 1.7280188420696272e-07 0 1.728018842069627e-07 0 1.728118842069627e-07 0.00021 1.7282188420696272e-07 0 1.728218842069627e-07 0 1.728318842069627e-07 0.00021 1.7284188420696272e-07 0 1.728418842069627e-07 0 1.728518842069627e-07 0.00021 1.728618842069627e-07 0 1.7286188420696269e-07 0 1.728718842069627e-07 0.00021 1.728818842069627e-07 0 1.7288188420696268e-07 0 1.728918842069627e-07 0.00021 1.729018842069627e-07 0 1.729410229685276e-07 0 1.7295102296852762e-07 0.00021 1.7296102296852763e-07 0 1.7296312803851152e-07 0 1.7297312803851153e-07 0.00021 1.7298312803851154e-07 0 1.7298312803851151e-07 0 1.7299312803851152e-07 0.00021 1.7300312803851154e-07 0 1.7305587630754002e-07 0 1.7306587630754003e-07 0.00021 1.7307587630754004e-07 0 1.7307587630754002e-07 0 1.7308587630754003e-07 0.00021 1.7309587630754004e-07 0 1.731412442401653e-07 0 1.731512442401653e-07 0.00021 1.7316124424016532e-07 0 1.731612442401653e-07 0 1.731712442401653e-07 0.00021 1.7318124424016532e-07 0 1.731812442401653e-07 0 1.731912442401653e-07 0.00021 1.7320124424016532e-07 0 1.732012442401653e-07 0 1.732112442401653e-07 0.00021 1.732212442401653e-07 0 1.7324080249627267e-07 0 1.7325080249627268e-07 0.00021 1.732608024962727e-07 0 1.7326080249627266e-07 0 1.7327080249627267e-07 0.00021 1.7328080249627268e-07 0 1.7331429371418432e-07 0 1.7332429371418433e-07 0.00021 1.7333429371418434e-07 0 1.7339937653420027e-07 0 1.7340937653420028e-07 0.00021 1.734193765342003e-07 0 1.734424053860847e-07 0 1.734524053860847e-07 0.00021 1.7346240538608472e-07 0 1.734624053860847e-07 0 1.734724053860847e-07 0.00021 1.7348240538608472e-07 0 1.7350095975972928e-07 0 1.735109597597293e-07 0.00021 1.735209597597293e-07 0 1.7354141180575583e-07 0 1.7355141180575584e-07 0.00021 1.7356141180575585e-07 0 1.735675349901858e-07 0 1.735775349901858e-07 0.00021 1.735875349901858e-07 0 1.7358753499018579e-07 0 1.735975349901858e-07 0.00021 1.736075349901858e-07 0 1.7360753499018578e-07 0 1.736175349901858e-07 0.00021 1.736275349901858e-07 0 1.7362753499018578e-07 0 1.736375349901858e-07 0.00021 1.736475349901858e-07 0 1.7364869727499942e-07 0 1.7365869727499943e-07 0.00021 1.7366869727499944e-07 0 1.7366869727499941e-07 0 1.7367869727499943e-07 0.00021 1.7368869727499944e-07 0 1.737078506032638e-07 0 1.737178506032638e-07 0.00021 1.7372785060326382e-07 0 1.737278506032638e-07 0 1.737378506032638e-07 0.00021 1.7374785060326381e-07 0 1.737691092169018e-07 0 1.737791092169018e-07 0.00021 1.737891092169018e-07 0 1.7379474526252156e-07 0 1.7380474526252157e-07 0.00021 1.7381474526252158e-07 0 1.738256488790533e-07 0 1.7383564887905332e-07 0.00021 1.7384564887905333e-07 0 1.738456488790533e-07 0 1.7385564887905332e-07 0.00021 1.7386564887905333e-07 0 1.738656488790533e-07 0 1.7387564887905332e-07 0.00021 1.7388564887905333e-07 0 1.738856488790533e-07 0 1.738956488790533e-07 0.00021 1.7390564887905332e-07 0 1.739056488790533e-07 0 1.739156488790533e-07 0.00021 1.7392564887905332e-07 0 1.739256488790533e-07 0 1.739356488790533e-07 0.00021 1.7394564887905332e-07 0 1.739456488790533e-07 0 1.739556488790533e-07 0.00021 1.739656488790533e-07 0 1.7396564887905329e-07 0 1.739756488790533e-07 0.00021 1.739856488790533e-07 0 1.7398564887905328e-07 0 1.739956488790533e-07 0.00021 1.740056488790533e-07 0 1.7400564887905328e-07 0 1.740156488790533e-07 0.00021 1.740256488790533e-07 0 1.7402564887905327e-07 0 1.7403564887905329e-07 0.00021 1.740456488790533e-07 0 1.7404564887905327e-07 0 1.7405564887905328e-07 0.00021 1.740656488790533e-07 0 1.7406564887905327e-07 0 1.7407564887905328e-07 0.00021 1.740856488790533e-07 0 1.7408564887905326e-07 0 1.7409564887905327e-07 0.00021 1.7410564887905329e-07 0 1.7410564887905326e-07 0 1.7411564887905327e-07 0.00021 1.7412564887905328e-07 0 1.7412564887905325e-07 0 1.7413564887905327e-07 0.00021 1.7414564887905328e-07 0 1.7414564887905325e-07 0 1.7415564887905326e-07 0.00021 1.7416564887905327e-07 0 1.7416564887905325e-07 0 1.7417564887905326e-07 0.00021 1.7418564887905327e-07 0 1.7418571912939787e-07 0 1.7419571912939788e-07 0.00021 1.742057191293979e-07 0 1.7420571912939787e-07 0 1.7421571912939788e-07 0.00021 1.742257191293979e-07 0 1.7422571912939786e-07 0 1.7423571912939787e-07 0.00021 1.7424571912939789e-07 0 1.7427106353914722e-07 0 1.7428106353914723e-07 0.00021 1.7429106353914724e-07 0 1.743469897671765e-07 0 1.7435698976717652e-07 0.00021 1.7436698976717654e-07 0 1.743669897671765e-07 0 1.7437698976717652e-07 0.00021 1.7438698976717653e-07 0 1.7440253115481112e-07 0 1.7441253115481113e-07 0.00021 1.7442253115481115e-07 0 1.7442253115481112e-07 0 1.7443253115481113e-07 0.00021 1.7444253115481114e-07 0 1.7444253115481112e-07 0 1.7445253115481113e-07 0.00021 1.7446253115481114e-07 0 1.744625311548111e-07 0 1.7447253115481112e-07 0.00021 1.7448253115481113e-07 0 1.7452570718616162e-07 0 1.7453570718616163e-07 0.00021 1.7454570718616164e-07 0 1.7455025265986032e-07 0 1.7456025265986033e-07 0.00021 1.7457025265986034e-07 0 1.7457025265986031e-07 0 1.7458025265986032e-07 0.00021 1.7459025265986034e-07 0 1.745902526598603e-07 0 1.7460025265986032e-07 0.00021 1.7461025265986033e-07 0 1.7462561879924068e-07 0 1.746356187992407e-07 0.00021 1.746456187992407e-07 0 1.7464561879924068e-07 0 1.746556187992407e-07 0.00021 1.746656187992407e-07 0 1.7466561879924068e-07 0 1.746756187992407e-07 0.00021 1.746856187992407e-07 0 1.7472920665279245e-07 0 1.7473920665279246e-07 0.00021 1.7474920665279247e-07 0 1.7475044058962478e-07 0 1.747604405896248e-07 0.00021 1.747704405896248e-07 0 1.7480158887604673e-07 0 1.7481158887604674e-07 0.00021 1.7482158887604675e-07 0 1.7482158887604673e-07 0 1.7483158887604674e-07 0.00021 1.7484158887604675e-07 0 1.7484158887604672e-07 0 1.7485158887604673e-07 0.00021 1.7486158887604675e-07 0 1.7486158887604672e-07 0 1.7487158887604673e-07 0.00021 1.7488158887604674e-07 0 1.7488158887604672e-07 0 1.7489158887604673e-07 0.00021 1.7490158887604674e-07 0 1.749015888760467e-07 0 1.7491158887604672e-07 0.00021 1.7492158887604673e-07 0 1.749215888760467e-07 0 1.7493158887604672e-07 0.00021 1.7494158887604673e-07 0 1.749415888760467e-07 0 1.7495158887604672e-07 0.00021 1.7496158887604673e-07 0 1.749615888760467e-07 0 1.749715888760467e-07 0.00021 1.7498158887604672e-07 0 1.749983570811081e-07 0 1.7500835708110812e-07 0.00021 1.7501835708110813e-07 0 1.750183570811081e-07 0 1.750283570811081e-07 0.00021 1.7503835708110812e-07 0 1.750482823891148e-07 0 1.750582823891148e-07 0.00021 1.7506828238911482e-07 0 1.7507803430877415e-07 0 1.7508803430877416e-07 0.00021 1.7509803430877418e-07 0 1.7514054771737885e-07 0 1.7515054771737886e-07 0.00021 1.7516054771737887e-07 0 1.7516054771737885e-07 0 1.7517054771737886e-07 0.00021 1.7518054771737887e-07 0 1.7525204592347327e-07 0 1.7526204592347328e-07 0.00021 1.752720459234733e-07 0 1.753257435914106e-07 0 1.753357435914106e-07 0.00021 1.7534574359141061e-07 0 1.753457435914106e-07 0 1.753557435914106e-07 0.00021 1.753657435914106e-07 0 1.7541872237761164e-07 0 1.7542872237761165e-07 0.00021 1.7543872237761167e-07 0 1.754531640213815e-07 0 1.7546316402138152e-07 0.00021 1.7547316402138153e-07 0 1.7549296351931383e-07 0 1.7550296351931384e-07 0.00021 1.7551296351931385e-07 0 1.7560311912028537e-07 0 1.7561311912028538e-07 0.00021 1.756231191202854e-07 0 1.7564197396154305e-07 0 1.7565197396154306e-07 0.00021 1.7566197396154308e-07 0 1.7566197396154305e-07 0 1.7567197396154306e-07 0.00021 1.7568197396154307e-07 0 1.7568197396154305e-07 0 1.7569197396154306e-07 0.00021 1.7570197396154307e-07 0 1.7570197396154304e-07 0 1.7571197396154305e-07 0.00021 1.7572197396154306e-07 0 1.7577523895123419e-07 0 1.757852389512342e-07 0.00021 1.757952389512342e-07 0 1.7582251293822833e-07 0 1.7583251293822834e-07 0.00021 1.7584251293822835e-07 0 1.758998474514751e-07 0 1.7590984745147512e-07 0.00021 1.7591984745147513e-07 0 1.759198474514751e-07 0 1.7592984745147511e-07 0.00021 1.7593984745147513e-07 0 1.7594735144614918e-07 0 1.759573514461492e-07 0.00021 1.759673514461492e-07 0 1.7596735144614917e-07 0 1.7597735144614918e-07 0.00021 1.759873514461492e-07 0 1.7598735144614917e-07 0 1.7599735144614918e-07 0.00021 1.760073514461492e-07 0 1.7605611163075733e-07 0 1.7606611163075734e-07 0.00021 1.7607611163075735e-07 0 1.7608067450794875e-07 0 1.7609067450794876e-07 0.00021 1.7610067450794878e-07 0 1.761887985237288e-07 0 1.7619879852372882e-07 0.00021 1.7620879852372883e-07 0 1.7623893966299859e-07 0 1.762489396629986e-07 0.00021 1.762589396629986e-07 0 1.7625893966299858e-07 0 1.762689396629986e-07 0.00021 1.762789396629986e-07 0 1.7627893966299858e-07 0 1.762889396629986e-07 0.00021 1.762989396629986e-07 0 1.7629893966299857e-07 0 1.7630893966299859e-07 0.00021 1.763189396629986e-07 0 1.763359173683407e-07 0 1.7634591736834072e-07 0.00021 1.7635591736834073e-07 0 1.763919776511308e-07 0 1.764019776511308e-07 0.00021 1.7641197765113082e-07 0 1.7643358828785466e-07 0 1.7644358828785467e-07 0.00021 1.7645358828785468e-07 0 1.7645760949938888e-07 0 1.764676094993889e-07 0.00021 1.764776094993889e-07 0 1.7650496638190861e-07 0 1.7651496638190863e-07 0.00021 1.7652496638190864e-07 0 1.765249663819086e-07 0 1.7653496638190862e-07 0.00021 1.7654496638190863e-07 0 1.765449663819086e-07 0 1.7655496638190862e-07 0.00021 1.7656496638190863e-07 0 1.7657230712043274e-07 0 1.7658230712043275e-07 0.00021 1.7659230712043276e-07 0 1.7659230712043273e-07 0 1.7660230712043274e-07 0.00021 1.7661230712043275e-07 0 1.7661230712043273e-07 0 1.7662230712043274e-07 0.00021 1.7663230712043275e-07 0 1.7663892277537913e-07 0 1.7664892277537914e-07 0.00021 1.7665892277537915e-07 0 1.767168255984445e-07 0 1.7672682559844452e-07 0.00021 1.7673682559844453e-07 0 1.7678270869680874e-07 0 1.7679270869680876e-07 0.00021 1.7680270869680877e-07 0 1.7682503225426432e-07 0 1.7683503225426433e-07 0.00021 1.7684503225426434e-07 0 1.7685320206239858e-07 0 1.768632020623986e-07 0.00021 1.768732020623986e-07 0 1.7688836553701327e-07 0 1.7689836553701328e-07 0.00021 1.769083655370133e-07 0 1.7690836553701326e-07 0 1.7691836553701327e-07 0.00021 1.7692836553701329e-07 0 1.769293409670847e-07 0 1.769393409670847e-07 0.00021 1.7694934096708472e-07 0 1.7700269535422877e-07 0 1.7701269535422879e-07 0.00021 1.770226953542288e-07 0 1.7702269535422877e-07 0 1.7703269535422878e-07 0.00021 1.770426953542288e-07 0 1.770561347808336e-07 0 1.770661347808336e-07 0.00021 1.7707613478083362e-07 0 1.771603726489078e-07 0 1.771703726489078e-07 0.00021 1.7718037264890781e-07 0 1.7721541219370013e-07 0 1.7722541219370014e-07 0.00021 1.7723541219370015e-07 0 1.7724684115279498e-07 0 1.77256841152795e-07 0.00021 1.77266841152795e-07 0 1.7726684115279498e-07 0 1.77276841152795e-07 0.00021 1.77286841152795e-07 0 1.7728684115279497e-07 0 1.7729684115279498e-07 0.00021 1.77306841152795e-07 0 1.7730684115279497e-07 0 1.7731684115279498e-07 0.00021 1.77326841152795e-07 0 1.7732684115279497e-07 0 1.7733684115279498e-07 0.00021 1.77346841152795e-07 0 1.7734684115279496e-07 0 1.7735684115279497e-07 0.00021 1.7736684115279498e-07 0 1.7736684115279496e-07 0 1.7737684115279497e-07 0.00021 1.7738684115279498e-07 0 1.7738684115279495e-07 0 1.7739684115279497e-07 0.00021 1.7740684115279498e-07 0 1.7740684115279495e-07 0 1.7741684115279496e-07 0.00021 1.7742684115279497e-07 0 1.7742684115279495e-07 0 1.7743684115279496e-07 0.00021 1.7744684115279497e-07 0 1.7744733168209504e-07 0 1.7745733168209505e-07 0.00021 1.7746733168209506e-07 0 1.7758913194360067e-07 0 1.7759913194360069e-07 0.00021 1.776091319436007e-07 0 1.776269185779887e-07 0 1.7763691857798872e-07 0.00021 1.7764691857798873e-07 0 1.7768654007878623e-07 0 1.7769654007878625e-07 0.00021 1.7770654007878626e-07 0 1.777177974472364e-07 0 1.777277974472364e-07 0.00021 1.7773779744723642e-07 0 1.777377974472364e-07 0 1.777477974472364e-07 0.00021 1.7775779744723641e-07 0 1.777577974472364e-07 0 1.777677974472364e-07 0.00021 1.777777974472364e-07 0 1.7777779744723638e-07 0 1.777877974472364e-07 0.00021 1.777977974472364e-07 0 1.7787235918638216e-07 0 1.7788235918638217e-07 0.00021 1.7789235918638218e-07 0 1.7789235918638216e-07 0 1.7790235918638217e-07 0.00021 1.7791235918638218e-07 0 1.7791235918638215e-07 0 1.7792235918638216e-07 0.00021 1.7793235918638218e-07 0 1.7793235918638215e-07 0 1.7794235918638216e-07 0.00021 1.7795235918638217e-07 0 1.7795235918638215e-07 0 1.7796235918638216e-07 0.00021 1.7797235918638217e-07 0 1.7797235918638214e-07 0 1.7798235918638215e-07 0.00021 1.7799235918638216e-07 0 1.7799235918638214e-07 0 1.7800235918638215e-07 0.00021 1.7801235918638216e-07 0 1.7801235918638213e-07 0 1.7802235918638215e-07 0.00021 1.7803235918638216e-07 0 1.7803235918638213e-07 0 1.7804235918638214e-07 0.00021 1.7805235918638215e-07 0 1.7805235918638213e-07 0 1.7806235918638214e-07 0.00021 1.7807235918638215e-07 0 1.7807235918638212e-07 0 1.7808235918638213e-07 0.00021 1.7809235918638214e-07 0 1.7809235918638212e-07 0 1.7810235918638213e-07 0.00021 1.7811235918638214e-07 0 1.7811235918638211e-07 0 1.7812235918638213e-07 0.00021 1.7813235918638214e-07 0 1.7815969747663067e-07 0 1.7816969747663068e-07 0.00021 1.781796974766307e-07 0 1.7821395658904832e-07 0 1.7822395658904833e-07 0.00021 1.7823395658904834e-07 0 1.7824331197788424e-07 0 1.7825331197788426e-07 0.00021 1.7826331197788427e-07 0 1.7826331197788424e-07 0 1.7827331197788425e-07 0.00021 1.7828331197788426e-07 0 1.7828331197788424e-07 0 1.7829331197788425e-07 0.00021 1.7830331197788426e-07 0 1.783298262820392e-07 0 1.783398262820392e-07 0.00021 1.7834982628203922e-07 0 1.783929785691825e-07 0 1.7840297856918252e-07 0.00021 1.7841297856918253e-07 0 1.784495317295065e-07 0 1.784595317295065e-07 0.00021 1.7846953172950652e-07 0 1.7859797648812477e-07 0 1.7860797648812478e-07 0.00021 1.786179764881248e-07 0 1.7863405329431347e-07 0 1.7864405329431348e-07 0.00021 1.786540532943135e-07 0 1.7867713395838203e-07 0 1.7868713395838204e-07 0.00021 1.7869713395838205e-07 0 1.7869713395838203e-07 0 1.7870713395838204e-07 0.00021 1.7871713395838205e-07 0 1.7871713395838202e-07 0 1.7872713395838203e-07 0.00021 1.7873713395838205e-07 0 1.7873713395838202e-07 0 1.7874713395838203e-07 0.00021 1.7875713395838204e-07 0 1.7875713395838202e-07 0 1.7876713395838203e-07 0.00021 1.7877713395838204e-07 0 1.7882571036015997e-07 0 1.7883571036015998e-07 0.00021 1.7884571036016e-07 0 1.7884571036015996e-07 0 1.7885571036015997e-07 0.00021 1.7886571036015999e-07 0 1.7886571036015996e-07 0 1.7887571036015997e-07 0.00021 1.7888571036015998e-07 0 1.7891487010089202e-07 0 1.7892487010089203e-07 0.00021 1.7893487010089204e-07 0 1.78934870100892e-07 0 1.7894487010089202e-07 0.00021 1.7895487010089203e-07 0 1.78954870100892e-07 0 1.7896487010089202e-07 0.00021 1.7897487010089203e-07 0 1.78974870100892e-07 0 1.7898487010089202e-07 0.00021 1.7899487010089203e-07 0 1.78994870100892e-07 0 1.79004870100892e-07 0.00021 1.7901487010089202e-07 0 1.79014870100892e-07 0 1.79024870100892e-07 0.00021 1.7903487010089202e-07 0 1.790348706264118e-07 0 1.790448706264118e-07 0.00021 1.7905487062641182e-07 0 1.7905891084799558e-07 0 1.790689108479956e-07 0.00021 1.790789108479956e-07 0 1.7907891084799558e-07 0 1.790889108479956e-07 0.00021 1.790989108479956e-07 0 1.7918006606451238e-07 0 1.791900660645124e-07 0.00021 1.792000660645124e-07 0 1.7920006606451238e-07 0 1.792100660645124e-07 0.00021 1.792200660645124e-07 0 1.7937243537859995e-07 0 1.7938243537859996e-07 0.00021 1.7939243537859997e-07 0 1.7939243537859994e-07 0 1.7940243537859995e-07 0.00021 1.7941243537859997e-07 0 1.7941243537859994e-07 0 1.7942243537859995e-07 0.00021 1.7943243537859996e-07 0 1.7943243537859994e-07 0 1.7944243537859995e-07 0.00021 1.7945243537859996e-07 0 1.7946419209940263e-07 0 1.7947419209940264e-07 0.00021 1.7948419209940265e-07 0 1.7949283795592236e-07 0 1.7950283795592237e-07 0.00021 1.7951283795592239e-07 0 1.7951283795592236e-07 0 1.7952283795592237e-07 0.00021 1.7953283795592238e-07 0 1.7953283795592236e-07 0 1.7954283795592237e-07 0.00021 1.7955283795592238e-07 0 1.7957579428467103e-07 0 1.7958579428467104e-07 0.00021 1.7959579428467105e-07 0 1.796092484559854e-07 0 1.796192484559854e-07 0.00021 1.7962924845598542e-07 0 1.7964511167183e-07 0 1.7965511167183001e-07 0.00021 1.7966511167183003e-07 0 1.7966511167183e-07 0 1.7967511167183e-07 0.00021 1.7968511167183002e-07 0 1.7968511167183e-07 0 1.7969511167183e-07 0.00021 1.7970511167183002e-07 0 1.7970511167183e-07 0 1.7971511167183e-07 0.00021 1.7972511167183001e-07 0 1.7975104220868727e-07 0 1.7976104220868728e-07 0.00021 1.797710422086873e-07 0 1.7984038467044322e-07 0 1.7985038467044323e-07 0.00021 1.7986038467044324e-07 0 1.7986038467044321e-07 0 1.7987038467044323e-07 0.00021 1.7988038467044324e-07 0 1.798938311825827e-07 0 1.799038311825827e-07 0.00021 1.7991383118258272e-07 0 1.799603778633977e-07 0 1.799703778633977e-07 0.00021 1.7998037786339772e-07 0 1.8008866125083587e-07 0 1.8009866125083588e-07 0.00021 1.801086612508359e-07 0 1.8014028146367887e-07 0 1.8015028146367888e-07 0.00021 1.801602814636789e-07 0 1.8016028146367887e-07 0 1.8017028146367888e-07 0.00021 1.801802814636789e-07 0 1.8018028146367886e-07 0 1.8019028146367887e-07 0.00021 1.8020028146367888e-07 0 1.8020028146367886e-07 0 1.8021028146367887e-07 0.00021 1.8022028146367888e-07 0 1.8022028146367885e-07 0 1.8023028146367887e-07 0.00021 1.8024028146367888e-07 0 1.802545085435491e-07 0 1.802645085435491e-07 0.00021 1.8027450854354912e-07 0 1.802745085435491e-07 0 1.802845085435491e-07 0.00021 1.8029450854354912e-07 0 1.802945085435491e-07 0 1.803045085435491e-07 0.00021 1.8031450854354911e-07 0 1.803145085435491e-07 0 1.803245085435491e-07 0.00021 1.803345085435491e-07 0 1.8033450854354908e-07 0 1.803445085435491e-07 0.00021 1.803545085435491e-07 0 1.8035450854354908e-07 0 1.803645085435491e-07 0.00021 1.803745085435491e-07 0 1.8037450854354908e-07 0 1.803845085435491e-07 0.00021 1.803945085435491e-07 0 1.8039450854354907e-07 0 1.8040450854354908e-07 0.00021 1.804145085435491e-07 0 1.8041450854354907e-07 0 1.8042450854354908e-07 0.00021 1.804345085435491e-07 0 1.8043450854354907e-07 0 1.8044450854354908e-07 0.00021 1.804545085435491e-07 0 1.8045450854354906e-07 0 1.8046450854354907e-07 0.00021 1.8047450854354908e-07 0 1.8047450854354906e-07 0 1.8048450854354907e-07 0.00021 1.8049450854354908e-07 0 1.8049450854354905e-07 0 1.8050450854354907e-07 0.00021 1.8051450854354908e-07 0 1.8051921223877195e-07 0 1.8052921223877196e-07 0.00021 1.8053921223877197e-07 0 1.8053921223877194e-07 0 1.8054921223877196e-07 0.00021 1.8055921223877197e-07 0 1.8055921223877194e-07 0 1.8056921223877195e-07 0.00021 1.8057921223877196e-07 0 1.8059562425751874e-07 0 1.8060562425751875e-07 0.00021 1.8061562425751876e-07 0 1.80630172978223e-07 0 1.8064017297822302e-07 0.00021 1.8065017297822303e-07 0 1.8070962153287767e-07 0 1.8071962153287769e-07 0.00021 1.807296215328777e-07 0 1.8072962153287767e-07 0 1.8073962153287768e-07 0.00021 1.807496215328777e-07 0 1.8074962153287767e-07 0 1.8075962153287768e-07 0.00021 1.807696215328777e-07 0 1.8076962153287766e-07 0 1.8077962153287767e-07 0.00021 1.8078962153287769e-07 0 1.8080155773183767e-07 0 1.8081155773183768e-07 0.00021 1.808215577318377e-07 0 1.8089208443381533e-07 0 1.8090208443381534e-07 0.00021 1.8091208443381535e-07 0 1.8091208443381532e-07 0 1.8092208443381533e-07 0.00021 1.8093208443381534e-07 0 1.8093208443381532e-07 0 1.8094208443381533e-07 0.00021 1.8095208443381534e-07 0 1.8095208443381531e-07 0 1.8096208443381533e-07 0.00021 1.8097208443381534e-07 0 1.8100018498274194e-07 0 1.8101018498274196e-07 0.00021 1.8102018498274197e-07 0 1.810397884683508e-07 0 1.8104978846835082e-07 0.00021 1.8105978846835083e-07 0 1.810597884683508e-07 0 1.8106978846835082e-07 0.00021 1.8107978846835083e-07 0 1.810797884683508e-07 0 1.8108978846835082e-07 0.00021 1.8109978846835083e-07 0 1.8110058475772553e-07 0 1.8111058475772554e-07 0.00021 1.8112058475772555e-07 0 1.8112058475772552e-07 0 1.8113058475772553e-07 0.00021 1.8114058475772555e-07 0 1.81184857328688e-07 0 1.81194857328688e-07 0.00021 1.81204857328688e-07 0 1.812688186096379e-07 0 1.812788186096379e-07 0.00021 1.812888186096379e-07 0 1.813124313170595e-07 0 1.813224313170595e-07 0.00021 1.8133243131705952e-07 0 1.813324313170595e-07 0 1.813424313170595e-07 0.00021 1.8135243131705952e-07 0 1.813524313170595e-07 0 1.813624313170595e-07 0.00021 1.813724313170595e-07 0 1.8137243131705949e-07 0 1.813824313170595e-07 0.00021 1.813924313170595e-07 0 1.8139243131705948e-07 0 1.814024313170595e-07 0.00021 1.814124313170595e-07 0 1.8141243131705948e-07 0 1.814224313170595e-07 0.00021 1.814324313170595e-07 0 1.814361684190288e-07 0 1.814461684190288e-07 0.00021 1.8145616841902882e-07 0 1.8150920561250463e-07 0 1.8151920561250464e-07 0.00021 1.8152920561250465e-07 0 1.8152920561250462e-07 0 1.8153920561250464e-07 0.00021 1.8154920561250465e-07 0 1.8154920561250462e-07 0 1.8155920561250463e-07 0.00021 1.8156920561250464e-07 0 1.8156920561250462e-07 0 1.8157920561250463e-07 0.00021 1.8158920561250464e-07 0 1.8158920561250461e-07 0 1.8159920561250462e-07 0.00021 1.8160920561250464e-07 0 1.816092056125046e-07 0 1.8161920561250462e-07 0.00021 1.8162920561250463e-07 0 1.816292056125046e-07 0 1.8163920561250462e-07 0.00021 1.8164920561250463e-07 0 1.816492056125046e-07 0 1.8165920561250461e-07 0.00021 1.8166920561250462e-07 0 1.816909998618264e-07 0 1.8170099986182642e-07 0.00021 1.8171099986182643e-07 0 1.817141970478996e-07 0 1.817241970478996e-07 0.00021 1.817341970478996e-07 0 1.8185175337369123e-07 0 1.8186175337369124e-07 0.00021 1.8187175337369125e-07 0 1.8187175337369122e-07 0 1.8188175337369123e-07 0.00021 1.8189175337369125e-07 0 1.8189175337369122e-07 0 1.8190175337369123e-07 0.00021 1.8191175337369124e-07 0 1.8191175337369122e-07 0 1.8192175337369123e-07 0.00021 1.8193175337369124e-07 0 1.819317533736912e-07 0 1.8194175337369122e-07 0.00021 1.8195175337369123e-07 0 1.819517533736912e-07 0 1.8196175337369122e-07 0.00021 1.8197175337369123e-07 0 1.819717533736912e-07 0 1.8198175337369121e-07 0.00021 1.8199175337369123e-07 0 1.8199848199707648e-07 0 1.820084819970765e-07 0.00021 1.820184819970765e-07 0 1.8201848199707648e-07 0 1.820284819970765e-07 0.00021 1.820384819970765e-07 0 1.8203848199707647e-07 0 1.8204848199707648e-07 0.00021 1.820584819970765e-07 0 1.8205848199707647e-07 0 1.8206848199707648e-07 0.00021 1.820784819970765e-07 0 1.82084823910104e-07 0 1.82094823910104e-07 0.00021 1.8210482391010402e-07 0 1.82104823910104e-07 0 1.82114823910104e-07 0.00021 1.8212482391010402e-07 0 1.8219984713439361e-07 0 1.8220984713439362e-07 0.00021 1.8221984713439364e-07 0 1.822198471343936e-07 0 1.8222984713439362e-07 0.00021 1.8223984713439363e-07 0 1.822398471343936e-07 0 1.8224984713439362e-07 0.00021 1.8225984713439363e-07 0 1.822598471343936e-07 0 1.8226984713439361e-07 0.00021 1.8227984713439362e-07 0 1.8228079196757524e-07 0 1.8229079196757525e-07 0.00021 1.8230079196757526e-07 0 1.8244534862178752e-07 0 1.8245534862178753e-07 0.00021 1.8246534862178754e-07 0 1.8246534862178752e-07 0 1.8247534862178753e-07 0.00021 1.8248534862178754e-07 0 1.824853486217875e-07 0 1.8249534862178752e-07 0.00021 1.8250534862178753e-07 0 1.8257287582616425e-07 0 1.8258287582616426e-07 0.00021 1.8259287582616427e-07 0 1.82628553526984e-07 0 1.82638553526984e-07 0.00021 1.82648553526984e-07 0 1.8267905579230573e-07 0 1.8268905579230574e-07 0.00021 1.8269905579230575e-07 0 1.827657617993092e-07 0 1.827757617993092e-07 0.00021 1.8278576179930922e-07 0 1.8278576834049505e-07 0 1.8279576834049507e-07 0.00021 1.8280576834049508e-07 0 1.8281953592027618e-07 0 1.828295359202762e-07 0.00021 1.828395359202762e-07 0 1.8283953592027617e-07 0 1.8284953592027618e-07 0.00021 1.828595359202762e-07 0 1.8285953592027617e-07 0 1.8286953592027618e-07 0.00021 1.828795359202762e-07 0 1.8287953592027617e-07 0 1.8288953592027618e-07 0.00021 1.828995359202762e-07 0 1.8289953592027616e-07 0 1.8290953592027617e-07 0.00021 1.8291953592027618e-07 0 1.8291953592027616e-07 0 1.8292953592027617e-07 0.00021 1.8293953592027618e-07 0 1.8293953592027615e-07 0 1.8294953592027617e-07 0.00021 1.8295953592027618e-07 0 1.829618248069087e-07 0 1.829718248069087e-07 0.00021 1.8298182480690872e-07 0 1.829818248069087e-07 0 1.829918248069087e-07 0.00021 1.8300182480690872e-07 0 1.830018248069087e-07 0 1.830118248069087e-07 0.00021 1.830218248069087e-07 0 1.8302921649778893e-07 0 1.8303921649778895e-07 0.00021 1.8304921649778896e-07 0 1.8304921649778893e-07 0 1.8305921649778894e-07 0.00021 1.8306921649778895e-07 0 1.8311034053956816e-07 0 1.8312034053956817e-07 0.00021 1.8313034053956818e-07 0 1.8313034053956816e-07 0 1.8314034053956817e-07 0.00021 1.8315034053956818e-07 0 1.8315203158006066e-07 0 1.8316203158006067e-07 0.00021 1.8317203158006068e-07 0 1.8317925490143313e-07 0 1.8318925490143314e-07 0.00021 1.8319925490143315e-07 0 1.832430804368232e-07 0 1.832530804368232e-07 0.00021 1.8326308043682322e-07 0 1.8328159529255179e-07 0 1.832915952925518e-07 0.00021 1.833015952925518e-07 0 1.8334844211822849e-07 0 1.833584421182285e-07 0.00021 1.833684421182285e-07 0 1.83398770953485e-07 0 1.8340877095348501e-07 0.00021 1.8341877095348503e-07 0 1.834425979688748e-07 0 1.8345259796887481e-07 0.00021 1.8346259796887483e-07 0 1.8348041091703565e-07 0 1.8349041091703566e-07 0.00021 1.8350041091703567e-07 0 1.8350290035529727e-07 0 1.8351290035529728e-07 0.00021 1.835229003552973e-07 0 1.8352343949856364e-07 0 1.8353343949856366e-07 0.00021 1.8354343949856367e-07 0 1.8359854532744578e-07 0 1.836085453274458e-07 0.00021 1.836185453274458e-07 0 1.8361854532744577e-07 0 1.8362854532744578e-07 0.00021 1.836385453274458e-07 0 1.8363854532744577e-07 0 1.8364854532744578e-07 0.00021 1.836585453274458e-07 0 1.8365854532744577e-07 0 1.8366854532744578e-07 0.00021 1.836785453274458e-07 0 1.8370496648385473e-07 0 1.8371496648385474e-07 0.00021 1.8372496648385475e-07 0 1.8372791642188168e-07 0 1.837379164218817e-07 0.00021 1.837479164218817e-07 0 1.8374791642188167e-07 0 1.8375791642188168e-07 0.00021 1.837679164218817e-07 0 1.8376791642188167e-07 0 1.8377791642188168e-07 0.00021 1.837879164218817e-07 0 1.8378791642188166e-07 0 1.8379791642188168e-07 0.00021 1.838079164218817e-07 0 1.8380791642188166e-07 0 1.8381791642188167e-07 0.00021 1.8382791642188168e-07 0 1.8383744862544343e-07 0 1.8384744862544344e-07 0.00021 1.8385744862544345e-07 0 1.8385744862544342e-07 0 1.8386744862544344e-07 0.00021 1.8387744862544345e-07 0 1.8387744862544342e-07 0 1.8388744862544343e-07 0.00021 1.8389744862544344e-07 0 1.8389744862544342e-07 0 1.8390744862544343e-07 0.00021 1.8391744862544344e-07 0 1.839174486254434e-07 0 1.8392744862544342e-07 0.00021 1.8393744862544344e-07 0 1.839374486254434e-07 0 1.8394744862544342e-07 0.00021 1.8395744862544343e-07 0 1.839574486254434e-07 0 1.8396744862544342e-07 0.00021 1.8397744862544343e-07 0 1.839774486254434e-07 0 1.839874486254434e-07 0.00021 1.8399744862544342e-07 0 1.839974486254434e-07 0 1.840074486254434e-07 0.00021 1.8401744862544342e-07 0 1.840174486254434e-07 0 1.840274486254434e-07 0.00021 1.8403744862544342e-07 0 1.840374486254434e-07 0 1.840474486254434e-07 0.00021 1.840574486254434e-07 0 1.8405744862544339e-07 0 1.840674486254434e-07 0.00021 1.840774486254434e-07 0 1.8407744862544338e-07 0 1.840874486254434e-07 0.00021 1.840974486254434e-07 0 1.8409744862544338e-07 0 1.841074486254434e-07 0.00021 1.841174486254434e-07 0 1.8411744862544338e-07 0 1.8412744862544339e-07 0.00021 1.841374486254434e-07 0 1.8413744862544337e-07 0 1.8414744862544338e-07 0.00021 1.841574486254434e-07 0 1.8415744862544337e-07 0 1.8416744862544338e-07 0.00021 1.841774486254434e-07 0 1.841960736750023e-07 0 1.842060736750023e-07 0.00021 1.8421607367500232e-07 0 1.842160736750023e-07 0 1.842260736750023e-07 0.00021 1.842360736750023e-07 0 1.8423607367500229e-07 0 1.842460736750023e-07 0.00021 1.842560736750023e-07 0 1.8425607367500228e-07 0 1.842660736750023e-07 0.00021 1.842760736750023e-07 0 1.8427607367500228e-07 0 1.842860736750023e-07 0.00021 1.842960736750023e-07 0 1.8429607367500227e-07 0 1.8430607367500229e-07 0.00021 1.843160736750023e-07 0 1.8431607367500227e-07 0 1.8432607367500228e-07 0.00021 1.843360736750023e-07 0 1.8433607367500227e-07 0 1.8434607367500228e-07 0.00021 1.843560736750023e-07 0 1.843802546550299e-07 0 1.8439025465502992e-07 0.00021 1.8440025465502993e-07 0 1.844002546550299e-07 0 1.8441025465502992e-07 0.00021 1.8442025465502993e-07 0 1.844202546550299e-07 0 1.8443025465502991e-07 0.00021 1.8444025465502992e-07 0 1.844402546550299e-07 0 1.844502546550299e-07 0.00021 1.8446025465502992e-07 0 1.844602546550299e-07 0 1.844702546550299e-07 0.00021 1.8448025465502992e-07 0 1.844802546550299e-07 0 1.844902546550299e-07 0.00021 1.8450025465502991e-07 0 1.845002546550299e-07 0 1.845102546550299e-07 0.00021 1.845202546550299e-07 0 1.8452025465502988e-07 0 1.845302546550299e-07 0.00021 1.845402546550299e-07 0 1.8454025465502988e-07 0 1.845502546550299e-07 0.00021 1.845602546550299e-07 0 1.8456025465502988e-07 0 1.845702546550299e-07 0.00021 1.845802546550299e-07 0 1.8458025465502987e-07 0 1.8459025465502988e-07 0.00021 1.846002546550299e-07 0 1.8460025465502987e-07 0 1.8461025465502988e-07 0.00021 1.846202546550299e-07 0 1.8462025465502986e-07 0 1.8463025465502988e-07 0.00021 1.846402546550299e-07 0 1.8465077053654756e-07 0 1.8466077053654757e-07 0.00021 1.8467077053654758e-07 0 1.8472278373981876e-07 0 1.8473278373981877e-07 0.00021 1.8474278373981878e-07 0 1.8476530232047651e-07 0 1.8477530232047653e-07 0.00021 1.8478530232047654e-07 0 1.847953124629091e-07 0 1.848053124629091e-07 0.00021 1.8481531246290912e-07 0 1.849226981735782e-07 0 1.8493269817357822e-07 0.00021 1.8494269817357823e-07 0 1.849426981735782e-07 0 1.8495269817357822e-07 0.00021 1.8496269817357823e-07 0 1.849626981735782e-07 0 1.8497269817357821e-07 0.00021 1.8498269817357823e-07 0 1.8499507821479029e-07 0 1.850050782147903e-07 0.00021 1.850150782147903e-07 0 1.8501507821479028e-07 0 1.850250782147903e-07 0.00021 1.850350782147903e-07 0 1.8507859010455617e-07 0 1.8508859010455618e-07 0.00021 1.850985901045562e-07 0 1.8509859010455616e-07 0 1.8510859010455617e-07 0.00021 1.8511859010455619e-07 0 1.8511859010455616e-07 0 1.8512859010455617e-07 0.00021 1.8513859010455618e-07 0 1.8513859010455615e-07 0 1.8514859010455617e-07 0.00021 1.8515859010455618e-07 0 1.8515859010455615e-07 0 1.8516859010455616e-07 0.00021 1.8517859010455617e-07 0 1.8521845337769343e-07 0 1.8522845337769345e-07 0.00021 1.8523845337769346e-07 0 1.8526924864029011e-07 0 1.8527924864029013e-07 0.00021 1.8528924864029014e-07 0 1.852892486402901e-07 0 1.8529924864029012e-07 0.00021 1.8530924864029013e-07 0 1.8532328535067998e-07 0 1.8533328535068e-07 0.00021 1.8534328535068e-07 0 1.853518818040044e-07 0 1.8536188180400442e-07 0.00021 1.8537188180400443e-07 0 1.8538352562268548e-07 0 1.853935256226855e-07 0.00021 1.854035256226855e-07 0 1.8542151733436038e-07 0 1.854315173343604e-07 0.00021 1.854415173343604e-07 0 1.8544151733436038e-07 0 1.8545151733436039e-07 0.00021 1.854615173343604e-07 0 1.8546151733436037e-07 0 1.8547151733436038e-07 0.00021 1.854815173343604e-07 0 1.8548151733436037e-07 0 1.8549151733436038e-07 0.00021 1.855015173343604e-07 0 1.8550151733436036e-07 0 1.8551151733436038e-07 0.00021 1.8552151733436039e-07 0 1.8557305212013338e-07 0 1.855830521201334e-07 0.00021 1.855930521201334e-07 0 1.8559305212013338e-07 0 1.856030521201334e-07 0.00021 1.856130521201334e-07 0 1.8562824815892053e-07 0 1.8563824815892054e-07 0.00021 1.8564824815892056e-07 0 1.8569440880212296e-07 0 1.8570440880212297e-07 0.00021 1.8571440880212298e-07 0 1.8571440880212296e-07 0 1.8572440880212297e-07 0.00021 1.8573440880212298e-07 0 1.8573440880212295e-07 0 1.8574440880212297e-07 0.00021 1.8575440880212298e-07 0 1.8575440880212295e-07 0 1.8576440880212296e-07 0.00021 1.8577440880212297e-07 0 1.8577440880212295e-07 0 1.8578440880212296e-07 0.00021 1.8579440880212297e-07 0 1.8579440880212294e-07 0 1.8580440880212295e-07 0.00021 1.8581440880212297e-07 0 1.8581440880212294e-07 0 1.8582440880212295e-07 0.00021 1.8583440880212296e-07 0 1.8583440880212294e-07 0 1.8584440880212295e-07 0.00021 1.8585440880212296e-07 0 1.8585440880212293e-07 0 1.8586440880212294e-07 0.00021 1.8587440880212295e-07 0 1.8587440880212293e-07 0 1.8588440880212294e-07 0.00021 1.8589440880212295e-07 0 1.8589440880212292e-07 0 1.8590440880212294e-07 0.00021 1.8591440880212295e-07 0 1.8591440880212292e-07 0 1.8592440880212293e-07 0.00021 1.8593440880212294e-07 0 1.8593440880212292e-07 0 1.8594440880212293e-07 0.00021 1.8595440880212294e-07 0 1.859544088021229e-07 0 1.8596440880212292e-07 0.00021 1.8597440880212294e-07 0 1.859744088021229e-07 0 1.8598440880212292e-07 0.00021 1.8599440880212293e-07 0 1.859944088021229e-07 0 1.8600440880212292e-07 0.00021 1.8601440880212293e-07 0 1.860144088021229e-07 0 1.860244088021229e-07 0.00021 1.8603440880212292e-07 0 1.860344088021229e-07 0 1.860444088021229e-07 0.00021 1.8605440880212292e-07 0 1.860544088021229e-07 0 1.860644088021229e-07 0.00021 1.8607440880212292e-07 0 1.860744088021229e-07 0 1.860844088021229e-07 0.00021 1.860944088021229e-07 0 1.8609440880212289e-07 0 1.861044088021229e-07 0.00021 1.861144088021229e-07 0 1.8611440880212288e-07 0 1.861244088021229e-07 0.00021 1.861344088021229e-07 0 1.8613440880212288e-07 0 1.861444088021229e-07 0.00021 1.861544088021229e-07 0 1.8615440880212287e-07 0 1.8616440880212289e-07 0.00021 1.861744088021229e-07 0 1.8617440880212287e-07 0 1.8618440880212288e-07 0.00021 1.861944088021229e-07 0 1.8619440880212287e-07 0 1.8620440880212288e-07 0.00021 1.862144088021229e-07 0 1.8621440880212286e-07 0 1.8622440880212287e-07 0.00021 1.8623440880212289e-07 0 1.8623440880212286e-07 0 1.8624440880212287e-07 0.00021 1.8625440880212288e-07 0 1.8625440880212286e-07 0 1.8626440880212287e-07 0.00021 1.8627440880212288e-07 0 1.8633425509581065e-07 0 1.8634425509581067e-07 0.00021 1.8635425509581068e-07 0 1.8635425509581065e-07 0 1.8636425509581066e-07 0.00021 1.8637425509581067e-07 0 1.8637425509581065e-07 0 1.8638425509581066e-07 0.00021 1.8639425509581067e-07 0 1.8639425509581064e-07 0 1.8640425509581065e-07 0.00021 1.8641425509581067e-07 0 1.8642326109924248e-07 0 1.864332610992425e-07 0.00021 1.864432610992425e-07 0 1.864551524560983e-07 0 1.864651524560983e-07 0.00021 1.8647515245609831e-07 0 1.8648159734369294e-07 0 1.8649159734369296e-07 0.00021 1.8650159734369297e-07 0 1.865617944835619e-07 0 1.865717944835619e-07 0.00021 1.8658179448356191e-07 0 1.865817944835619e-07 0 1.865917944835619e-07 0.00021 1.866017944835619e-07 0 1.8671217919890033e-07 0 1.8672217919890034e-07 0.00021 1.8673217919890035e-07 0 1.8673396971735843e-07 0 1.8674396971735844e-07 0.00021 1.8675396971735845e-07 0 1.8679347703536533e-07 0 1.8680347703536534e-07 0.00021 1.8681347703536535e-07 0 1.8685178554693952e-07 0 1.8686178554693953e-07 0.00021 1.8687178554693955e-07 0 1.8687178554693952e-07 0 1.8688178554693953e-07 0.00021 1.8689178554693954e-07 0 1.8689178554693951e-07 0 1.8690178554693953e-07 0.00021 1.8691178554693954e-07 0 1.8696166305710397e-07 0 1.8697166305710398e-07 0.00021 1.86981663057104e-07 0 1.8698166305710397e-07 0 1.8699166305710398e-07 0.00021 1.87001663057104e-07 0 1.8700166305710396e-07 0 1.8701166305710397e-07 0.00021 1.8702166305710398e-07 0 1.8702166305710396e-07 0 1.8703166305710397e-07 0.00021 1.8704166305710398e-07 0 1.8704166305710395e-07 0 1.8705166305710397e-07 0.00021 1.8706166305710398e-07 0 1.8706166305710395e-07 0 1.8707166305710396e-07 0.00021 1.8708166305710397e-07 0 1.870927151144375e-07 0 1.8710271511443752e-07 0.00021 1.8711271511443753e-07 0 1.871152463233923e-07 0 1.871252463233923e-07 0.00021 1.8713524632339232e-07 0 1.871352463233923e-07 0 1.871452463233923e-07 0.00021 1.871552463233923e-07 0 1.8715524632339229e-07 0 1.871652463233923e-07 0.00021 1.871752463233923e-07 0 1.8718929825523092e-07 0 1.8719929825523094e-07 0.00021 1.8720929825523095e-07 0 1.8720929825523092e-07 0 1.8721929825523093e-07 0.00021 1.8722929825523094e-07 0 1.8729394141976532e-07 0 1.8730394141976533e-07 0.00021 1.8731394141976534e-07 0 1.873139414197653e-07 0 1.8732394141976532e-07 0.00021 1.8733394141976533e-07 0 1.873339414197653e-07 0 1.8734394141976532e-07 0.00021 1.8735394141976533e-07 0 1.8736154318678193e-07 0 1.8737154318678194e-07 0.00021 1.8738154318678195e-07 0 1.8738895530710517e-07 0 1.8739895530710518e-07 0.00021 1.874089553071052e-07 0 1.8741504942898545e-07 0 1.8742504942898547e-07 0.00021 1.8743504942898548e-07 0 1.8743504942898545e-07 0 1.8744504942898546e-07 0.00021 1.8745504942898547e-07 0 1.8747237476115734e-07 0 1.8748237476115735e-07 0.00021 1.8749237476115736e-07 0 1.8749237476115733e-07 0 1.8750237476115735e-07 0.00021 1.8751237476115736e-07 0 1.8751237476115733e-07 0 1.8752237476115734e-07 0.00021 1.8753237476115735e-07 0 1.876339433849941e-07 0 1.8764394338499412e-07 0.00021 1.8765394338499413e-07 0 1.876539433849941e-07 0 1.8766394338499411e-07 0.00021 1.8767394338499413e-07 0 1.876900025730521e-07 0 1.8770000257305212e-07 0.00021 1.8771000257305213e-07 0 1.878124021227409e-07 0 1.878224021227409e-07 0.00021 1.878324021227409e-07 0 1.8786238765190794e-07 0 1.8787238765190795e-07 0.00021 1.8788238765190796e-07 0 1.8788238765190794e-07 0 1.8789238765190795e-07 0.00021 1.8790238765190796e-07 0 1.8793195301934439e-07 0 1.879419530193444e-07 0.00021 1.879519530193444e-07 0 1.8795195301934438e-07 0 1.879619530193444e-07 0.00021 1.879719530193444e-07 0 1.8799141627628752e-07 0 1.8800141627628753e-07 0.00021 1.8801141627628754e-07 0 1.880268153019633e-07 0 1.8803681530196332e-07 0.00021 1.8804681530196334e-07 0 1.881268454853228e-07 0 1.881368454853228e-07 0.00021 1.8814684548532282e-07 0 1.8815150455008522e-07 0 1.8816150455008523e-07 0.00021 1.8817150455008525e-07 0 1.8822728514326698e-07 0 1.88237285143267e-07 0.00021 1.88247285143267e-07 0 1.8831215145552653e-07 0 1.8832215145552654e-07 0.00021 1.8833215145552655e-07 0 1.883653708982252e-07 0 1.8837537089822522e-07 0.00021 1.8838537089822523e-07 0 1.883853708982252e-07 0 1.8839537089822522e-07 0.00021 1.8840537089822523e-07 0 1.884053708982252e-07 0 1.884153708982252e-07 0.00021 1.8842537089822522e-07 0 1.884253708982252e-07 0 1.884353708982252e-07 0.00021 1.8844537089822522e-07 0 1.884453708982252e-07 0 1.884553708982252e-07 0.00021 1.8846537089822522e-07 0 1.884653708982252e-07 0 1.884753708982252e-07 0.00021 1.884853708982252e-07 0 1.8848537089822519e-07 0 1.884953708982252e-07 0.00021 1.885053708982252e-07 0 1.8850537089822518e-07 0 1.885153708982252e-07 0.00021 1.885253708982252e-07 0 1.8852716568698959e-07 0 1.885371656869896e-07 0.00021 1.885471656869896e-07 0 1.886048866179398e-07 0 1.8861488661793982e-07 0.00021 1.8862488661793983e-07 0 1.886248866179398e-07 0 1.8863488661793982e-07 0.00021 1.8864488661793983e-07 0 1.8866639925631484e-07 0 1.8867639925631485e-07 0.00021 1.8868639925631486e-07 0 1.8868639925631483e-07 0 1.8869639925631485e-07 0.00021 1.8870639925631486e-07 0 1.8870639925631483e-07 0 1.8871639925631484e-07 0.00021 1.8872639925631485e-07 0 1.8873103801644785e-07 0 1.8874103801644786e-07 0.00021 1.8875103801644787e-07 0 1.887581091511923e-07 0 1.8876810915119232e-07 0.00021 1.8877810915119233e-07 0 1.887781091511923e-07 0 1.8878810915119232e-07 0.00021 1.8879810915119233e-07 0 1.887981091511923e-07 0 1.8880810915119231e-07 0.00021 1.8881810915119233e-07 0 1.888181091511923e-07 0 1.888281091511923e-07 0.00021 1.8883810915119232e-07 0 1.888381091511923e-07 0 1.888481091511923e-07 0.00021 1.8885810915119232e-07 0 1.888581091511923e-07 0 1.888681091511923e-07 0.00021 1.8887810915119231e-07 0 1.888781091511923e-07 0 1.888881091511923e-07 0.00021 1.888981091511923e-07 0 1.889492307654042e-07 0 1.889592307654042e-07 0.00021 1.8896923076540421e-07 0 1.889692307654042e-07 0 1.889792307654042e-07 0.00021 1.889892307654042e-07 0 1.8904345719245848e-07 0 1.890534571924585e-07 0.00021 1.890634571924585e-07 0 1.890918645660775e-07 0 1.8910186456607752e-07 0.00021 1.8911186456607753e-07 0 1.891118645660775e-07 0 1.8912186456607752e-07 0.00021 1.8913186456607753e-07 0 1.891318645660775e-07 0 1.8914186456607752e-07 0.00021 1.8915186456607753e-07 0 1.891518645660775e-07 0 1.891618645660775e-07 0.00021 1.8917186456607752e-07 0 1.891718645660775e-07 0 1.891818645660775e-07 0.00021 1.8919186456607752e-07 0 1.891918645660775e-07 0 1.892018645660775e-07 0.00021 1.8921186456607752e-07 0 1.8924055958804578e-07 0 1.892505595880458e-07 0.00021 1.892605595880458e-07 0 1.8930197927203793e-07 0 1.8931197927203794e-07 0.00021 1.8932197927203795e-07 0 1.893704092863089e-07 0 1.893804092863089e-07 0.00021 1.8939040928630892e-07 0 1.8945397555580982e-07 0 1.8946397555580984e-07 0.00021 1.8947397555580985e-07 0 1.894842656288159e-07 0 1.8949426562881592e-07 0.00021 1.8950426562881593e-07 0 1.895042656288159e-07 0 1.8951426562881592e-07 0.00021 1.8952426562881593e-07 0 1.8960941536688696e-07 0 1.8961941536688697e-07 0.00021 1.8962941536688698e-07 0 1.8962941536688695e-07 0 1.8963941536688697e-07 0.00021 1.8964941536688698e-07 0 1.8964941536688695e-07 0 1.8965941536688696e-07 0.00021 1.8966941536688697e-07 0 1.8966941536688695e-07 0 1.8967941536688696e-07 0.00021 1.8968941536688697e-07 0 1.8968941536688694e-07 0 1.8969941536688695e-07 0.00021 1.8970941536688697e-07 0 1.8975335762311223e-07 0 1.8976335762311224e-07 0.00021 1.8977335762311226e-07 0 1.8977335762311223e-07 0 1.8978335762311224e-07 0.00021 1.8979335762311225e-07 0 1.898036484786084e-07 0 1.898136484786084e-07 0.00021 1.898236484786084e-07 0 1.8982364847860838e-07 0 1.898336484786084e-07 0.00021 1.898436484786084e-07 0 1.8984364847860838e-07 0 1.898536484786084e-07 0.00021 1.898636484786084e-07 0 1.8990326198294245e-07 0 1.8991326198294246e-07 0.00021 1.8992326198294247e-07 0 1.8992326198294245e-07 0 1.8993326198294246e-07 0.00021 1.8994326198294247e-07 0 1.8994326198294244e-07 0 1.8995326198294245e-07 0.00021 1.8996326198294247e-07 0 1.8996326198294244e-07 0 1.8997326198294245e-07 0.00021 1.8998326198294246e-07 0 1.8998326198294244e-07 0 1.8999326198294245e-07 0.00021 1.9000326198294246e-07 0 1.900313519611422e-07 0 1.900413519611422e-07 0.00021 1.9005135196114222e-07 0 1.900716515159613e-07 0 1.900816515159613e-07 0.00021 1.9009165151596132e-07 0 1.900916515159613e-07 0 1.901016515159613e-07 0.00021 1.901116515159613e-07 0 1.9014203051401142e-07 0 1.9015203051401143e-07 0.00021 1.9016203051401144e-07 0 1.9017338445579685e-07 0 1.9018338445579687e-07 0.00021 1.9019338445579688e-07 0 1.9022924456473133e-07 0 1.9023924456473134e-07 0.00021 1.9024924456473135e-07 0 1.9024924456473133e-07 0 1.9025924456473134e-07 0.00021 1.9026924456473135e-07 0 1.9028941767471714e-07 0 1.9029941767471715e-07 0.00021 1.9030941767471716e-07 0 1.9031367451275436e-07 0 1.9032367451275437e-07 0.00021 1.9033367451275438e-07 0 1.9033367451275436e-07 0 1.9034367451275437e-07 0.00021 1.9035367451275438e-07 0 1.903743726807998e-07 0 1.903843726807998e-07 0.00021 1.9039437268079982e-07 0 1.903943726807998e-07 0 1.904043726807998e-07 0.00021 1.9041437268079982e-07 0 1.9041681962923985e-07 0 1.9042681962923986e-07 0.00021 1.9043681962923987e-07 0 1.904699958390507e-07 0 1.9047999583905072e-07 0.00021 1.9048999583905074e-07 0 1.9050369443958397e-07 0 1.9051369443958398e-07 0.00021 1.90523694439584e-07 0 1.9052519147259676e-07 0 1.9053519147259678e-07 0.00021 1.9054519147259679e-07 0 1.9054519147259676e-07 0 1.9055519147259677e-07 0.00021 1.9056519147259678e-07 0 1.9056519147259676e-07 0 1.9057519147259677e-07 0.00021 1.9058519147259678e-07 0 1.9058519147259675e-07 0 1.9059519147259676e-07 0.00021 1.9060519147259678e-07 0 1.9060519147259675e-07 0 1.9061519147259676e-07 0.00021 1.9062519147259677e-07 0 1.9062519147259674e-07 0 1.9063519147259676e-07 0.00021 1.9064519147259677e-07 0 1.9068693311843772e-07 0 1.9069693311843773e-07 0.00021 1.9070693311843774e-07 0 1.9078858463733202e-07 0 1.9079858463733203e-07 0.00021 1.9080858463733205e-07 0 1.908239253934139e-07 0 1.9083392539341392e-07 0.00021 1.9084392539341393e-07 0 1.9086808897993603e-07 0 1.9087808897993604e-07 0.00021 1.9088808897993605e-07 0 1.9094177216115743e-07 0 1.9095177216115744e-07 0.00021 1.9096177216115745e-07 0 1.9098965761397354e-07 0 1.9099965761397356e-07 0.00021 1.9100965761397357e-07 0 1.9103339888427177e-07 0 1.9104339888427178e-07 0.00021 1.910533988842718e-07 0 1.9107380398103248e-07 0 1.910838039810325e-07 0.00021 1.910938039810325e-07 0 1.910968403210658e-07 0 1.9110684032106582e-07 0.00021 1.9111684032106583e-07 0 1.912388274639264e-07 0 1.912488274639264e-07 0.00021 1.9125882746392642e-07 0 1.9128574526927044e-07 0 1.9129574526927045e-07 0.00021 1.9130574526927046e-07 0 1.9130574526927043e-07 0 1.9131574526927044e-07 0.00021 1.9132574526927045e-07 0 1.9132574526927043e-07 0 1.9133574526927044e-07 0.00021 1.9134574526927045e-07 0 1.9136918424465806e-07 0 1.9137918424465807e-07 0.00021 1.9138918424465808e-07 0 1.9138918424465806e-07 0 1.9139918424465807e-07 0.00021 1.9140918424465808e-07 0 1.9140918424465805e-07 0 1.9141918424465806e-07 0.00021 1.9142918424465807e-07 0 1.9142918424465805e-07 0 1.9143918424465806e-07 0.00021 1.9144918424465807e-07 0 1.9144918424465804e-07 0 1.9145918424465806e-07 0.00021 1.9146918424465807e-07 0 1.9147267759500423e-07 0 1.9148267759500424e-07 0.00021 1.9149267759500425e-07 0 1.9149267759500422e-07 0 1.9150267759500423e-07 0.00021 1.9151267759500424e-07 0 1.9151267759500422e-07 0 1.9152267759500423e-07 0.00021 1.9153267759500424e-07 0 1.9155654578069011e-07 0 1.9156654578069013e-07 0.00021 1.9157654578069014e-07 0 1.9162192757988468e-07 0 1.916319275798847e-07 0.00021 1.916419275798847e-07 0 1.9164491110305857e-07 0 1.9165491110305858e-07 0.00021 1.916649111030586e-07 0 1.9171181900222356e-07 0 1.9172181900222357e-07 0.00021 1.9173181900222359e-07 0 1.9173181900222356e-07 0 1.9174181900222357e-07 0.00021 1.9175181900222358e-07 0 1.9175181900222355e-07 0 1.9176181900222357e-07 0.00021 1.9177181900222358e-07 0 1.9177181900222355e-07 0 1.9178181900222356e-07 0.00021 1.9179181900222357e-07 0 1.9184637002316132e-07 0 1.9185637002316133e-07 0.00021 1.9186637002316135e-07 0 1.9186637002316132e-07 0 1.9187637002316133e-07 0.00021 1.9188637002316134e-07 0 1.9188637002316132e-07 0 1.9189637002316133e-07 0.00021 1.9190637002316134e-07 0 1.919063700231613e-07 0 1.9191637002316132e-07 0.00021 1.9192637002316133e-07 0 1.919263700231613e-07 0 1.9193637002316132e-07 0.00021 1.9194637002316133e-07 0 1.919463700231613e-07 0 1.9195637002316132e-07 0.00021 1.9196637002316133e-07 0 1.919663700231613e-07 0 1.919763700231613e-07 0.00021 1.9198637002316132e-07 0 1.919863700231613e-07 0 1.919963700231613e-07 0.00021 1.9200637002316132e-07 0 1.920238946291506e-07 0 1.920338946291506e-07 0.00021 1.9204389462915062e-07 0 1.920438946291506e-07 0 1.920538946291506e-07 0.00021 1.9206389462915061e-07 0 1.920638946291506e-07 0 1.920738946291506e-07 0.00021 1.920838946291506e-07 0 1.9209334660468598e-07 0 1.92103346604686e-07 0.00021 1.92113346604686e-07 0 1.9218935606470545e-07 0 1.9219935606470546e-07 0.00021 1.9220935606470547e-07 0 1.9227326416887415e-07 0 1.9228326416887416e-07 0.00021 1.9229326416887417e-07 0 1.9231473839331005e-07 0 1.9232473839331006e-07 0.00021 1.9233473839331007e-07 0 1.923534794895352e-07 0 1.923634794895352e-07 0.00021 1.9237347948953522e-07 0 1.9238738141795914e-07 0 1.9239738141795915e-07 0.00021 1.9240738141795916e-07 0 1.9240738141795913e-07 0 1.9241738141795914e-07 0.00021 1.9242738141795916e-07 0 1.9242738141795913e-07 0 1.9243738141795914e-07 0.00021 1.9244738141795915e-07 0 1.9244738141795913e-07 0 1.9245738141795914e-07 0.00021 1.9246738141795915e-07 0 1.9246738141795912e-07 0 1.9247738141795913e-07 0.00021 1.9248738141795914e-07 0 1.9248738141795912e-07 0 1.9249738141795913e-07 0.00021 1.9250738141795914e-07 0 1.9256367816596528e-07 0 1.925736781659653e-07 0.00021 1.925836781659653e-07 0 1.92716993764761e-07 0 1.92726993764761e-07 0.00021 1.9273699376476102e-07 0 1.92736993764761e-07 0 1.92746993764761e-07 0.00021 1.9275699376476102e-07 0 1.92756993764761e-07 0 1.92766993764761e-07 0.00021 1.9277699376476102e-07 0 1.92776993764761e-07 0 1.92786993764761e-07 0.00021 1.92796993764761e-07 0 1.9279699376476098e-07 0 1.92806993764761e-07 0.00021 1.92816993764761e-07 0 1.9281699376476098e-07 0 1.92826993764761e-07 0.00021 1.92836993764761e-07 0 1.9283699376476098e-07 0 1.92846993764761e-07 0.00021 1.92856993764761e-07 0 1.9288168460460763e-07 0 1.9289168460460764e-07 0.00021 1.9290168460460765e-07 0 1.9290168460460763e-07 0 1.9291168460460764e-07 0.00021 1.9292168460460765e-07 0 1.9292168460460762e-07 0 1.9293168460460763e-07 0.00021 1.9294168460460764e-07 0 1.9302118898390726e-07 0 1.9303118898390727e-07 0.00021 1.9304118898390729e-07 0 1.9304118898390726e-07 0 1.9305118898390727e-07 0.00021 1.9306118898390728e-07 0 1.9306118898390726e-07 0 1.9307118898390727e-07 0.00021 1.9308118898390728e-07 0 1.9308118898390725e-07 0 1.9309118898390726e-07 0.00021 1.9310118898390727e-07 0 1.9310118898390725e-07 0 1.9311118898390726e-07 0.00021 1.9312118898390727e-07 0 1.9312118898390724e-07 0 1.9313118898390726e-07 0.00021 1.9314118898390727e-07 0 1.931840625829779e-07 0 1.931940625829779e-07 0.00021 1.9320406258297792e-07 0 1.932040625829779e-07 0 1.932140625829779e-07 0.00021 1.9322406258297791e-07 0 1.932240625829779e-07 0 1.932340625829779e-07 0.00021 1.932440625829779e-07 0 1.9324406258297788e-07 0 1.932540625829779e-07 0.00021 1.932640625829779e-07 0 1.9326406258297788e-07 0 1.932740625829779e-07 0.00021 1.932840625829779e-07 0 1.932934708906597e-07 0 1.933034708906597e-07 0.00021 1.933134708906597e-07 0 1.9331347089065969e-07 0 1.933234708906597e-07 0.00021 1.933334708906597e-07 0 1.9333347089065968e-07 0 1.933434708906597e-07 0.00021 1.933534708906597e-07 0 1.9335347089065968e-07 0 1.933634708906597e-07 0.00021 1.933734708906597e-07 0 1.9337347089065968e-07 0 1.9338347089065969e-07 0.00021 1.933934708906597e-07 0 1.9339347089065967e-07 0 1.9340347089065968e-07 0.00021 1.934134708906597e-07 0 1.9341347089065967e-07 0 1.9342347089065968e-07 0.00021 1.934334708906597e-07 0 1.9343347089065966e-07 0 1.9344347089065968e-07 0.00021 1.9345347089065969e-07 0 1.9345347089065966e-07 0 1.9346347089065967e-07 0.00021 1.9347347089065968e-07 0 1.9347347089065966e-07 0 1.9348347089065967e-07 0.00021 1.9349347089065968e-07 0 1.9349347089065965e-07 0 1.9350347089065966e-07 0.00021 1.9351347089065968e-07 0 1.9351347089065965e-07 0 1.9352347089065966e-07 0.00021 1.9353347089065967e-07 0 1.9353347089065964e-07 0 1.9354347089065966e-07 0.00021 1.9355347089065967e-07 0 1.9355347089065964e-07 0 1.9356347089065965e-07 0.00021 1.9357347089065966e-07 0 1.9357347089065964e-07 0 1.9358347089065965e-07 0.00021 1.9359347089065966e-07 0 1.9359347089065963e-07 0 1.9360347089065964e-07 0.00021 1.9361347089065966e-07 0 1.9361347089065963e-07 0 1.9362347089065964e-07 0.00021 1.9363347089065965e-07 0 1.9363347089065963e-07 0 1.9364347089065964e-07 0.00021 1.9365347089065965e-07 0 1.9365347089065962e-07 0 1.9366347089065963e-07 0.00021 1.9367347089065964e-07 0 1.9370161566939346e-07 0 1.9371161566939348e-07 0.00021 1.937216156693935e-07 0 1.9372161566939346e-07 0 1.9373161566939347e-07 0.00021 1.9374161566939348e-07 0 1.9374161566939346e-07 0 1.9375161566939347e-07 0.00021 1.9376161566939348e-07 0 1.9376161566939345e-07 0 1.9377161566939346e-07 0.00021 1.9378161566939348e-07 0 1.9378161566939345e-07 0 1.9379161566939346e-07 0.00021 1.9380161566939347e-07 0 1.9380161566939345e-07 0 1.9381161566939346e-07 0.00021 1.9382161566939347e-07 0 1.9384929386668724e-07 0 1.9385929386668725e-07 0.00021 1.9386929386668727e-07 0 1.9395303369536916e-07 0 1.9396303369536917e-07 0.00021 1.9397303369536918e-07 0 1.9400012715578402e-07 0 1.9401012715578404e-07 0.00021 1.9402012715578405e-07 0 1.9407057906531474e-07 0 1.9408057906531475e-07 0.00021 1.9409057906531476e-07 0 1.940975949300325e-07 0 1.941075949300325e-07 0.00021 1.9411759493003252e-07 0 1.941175949300325e-07 0 1.941275949300325e-07 0.00021 1.941375949300325e-07 0 1.9413759493003249e-07 0 1.941475949300325e-07 0.00021 1.941575949300325e-07 0 1.9416699505226824e-07 0 1.9417699505226825e-07 0.00021 1.9418699505226826e-07 0 1.9419081644217636e-07 0 1.9420081644217637e-07 0.00021 1.9421081644217638e-07 0 1.942119457379894e-07 0 1.942219457379894e-07 0.00021 1.9423194573798942e-07 0 1.942364132526127e-07 0 1.9424641325261272e-07 0.00021 1.9425641325261273e-07 0 1.942644618398908e-07 0 1.942744618398908e-07 0.00021 1.9428446183989082e-07 0 1.9429944619510868e-07 0 1.943094461951087e-07 0.00021 1.943194461951087e-07 0 1.9431944619510868e-07 0 1.943294461951087e-07 0.00021 1.943394461951087e-07 0 1.9433944619510867e-07 0 1.9434944619510868e-07 0.00021 1.943594461951087e-07 0 1.943663320333393e-07 0 1.943763320333393e-07 0.00021 1.9438633203333931e-07 0 1.943863320333393e-07 0 1.943963320333393e-07 0.00021 1.944063320333393e-07 0 1.9446758440318508e-07 0 1.944775844031851e-07 0.00021 1.944875844031851e-07 0 1.945194983084039e-07 0 1.9452949830840392e-07 0.00021 1.9453949830840393e-07 0 1.9454046436535777e-07 0 1.9455046436535778e-07 0.00021 1.945604643653578e-07 0 1.9458234995481337e-07 0 1.9459234995481339e-07 0.00021 1.946023499548134e-07 0 1.9460234995481337e-07 0 1.9461234995481338e-07 0.00021 1.946223499548134e-07 0 1.9463393722448925e-07 0 1.9464393722448926e-07 0.00021 1.9465393722448927e-07 0 1.9465393722448925e-07 0 1.9466393722448926e-07 0.00021 1.9467393722448927e-07 0 1.9467393722448924e-07 0 1.9468393722448926e-07 0.00021 1.9469393722448927e-07 0 1.9469393722448924e-07 0 1.9470393722448925e-07 0.00021 1.9471393722448926e-07 0 1.9471393722448924e-07 0 1.9472393722448925e-07 0.00021 1.9473393722448926e-07 0 1.9473393722448923e-07 0 1.9474393722448924e-07 0.00021 1.9475393722448926e-07 0 1.9475393722448923e-07 0 1.9476393722448924e-07 0.00021 1.9477393722448925e-07 0 1.9477393722448923e-07 0 1.9478393722448924e-07 0.00021 1.9479393722448925e-07 0 1.9479393722448922e-07 0 1.9480393722448923e-07 0.00021 1.9481393722448924e-07 0 1.9481393722448922e-07 0 1.9482393722448923e-07 0.00021 1.9483393722448924e-07 0 1.9483393722448921e-07 0 1.9484393722448923e-07 0.00021 1.9485393722448924e-07 0 1.948539372244892e-07 0 1.9486393722448922e-07 0.00021 1.9487393722448923e-07 0 1.9490524114238178e-07 0 1.949152411423818e-07 0.00021 1.949252411423818e-07 0 1.9492524114238177e-07 0 1.9493524114238178e-07 0.00021 1.949452411423818e-07 0 1.9494524114238177e-07 0 1.9495524114238178e-07 0.00021 1.949652411423818e-07 0 1.9496524114238176e-07 0 1.9497524114238178e-07 0.00021 1.949852411423818e-07 0 1.9499781960783306e-07 0 1.9500781960783307e-07 0.00021 1.9501781960783308e-07 0 1.9501781960783305e-07 0 1.9502781960783306e-07 0.00021 1.9503781960783307e-07 0 1.950901656929601e-07 0 1.951001656929601e-07 0.00021 1.951101656929601e-07 0 1.9511016569296008e-07 0 1.951201656929601e-07 0.00021 1.951301656929601e-07 0 1.9513016569296008e-07 0 1.951401656929601e-07 0.00021 1.951501656929601e-07 0 1.9518350086323737e-07 0 1.9519350086323738e-07 0.00021 1.952035008632374e-07 0 1.9520891963604157e-07 0 1.9521891963604159e-07 0.00021 1.952289196360416e-07 0 1.9522891963604157e-07 0 1.9523891963604158e-07 0.00021 1.952489196360416e-07 0 1.9527585931022148e-07 0 1.9528585931022149e-07 0.00021 1.952958593102215e-07 0 1.9529585931022147e-07 0 1.9530585931022148e-07 0.00021 1.953158593102215e-07 0 1.9531585931022147e-07 0 1.9532585931022148e-07 0.00021 1.953358593102215e-07 0 1.9542664177426272e-07 0 1.9543664177426273e-07 0.00021 1.9544664177426274e-07 0 1.9544664177426272e-07 0 1.9545664177426273e-07 0.00021 1.9546664177426274e-07 0 1.954666417742627e-07 0 1.9547664177426272e-07 0.00021 1.9548664177426274e-07 0 1.954866417742627e-07 0 1.9549664177426272e-07 0.00021 1.9550664177426273e-07 0 1.955066417742627e-07 0 1.9551664177426272e-07 0.00021 1.9552664177426273e-07 0 1.9556071950990534e-07 0 1.9557071950990535e-07 0.00021 1.9558071950990536e-07 0 1.9562625485409133e-07 0 1.9563625485409134e-07 0.00021 1.9564625485409135e-07 0 1.9567014736886083e-07 0 1.9568014736886085e-07 0.00021 1.9569014736886086e-07 0 1.9569014736886083e-07 0 1.9570014736886084e-07 0.00021 1.9571014736886085e-07 0 1.9573748874401884e-07 0 1.9574748874401885e-07 0.00021 1.9575748874401886e-07 0 1.9575748874401883e-07 0 1.9576748874401884e-07 0.00021 1.9577748874401886e-07 0 1.957843997272728e-07 0 1.9579439972727282e-07 0.00021 1.9580439972727283e-07 0 1.958043997272728e-07 0 1.958143997272728e-07 0.00021 1.9582439972727282e-07 0 1.958243997272728e-07 0 1.958343997272728e-07 0.00021 1.9584439972727282e-07 0 1.958443997272728e-07 0 1.958543997272728e-07 0.00021 1.9586439972727282e-07 0 1.958643997272728e-07 0 1.958743997272728e-07 0.00021 1.958843997272728e-07 0 1.9588439972727279e-07 0 1.958943997272728e-07 0.00021 1.959043997272728e-07 0 1.9590439972727278e-07 0 1.959143997272728e-07 0.00021 1.959243997272728e-07 0 1.9592549641439817e-07 0 1.9593549641439818e-07 0.00021 1.959454964143982e-07 0 1.9595751329200015e-07 0 1.9596751329200016e-07 0.00021 1.9597751329200017e-07 0 1.9597751329200015e-07 0 1.9598751329200016e-07 0.00021 1.9599751329200017e-07 0 1.9599751329200014e-07 0 1.9600751329200015e-07 0.00021 1.9601751329200016e-07 0 1.9601751329200014e-07 0 1.9602751329200015e-07 0.00021 1.9603751329200016e-07 0 1.9603751329200013e-07 0 1.9604751329200015e-07 0.00021 1.9605751329200016e-07 0 1.9605751329200013e-07 0 1.9606751329200014e-07 0.00021 1.9607751329200015e-07 0 1.9607751329200013e-07 0 1.9608751329200014e-07 0.00021 1.9609751329200015e-07 0 1.9609751329200012e-07 0 1.9610751329200013e-07 0.00021 1.9611751329200015e-07 0 1.9611751329200012e-07 0 1.9612751329200013e-07 0.00021 1.9613751329200014e-07 0 1.9613751329200012e-07 0 1.9614751329200013e-07 0.00021 1.9615751329200014e-07 0 1.961575132920001e-07 0 1.9616751329200012e-07 0.00021 1.9617751329200013e-07 0 1.961775132920001e-07 0 1.9618751329200012e-07 0.00021 1.9619751329200013e-07 0 1.961975132920001e-07 0 1.9620751329200012e-07 0.00021 1.9621751329200013e-07 0 1.962175132920001e-07 0 1.962275132920001e-07 0.00021 1.9623751329200012e-07 0 1.962375132920001e-07 0 1.962475132920001e-07 0.00021 1.9625751329200012e-07 0 1.962575132920001e-07 0 1.962675132920001e-07 0.00021 1.9627751329200012e-07 0 1.962775132920001e-07 0 1.962875132920001e-07 0.00021 1.962975132920001e-07 0 1.9629751329200009e-07 0 1.963075132920001e-07 0.00021 1.963175132920001e-07 0 1.9631751329200008e-07 0 1.963275132920001e-07 0.00021 1.963375132920001e-07 0 1.9633751329200008e-07 0 1.963475132920001e-07 0.00021 1.963575132920001e-07 0 1.9635751329200007e-07 0 1.9636751329200009e-07 0.00021 1.963775132920001e-07 0 1.9637751329200007e-07 0 1.9638751329200008e-07 0.00021 1.963975132920001e-07 0 1.9639751329200007e-07 0 1.9640751329200008e-07 0.00021 1.964175132920001e-07 0 1.964486367617259e-07 0 1.964586367617259e-07 0.00021 1.9646863676172592e-07 0 1.9651767920918547e-07 0 1.9652767920918548e-07 0.00021 1.965376792091855e-07 0 1.9657080090007847e-07 0 1.9658080090007849e-07 0.00021 1.965908009000785e-07 0 1.9659080090007847e-07 0 1.9660080090007848e-07 0.00021 1.966108009000785e-07 0 1.9661080090007847e-07 0 1.9662080090007848e-07 0.00021 1.966308009000785e-07 0 1.9663080090007846e-07 0 1.9664080090007847e-07 0.00021 1.9665080090007849e-07 0 1.9665080090007846e-07 0 1.9666080090007847e-07 0.00021 1.9667080090007848e-07 0 1.96737946309234e-07 0 1.9674794630923402e-07 0.00021 1.9675794630923403e-07 0 1.967729478523658e-07 0 1.967829478523658e-07 0.00021 1.9679294785236581e-07 0 1.968251015065974e-07 0 1.968351015065974e-07 0.00021 1.9684510150659742e-07 0 1.968451015065974e-07 0 1.968551015065974e-07 0.00021 1.9686510150659741e-07 0 1.968651015065974e-07 0 1.968751015065974e-07 0.00021 1.968851015065974e-07 0 1.9690951462208926e-07 0 1.9691951462208927e-07 0.00021 1.9692951462208928e-07 0 1.9692951462208925e-07 0 1.9693951462208927e-07 0.00021 1.9694951462208928e-07 0 1.9694951462208925e-07 0 1.9695951462208926e-07 0.00021 1.9696951462208927e-07 0 1.9696951462208925e-07 0 1.9697951462208926e-07 0.00021 1.9698951462208927e-07 0 1.9698951462208924e-07 0 1.9699951462208925e-07 0.00021 1.9700951462208927e-07 0 1.9700951462208924e-07 0 1.9701951462208925e-07 0.00021 1.9702951462208926e-07 0 1.9702951462208924e-07 0 1.9703951462208925e-07 0.00021 1.9704951462208926e-07 0 1.9704951462208923e-07 0 1.9705951462208924e-07 0.00021 1.9706951462208925e-07 0 1.9706951462208923e-07 0 1.9707951462208924e-07 0.00021 1.9708951462208925e-07 0 1.9708951462208922e-07 0 1.9709951462208924e-07 0.00021 1.9710951462208925e-07 0 1.9710951462208922e-07 0 1.9711951462208923e-07 0.00021 1.9712951462208924e-07 0 1.9712951462208922e-07 0 1.9713951462208923e-07 0.00021 1.9714951462208924e-07 0 1.9725341834746145e-07 0 1.9726341834746146e-07 0.00021 1.9727341834746147e-07 0 1.9727341834746144e-07 0 1.9728341834746145e-07 0.00021 1.9729341834746146e-07 0 1.9729341834746144e-07 0 1.9730341834746145e-07 0.00021 1.9731341834746146e-07 0 1.973551636101498e-07 0 1.973651636101498e-07 0.00021 1.9737516361014982e-07 0 1.9739114439304136e-07 0 1.9740114439304137e-07 0.00021 1.9741114439304138e-07 0 1.9749028065082937e-07 0 1.9750028065082938e-07 0.00021 1.975102806508294e-07 0 1.9761386722901167e-07 0 1.9762386722901168e-07 0.00021 1.976338672290117e-07 0 1.976935105823733e-07 0 1.977035105823733e-07 0.00021 1.977135105823733e-07 0 1.9774459148799564e-07 0 1.9775459148799565e-07 0.00021 1.9776459148799566e-07 0 1.9776459148799564e-07 0 1.9777459148799565e-07 0.00021 1.9778459148799566e-07 0 1.978136412408658e-07 0 1.9782364124086582e-07 0.00021 1.9783364124086583e-07 0 1.97846814218968e-07 0 1.97856814218968e-07 0.00021 1.9786681421896802e-07 0 1.979008864969837e-07 0 1.979108864969837e-07 0.00021 1.9792088649698372e-07 0 1.979818872764096e-07 0 1.9799188727640962e-07 0.00021 1.9800188727640963e-07 0 1.980045780814543e-07 0 1.980145780814543e-07 0.00021 1.9802457808145432e-07 0 1.9802604511128073e-07 0 1.9803604511128075e-07 0.00021 1.9804604511128076e-07 0 1.9804604511128073e-07 0 1.9805604511128074e-07 0.00021 1.9806604511128075e-07 0 1.9806604511128073e-07 0 1.9807604511128074e-07 0.00021 1.9808604511128075e-07 0 1.9808604511128072e-07 0 1.9809604511128073e-07 0.00021 1.9810604511128075e-07 0 1.9810604511128072e-07 0 1.9811604511128073e-07 0.00021 1.9812604511128074e-07 0 1.9812604511128071e-07 0 1.9813604511128073e-07 0.00021 1.9814604511128074e-07 0 1.9816980331377375e-07 0 1.9817980331377377e-07 0.00021 1.9818980331377378e-07 0 1.9818980331377375e-07 0 1.9819980331377376e-07 0.00021 1.9820980331377377e-07 0 1.9833834868029568e-07 0 1.983483486802957e-07 0.00021 1.983583486802957e-07 0 1.9835834868029568e-07 0 1.983683486802957e-07 0.00021 1.983783486802957e-07 0 1.9837834868029567e-07 0 1.9838834868029568e-07 0.00021 1.983983486802957e-07 0 1.9839834868029567e-07 0 1.9840834868029568e-07 0.00021 1.984183486802957e-07 0 1.9841834868029567e-07 0 1.9842834868029568e-07 0.00021 1.984383486802957e-07 0 1.9846058051546934e-07 0 1.9847058051546935e-07 0.00021 1.9848058051546937e-07 0 1.9848058051546934e-07 0 1.9849058051546935e-07 0.00021 1.9850058051546936e-07 0 1.985046641725355e-07 0 1.985146641725355e-07 0.00021 1.9852466417253551e-07 0 1.9853942893393005e-07 0 1.9854942893393006e-07 0.00021 1.9855942893393007e-07 0 1.9865865308453997e-07 0 1.9866865308453998e-07 0.00021 1.9867865308454e-07 0 1.9878867002349298e-07 0 1.98798670023493e-07 0.00021 1.98808670023493e-07 0 1.9886705912422207e-07 0 1.9887705912422208e-07 0.00021 1.988870591242221e-07 0 1.9892373717484916e-07 0 1.9893373717484917e-07 0.00021 1.9894373717484918e-07 0 1.9895894654664173e-07 0 1.9896894654664174e-07 0.00021 1.9897894654664175e-07 0 1.989808529416366e-07 0 1.989908529416366e-07 0.00021 1.9900085294163662e-07 0 1.990008529416366e-07 0 1.990108529416366e-07 0.00021 1.990208529416366e-07 0 1.9902558150964158e-07 0 1.990355815096416e-07 0.00021 1.990455815096416e-07 0 1.9905263733198316e-07 0 1.9906263733198318e-07 0.00021 1.990726373319832e-07 0 1.9907263733198316e-07 0 1.9908263733198317e-07 0.00021 1.9909263733198318e-07 0 1.9909263733198316e-07 0 1.9910263733198317e-07 0.00021 1.9911263733198318e-07 0 1.9911263733198315e-07 0 1.9912263733198316e-07 0.00021 1.9913263733198318e-07 0 1.991415761747678e-07 0 1.991515761747678e-07 0.00021 1.9916157617476782e-07 0 1.9922232240105767e-07 0 1.9923232240105768e-07 0.00021 1.992423224010577e-07 0 1.9924956492523465e-07 0 1.9925956492523466e-07 0.00021 1.9926956492523467e-07 0 1.9927592940155862e-07 0 1.9928592940155864e-07 0.00021 1.9929592940155865e-07 0 1.9929592940155862e-07 0 1.9930592940155863e-07 0.00021 1.9931592940155864e-07 0 1.9931592940155862e-07 0 1.9932592940155863e-07 0.00021 1.9933592940155864e-07 0 1.993359294015586e-07 0 1.9934592940155862e-07 0.00021 1.9935592940155864e-07 0 1.993559294015586e-07 0 1.9936592940155862e-07 0.00021 1.9937592940155863e-07 0 1.993759294015586e-07 0 1.9938592940155862e-07 0.00021 1.9939592940155863e-07 0 1.993959294015586e-07 0 1.994059294015586e-07 0.00021 1.9941592940155862e-07 0 1.994159294015586e-07 0 1.994259294015586e-07 0.00021 1.9943592940155862e-07 0 1.994359294015586e-07 0 1.994459294015586e-07 0.00021 1.9945592940155862e-07 0 1.994932279134225e-07 0 1.995032279134225e-07 0.00021 1.9951322791342251e-07 0 1.995132279134225e-07 0 1.995232279134225e-07 0.00021 1.995332279134225e-07 0 1.9953322791342248e-07 0 1.995432279134225e-07 0.00021 1.995532279134225e-07 0 1.9955322791342248e-07 0 1.995632279134225e-07 0.00021 1.995732279134225e-07 0 1.9960684061445392e-07 0 1.9961684061445393e-07 0.00021 1.9962684061445395e-07 0 1.9962684061445392e-07 0 1.9963684061445393e-07 0.00021 1.9964684061445394e-07 0 1.9965381740564005e-07 0 1.9966381740564006e-07 0.00021 1.9967381740564007e-07 0 1.9967381740564004e-07 0 1.9968381740564006e-07 0.00021 1.9969381740564007e-07 0 1.9969381740564004e-07 0 1.9970381740564005e-07 0.00021 1.9971381740564006e-07 0 1.9972765073345914e-07 0 1.9973765073345916e-07 0.00021 1.9974765073345917e-07 0 1.9977098762782024e-07 0 1.9978098762782025e-07 0.00021 1.9979098762782026e-07 0 1.9984227907781263e-07 0 1.9985227907781264e-07 0.00021 1.9986227907781265e-07 0 1.9990611282787666e-07 0 1.9991611282787667e-07 0.00021 1.9992611282787668e-07 0 1.9992611282787666e-07 0 1.9993611282787667e-07 0.00021 1.9994611282787668e-07 0 1.9996289822012073e-07 0 1.9997289822012074e-07 0.00021 1.9998289822012075e-07 0 1.9998289822012073e-07 0 1.9999289822012074e-07 0.00021 2.0000289822012075e-07 0 2.0000289822012072e-07 0 2.0001289822012073e-07 0.00021 2.0002289822012075e-07 0 2.0002289822012072e-07 0 2.0003289822012073e-07 0.00021 2.0004289822012074e-07 0 2.0018803401825585e-07 0 2.0019803401825586e-07 0.00021 2.0020803401825587e-07 0 2.0024332651267333e-07 0 2.0025332651267334e-07 0.00021 2.0026332651267335e-07 0 2.0026332651267332e-07 0 2.0027332651267334e-07 0.00021 2.0028332651267335e-07 0 2.0028332651267332e-07 0 2.0029332651267333e-07 0.00021 2.0030332651267334e-07 0 2.0035329895340302e-07 0 2.0036329895340303e-07 0.00021 2.0037329895340304e-07 0 2.0038582633031986e-07 0 2.0039582633031987e-07 0.00021 2.0040582633031988e-07 0 2.0040582633031985e-07 0 2.0041582633031986e-07 0.00021 2.0042582633031988e-07 0 2.0042582633031985e-07 0 2.0043582633031986e-07 0.00021 2.0044582633031987e-07 0 2.0044582633031985e-07 0 2.0045582633031986e-07 0.00021 2.0046582633031987e-07 0 2.0046582633031984e-07 0 2.0047582633031985e-07 0.00021 2.0048582633031986e-07 0 2.0048582633031984e-07 0 2.0049582633031985e-07 0.00021 2.0050582633031986e-07 0 2.0050582633031983e-07 0 2.0051582633031984e-07 0.00021 2.0052582633031986e-07 0 2.0052582633031983e-07 0 2.0053582633031984e-07 0.00021 2.0054582633031985e-07 0 2.0054582633031983e-07 0 2.0055582633031984e-07 0.00021 2.0056582633031985e-07 0 2.0056582633031982e-07 0 2.0057582633031983e-07 0.00021 2.0058582633031984e-07 0 2.0058582633031982e-07 0 2.0059582633031983e-07 0.00021 2.0060582633031984e-07 0 2.0060582633031981e-07 0 2.0061582633031983e-07 0.00021 2.0062582633031984e-07 0 2.0068242948495126e-07 0 2.0069242948495127e-07 0.00021 2.0070242948495128e-07 0 2.0070242948495126e-07 0 2.0071242948495127e-07 0.00021 2.0072242948495128e-07 0 2.0076352246012214e-07 0 2.0077352246012215e-07 0.00021 2.0078352246012216e-07 0 2.0078824647353404e-07 0 2.0079824647353405e-07 0.00021 2.0080824647353406e-07 0 2.0080824647353403e-07 0 2.0081824647353404e-07 0.00021 2.0082824647353406e-07 0 2.0082824647353403e-07 0 2.0083824647353404e-07 0.00021 2.0084824647353405e-07 0 2.0101199169584479e-07 0 2.010219916958448e-07 0.00021 2.010319916958448e-07 0 2.0103199169584478e-07 0 2.010419916958448e-07 0.00021 2.010519916958448e-07 0 2.0105199169584478e-07 0 2.010619916958448e-07 0.00021 2.010719916958448e-07 0 2.0107199169584478e-07 0 2.0108199169584479e-07 0.00021 2.010919916958448e-07 0 2.0109199169584477e-07 0 2.0110199169584478e-07 0.00021 2.011119916958448e-07 0 2.0111199169584477e-07 0 2.0112199169584478e-07 0.00021 2.011319916958448e-07 0 2.0113199169584476e-07 0 2.0114199169584478e-07 0.00021 2.0115199169584479e-07 0 2.0115199169584476e-07 0 2.0116199169584477e-07 0.00021 2.0117199169584478e-07 0 2.0117199169584476e-07 0 2.0118199169584477e-07 0.00021 2.0119199169584478e-07 0 2.0119199169584475e-07 0 2.0120199169584476e-07 0.00021 2.0121199169584478e-07 0 2.0121199169584475e-07 0 2.0122199169584476e-07 0.00021 2.0123199169584477e-07 0 2.0123199169584474e-07 0 2.0124199169584476e-07 0.00021 2.0125199169584477e-07 0 2.0125199169584474e-07 0 2.0126199169584475e-07 0.00021 2.0127199169584476e-07 0 2.0127199169584474e-07 0 2.0128199169584475e-07 0.00021 2.0129199169584476e-07 0 2.0129199169584473e-07 0 2.0130199169584474e-07 0.00021 2.0131199169584476e-07 0 2.0131199169584473e-07 0 2.0132199169584474e-07 0.00021 2.0133199169584475e-07 0 2.0133199169584473e-07 0 2.0134199169584474e-07 0.00021 2.0135199169584475e-07 0 2.0135199169584472e-07 0 2.0136199169584473e-07 0.00021 2.0137199169584474e-07 0 2.0137199169584472e-07 0 2.0138199169584473e-07 0.00021 2.0139199169584474e-07 0 2.0139199169584471e-07 0 2.0140199169584473e-07 0.00021 2.0141199169584474e-07 0 2.014119916958447e-07 0 2.0142199169584472e-07 0.00021 2.0143199169584473e-07 0 2.014319916958447e-07 0 2.0144199169584472e-07 0.00021 2.0145199169584473e-07 0 2.014519916958447e-07 0 2.0146199169584471e-07 0.00021 2.0147199169584473e-07 0 2.014719916958447e-07 0 2.014819916958447e-07 0.00021 2.0149199169584472e-07 0 2.014919916958447e-07 0 2.015019916958447e-07 0.00021 2.0151199169584472e-07 0 2.015119916958447e-07 0 2.015219916958447e-07 0.00021 2.0153199169584471e-07 0 2.015319916958447e-07 0 2.015419916958447e-07 0.00021 2.015519916958447e-07 0 2.0155199169584468e-07 0 2.015619916958447e-07 0.00021 2.015719916958447e-07 0 2.0157199169584468e-07 0 2.015819916958447e-07 0.00021 2.015919916958447e-07 0 2.0159199169584468e-07 0 2.016019916958447e-07 0.00021 2.016119916958447e-07 0 2.0161199169584467e-07 0 2.0162199169584468e-07 0.00021 2.016319916958447e-07 0 2.0168257943311466e-07 0 2.0169257943311467e-07 0.00021 2.0170257943311468e-07 0 2.017078462546394e-07 0 2.0171784625463942e-07 0.00021 2.0172784625463943e-07 0 2.017278462546394e-07 0 2.017378462546394e-07 0.00021 2.0174784625463942e-07 0 2.017478462546394e-07 0 2.017578462546394e-07 0.00021 2.0176784625463942e-07 0 2.017678462546394e-07 0 2.017778462546394e-07 0.00021 2.0178784625463942e-07 0 2.017878462546394e-07 0 2.017978462546394e-07 0.00021 2.018078462546394e-07 0 2.0180784625463939e-07 0 2.018178462546394e-07 0.00021 2.018278462546394e-07 0 2.0182784625463938e-07 0 2.018378462546394e-07 0.00021 2.018478462546394e-07 0 2.0184784625463938e-07 0 2.018578462546394e-07 0.00021 2.018678462546394e-07 0 2.0186784625463937e-07 0 2.0187784625463939e-07 0.00021 2.018878462546394e-07 0 2.0188784625463937e-07 0 2.0189784625463938e-07 0.00021 2.019078462546394e-07 0 2.0190784625463937e-07 0 2.0191784625463938e-07 0.00021 2.019278462546394e-07 0 2.0192784625463936e-07 0 2.0193784625463937e-07 0.00021 2.0194784625463939e-07 0 2.0194784625463936e-07 0 2.0195784625463937e-07 0.00021 2.0196784625463938e-07 0 2.0196784625463936e-07 0 2.0197784625463937e-07 0.00021 2.0198784625463938e-07 0 2.0198784625463935e-07 0 2.0199784625463936e-07 0.00021 2.0200784625463937e-07 0 2.0200784625463935e-07 0 2.0201784625463936e-07 0.00021 2.0202784625463937e-07 0 2.0202784625463934e-07 0 2.0203784625463936e-07 0.00021 2.0204784625463937e-07 0 2.0204784625463934e-07 0 2.0205784625463935e-07 0.00021 2.0206784625463936e-07 0 2.0206784625463934e-07 0 2.0207784625463935e-07 0.00021 2.0208784625463936e-07 0 2.0208784625463933e-07 0 2.0209784625463934e-07 0.00021 2.0210784625463936e-07 0 2.0210784625463933e-07 0 2.0211784625463934e-07 0.00021 2.0212784625463935e-07 0 2.0212784625463933e-07 0 2.0213784625463934e-07 0.00021 2.0214784625463935e-07 0 2.0214784625463932e-07 0 2.0215784625463933e-07 0.00021 2.0216784625463934e-07 0 2.0216784625463932e-07 0 2.0217784625463933e-07 0.00021 2.0218784625463934e-07 0 2.0218784625463931e-07 0 2.0219784625463933e-07 0.00021 2.0220784625463934e-07 0 2.022078462546393e-07 0 2.0221784625463932e-07 0.00021 2.0222784625463933e-07 0 2.022278462546393e-07 0 2.0223784625463932e-07 0.00021 2.0224784625463933e-07 0 2.022478462546393e-07 0 2.0225784625463931e-07 0.00021 2.0226784625463933e-07 0 2.022678462546393e-07 0 2.022778462546393e-07 0.00021 2.0228784625463932e-07 0 2.022878462546393e-07 0 2.022978462546393e-07 0.00021 2.0230784625463932e-07 0 2.023078462546393e-07 0 2.023178462546393e-07 0.00021 2.0232784625463931e-07 0 2.023278462546393e-07 0 2.023378462546393e-07 0.00021 2.023478462546393e-07 0 2.0234784625463928e-07 0 2.023578462546393e-07 0.00021 2.023678462546393e-07 0 2.0236784625463928e-07 0 2.023778462546393e-07 0.00021 2.023878462546393e-07 0 2.0238784625463928e-07 0 2.023978462546393e-07 0.00021 2.024078462546393e-07 0 2.0240784625463927e-07 0 2.0241784625463928e-07 0.00021 2.024278462546393e-07 0 2.024513673104941e-07 0 2.024613673104941e-07 0.00021 2.024713673104941e-07 0 2.0247136731049408e-07 0 2.024813673104941e-07 0.00021 2.024913673104941e-07 0 2.0249184072219756e-07 0 2.0250184072219757e-07 0.00021 2.0251184072219758e-07 0 2.0254944113690952e-07 0 2.0255944113690953e-07 0.00021 2.0256944113690954e-07 0 2.0258019736165877e-07 0 2.0259019736165879e-07 0.00021 2.026001973616588e-07 0 2.0266905634356537e-07 0 2.0267905634356538e-07 0.00021 2.026890563435654e-07 0 2.0272366702449608e-07 0 2.027336670244961e-07 0.00021 2.027436670244961e-07 0 2.02748268144787e-07 0 2.02758268144787e-07 0.00021 2.0276826814478702e-07 0 2.0279595311305878e-07 0 2.028059531130588e-07 0.00021 2.028159531130588e-07 0 2.0287235093137301e-07 0 2.0288235093137303e-07 0.00021 2.0289235093137304e-07 0 2.02892350931373e-07 0 2.0290235093137302e-07 0.00021 2.0291235093137303e-07 0 2.0299046387863583e-07 0 2.0300046387863584e-07 0.00021 2.0301046387863585e-07 0 2.03069296023271e-07 0 2.0307929602327102e-07 0.00021 2.0308929602327103e-07 0 2.0309804950144417e-07 0 2.0310804950144418e-07 0.00021 2.031180495014442e-07 0 2.0311804950144417e-07 0 2.0312804950144418e-07 0.00021 2.031380495014442e-07 0 2.031764710765716e-07 0 2.031864710765716e-07 0.00021 2.0319647107657162e-07 0 2.032097999575363e-07 0 2.032197999575363e-07 0.00021 2.0322979995753632e-07 0 2.0323677154185862e-07 0 2.0324677154185863e-07 0.00021 2.0325677154185864e-07 0 2.0325677154185862e-07 0 2.0326677154185863e-07 0.00021 2.0327677154185864e-07 0 2.0327677154185861e-07 0 2.0328677154185863e-07 0.00021 2.0329677154185864e-07 0 2.032967715418586e-07 0 2.0330677154185862e-07 0.00021 2.0331677154185863e-07 0 2.033167715418586e-07 0 2.0332677154185862e-07 0.00021 2.0333677154185863e-07 0 2.033959785195416e-07 0 2.0340597851954162e-07 0.00021 2.0341597851954163e-07 0 2.034159785195416e-07 0 2.0342597851954162e-07 0.00021 2.0343597851954163e-07 0 2.0349004595277994e-07 0 2.0350004595277995e-07 0.00021 2.0351004595277996e-07 0 2.0351004595277993e-07 0 2.0352004595277994e-07 0.00021 2.0353004595277996e-07 0 2.0358967778295163e-07 0 2.0359967778295164e-07 0.00021 2.0360967778295165e-07 0 2.0361597902551448e-07 0 2.036259790255145e-07 0.00021 2.036359790255145e-07 0 2.0377176052992103e-07 0 2.0378176052992104e-07 0.00021 2.0379176052992105e-07 0 2.0380866500831344e-07 0 2.0381866500831345e-07 0.00021 2.0382866500831346e-07 0 2.0382866500831344e-07 0 2.0383866500831345e-07 0.00021 2.0384866500831346e-07 0 2.0392592173730586e-07 0 2.0393592173730588e-07 0.00021 2.039459217373059e-07 0 2.0394592173730586e-07 0 2.0395592173730587e-07 0.00021 2.0396592173730588e-07 0 2.0399604602496424e-07 0 2.0400604602496425e-07 0.00021 2.0401604602496426e-07 0 2.0401604602496423e-07 0 2.0402604602496424e-07 0.00021 2.0403604602496425e-07 0 2.0403604602496423e-07 0 2.0404604602496424e-07 0.00021 2.0405604602496425e-07 0 2.0405604602496422e-07 0 2.0406604602496424e-07 0.00021 2.0407604602496425e-07 0 2.0407604602496422e-07 0 2.0408604602496423e-07 0.00021 2.0409604602496424e-07 0 2.0409614796382742e-07 0 2.0410614796382743e-07 0.00021 2.0411614796382744e-07 0 2.0412417767869003e-07 0 2.0413417767869005e-07 0.00021 2.0414417767869006e-07 0 2.041768765197242e-07 0 2.0418687651972422e-07 0.00021 2.0419687651972423e-07 0 2.041968765197242e-07 0 2.0420687651972422e-07 0.00021 2.0421687651972423e-07 0 2.0422261492322443e-07 0 2.0423261492322444e-07 0.00021 2.0424261492322445e-07 0 2.0427215827997518e-07 0 2.042821582799752e-07 0.00021 2.042921582799752e-07 0 2.0429215827997518e-07 0 2.043021582799752e-07 0.00021 2.043121582799752e-07 0 2.043306356225437e-07 0 2.0434063562254372e-07 0.00021 2.0435063562254373e-07 0 2.0435563546287588e-07 0 2.043656354628759e-07 0.00021 2.043756354628759e-07 0 2.0437613394814063e-07 0 2.0438613394814064e-07 0.00021 2.0439613394814066e-07 0 2.0439613394814063e-07 0 2.0440613394814064e-07 0.00021 2.0441613394814065e-07 0 2.0441613394814062e-07 0 2.0442613394814064e-07 0.00021 2.0443613394814065e-07 0 2.0443613394814062e-07 0 2.0444613394814063e-07 0.00021 2.0445613394814064e-07 0 2.0446276083893518e-07 0 2.044727608389352e-07 0.00021 2.044827608389352e-07 0 2.045259446653248e-07 0 2.045359446653248e-07 0.00021 2.045459446653248e-07 0 2.0454594466532479e-07 0 2.045559446653248e-07 0.00021 2.045659446653248e-07 0 2.0456594466532478e-07 0 2.045759446653248e-07 0.00021 2.045859446653248e-07 0 2.046192741554258e-07 0 2.0462927415542582e-07 0.00021 2.0463927415542583e-07 0 2.046392741554258e-07 0 2.0464927415542582e-07 0.00021 2.0465927415542583e-07 0 2.046592741554258e-07 0 2.0466927415542581e-07 0.00021 2.0467927415542582e-07 0 2.046792741554258e-07 0 2.046892741554258e-07 0.00021 2.0469927415542582e-07 0 2.046992741554258e-07 0 2.047092741554258e-07 0.00021 2.0471927415542582e-07 0 2.0473403739948725e-07 0 2.0474403739948726e-07 0.00021 2.0475403739948727e-07 0 2.0481714427754635e-07 0 2.0482714427754636e-07 0.00021 2.0483714427754638e-07 0 2.04886062730997e-07 0 2.04896062730997e-07 0.00021 2.04906062730997e-07 0 2.049675146391371e-07 0 2.049775146391371e-07 0.00021 2.0498751463913712e-07 0 2.0498752565970524e-07 0 2.0499752565970525e-07 0.00021 2.0500752565970526e-07 0 2.0501461152616226e-07 0 2.0502461152616227e-07 0.00021 2.0503461152616228e-07 0 2.0503461152616226e-07 0 2.0504461152616227e-07 0.00021 2.0505461152616228e-07 0 2.050749365236801e-07 0 2.0508493652368012e-07 0.00021 2.0509493652368014e-07 0 2.0511057486834218e-07 0 2.051205748683422e-07 0.00021 2.051305748683422e-07 0 2.0516260331415998e-07 0 2.0517260331416e-07 0.00021 2.0518260331416e-07 0 2.0520414602223384e-07 0 2.0521414602223385e-07 0.00021 2.0522414602223386e-07 0 2.0522414602223383e-07 0 2.0523414602223384e-07 0.00021 2.0524414602223386e-07 0 2.0524699283417934e-07 0 2.0525699283417935e-07 0.00021 2.0526699283417936e-07 0 2.0526699283417933e-07 0 2.0527699283417934e-07 0.00021 2.0528699283417936e-07 0 2.0528699283417933e-07 0 2.0529699283417934e-07 0.00021 2.0530699283417935e-07 0 2.0530699283417933e-07 0 2.0531699283417934e-07 0.00021 2.0532699283417935e-07 0 2.0532699283417932e-07 0 2.0533699283417933e-07 0.00021 2.0534699283417934e-07 0 2.0534699283417932e-07 0 2.0535699283417933e-07 0.00021 2.0536699283417934e-07 0 2.0536699283417931e-07 0 2.0537699283417933e-07 0.00021 2.0538699283417934e-07 0 2.053869928341793e-07 0 2.0539699283417932e-07 0.00021 2.0540699283417933e-07 0 2.054069928341793e-07 0 2.0541699283417932e-07 0.00021 2.0542699283417933e-07 0 2.054269928341793e-07 0 2.0543699283417931e-07 0.00021 2.0544699283417933e-07 0 2.054469928341793e-07 0 2.054569928341793e-07 0.00021 2.0546699283417932e-07 0 2.054669928341793e-07 0 2.054769928341793e-07 0.00021 2.0548699283417932e-07 0 2.054999996600215e-07 0 2.055099996600215e-07 0.00021 2.0551999966002152e-07 0 2.055199996600215e-07 0 2.055299996600215e-07 0.00021 2.0553999966002152e-07 0 2.055399996600215e-07 0 2.055499996600215e-07 0.00021 2.055599996600215e-07 0 2.0556635693982286e-07 0 2.0557635693982287e-07 0.00021 2.0558635693982289e-07 0 2.0558635693982286e-07 0 2.0559635693982287e-07 0.00021 2.0560635693982288e-07 0 2.0560635693982285e-07 0 2.0561635693982287e-07 0.00021 2.0562635693982288e-07 0 2.0562635693982285e-07 0 2.0563635693982286e-07 0.00021 2.0564635693982287e-07 0 2.0571464771247885e-07 0 2.0572464771247887e-07 0.00021 2.0573464771247888e-07 0 2.0579491807212585e-07 0 2.0580491807212586e-07 0.00021 2.0581491807212588e-07 0 2.0581491807212585e-07 0 2.0582491807212586e-07 0.00021 2.0583491807212587e-07 0 2.058720661892604e-07 0 2.0588206618926042e-07 0.00021 2.0589206618926044e-07 0 2.058920661892604e-07 0 2.0590206618926042e-07 0.00021 2.0591206618926043e-07 0 2.059157567057352e-07 0 2.059257567057352e-07 0.00021 2.059357567057352e-07 0 2.0595999771386718e-07 0 2.059699977138672e-07 0.00021 2.059799977138672e-07 0 2.0600140460252127e-07 0 2.0601140460252128e-07 0.00021 2.060214046025213e-07 0 2.0603173438215616e-07 0 2.0604173438215617e-07 0.00021 2.0605173438215618e-07 0 2.0605173438215616e-07 0 2.0606173438215617e-07 0.00021 2.0607173438215618e-07 0 2.0607173438215615e-07 0 2.0608173438215617e-07 0.00021 2.0609173438215618e-07 0 2.0613342938799845e-07 0 2.0614342938799847e-07 0.00021 2.0615342938799848e-07 0 2.0615989491778445e-07 0 2.0616989491778446e-07 0.00021 2.0617989491778447e-07 0 2.0621343981792183e-07 0 2.0622343981792184e-07 0.00021 2.0623343981792185e-07 0 2.062376873044481e-07 0 2.062476873044481e-07 0.00021 2.0625768730444812e-07 0 2.062736133866629e-07 0 2.062836133866629e-07 0.00021 2.0629361338666292e-07 0 2.062936133866629e-07 0 2.063036133866629e-07 0.00021 2.0631361338666292e-07 0 2.0632535934192276e-07 0 2.0633535934192278e-07 0.00021 2.063453593419228e-07 0 2.0635335942536772e-07 0 2.0636335942536773e-07 0.00021 2.0637335942536774e-07 0 2.0637335942536771e-07 0 2.0638335942536772e-07 0.00021 2.0639335942536774e-07 0 2.0640349828727366e-07 0 2.0641349828727368e-07 0.00021 2.064234982872737e-07 0 2.0642984703694814e-07 0 2.0643984703694815e-07 0.00021 2.0644984703694816e-07 0 2.0644984703694813e-07 0 2.0645984703694814e-07 0.00021 2.0646984703694816e-07 0 2.0646984703694813e-07 0 2.0647984703694814e-07 0.00021 2.0648984703694815e-07 0 2.065167570601496e-07 0 2.065267570601496e-07 0.00021 2.0653675706014962e-07 0 2.0655294767613198e-07 0 2.06562947676132e-07 0.00021 2.06572947676132e-07 0 2.0657294767613198e-07 0 2.06582947676132e-07 0.00021 2.06592947676132e-07 0 2.0659294767613198e-07 0 2.0660294767613199e-07 0.00021 2.06612947676132e-07 0 2.0661294767613197e-07 0 2.0662294767613198e-07 0.00021 2.06632947676132e-07 0 2.0663294767613197e-07 0 2.0664294767613198e-07 0.00021 2.06652947676132e-07 0 2.0665294767613196e-07 0 2.0666294767613198e-07 0.00021 2.0667294767613199e-07 0 2.0667294767613196e-07 0 2.0668294767613197e-07 0.00021 2.0669294767613198e-07 0 2.0669294767613196e-07 0 2.0670294767613197e-07 0.00021 2.0671294767613198e-07 0 2.0671294767613195e-07 0 2.0672294767613196e-07 0.00021 2.0673294767613198e-07 0 2.0673294767613195e-07 0 2.0674294767613196e-07 0.00021 2.0675294767613197e-07 0 2.067729184214005e-07 0 2.067829184214005e-07 0.00021 2.0679291842140052e-07 0 2.068080913230734e-07 0 2.068180913230734e-07 0.00021 2.0682809132307342e-07 0 2.068280913230734e-07 0 2.068380913230734e-07 0.00021 2.0684809132307341e-07 0 2.0685960576285252e-07 0 2.0686960576285253e-07 0.00021 2.0687960576285254e-07 0 2.0687960576285252e-07 0 2.0688960576285253e-07 0.00021 2.0689960576285254e-07 0 2.068996057628525e-07 0 2.0690960576285252e-07 0.00021 2.0691960576285254e-07 0 2.069306612690349e-07 0 2.069406612690349e-07 0.00021 2.0695066126903492e-07 0 2.069506612690349e-07 0 2.069606612690349e-07 0.00021 2.0697066126903492e-07 0 2.069706612690349e-07 0 2.069806612690349e-07 0.00021 2.0699066126903491e-07 0 2.0701648367838626e-07 0 2.0702648367838627e-07 0.00021 2.0703648367838629e-07 0 2.0706314534601945e-07 0 2.0707314534601946e-07 0.00021 2.0708314534601947e-07 0 2.0708314534601944e-07 0 2.0709314534601945e-07 0.00021 2.0710314534601947e-07 0 2.0710314534601944e-07 0 2.0711314534601945e-07 0.00021 2.0712314534601946e-07 0 2.0712314534601944e-07 0 2.0713314534601945e-07 0.00021 2.0714314534601946e-07 0 2.0714314534601943e-07 0 2.0715314534601944e-07 0.00021 2.0716314534601945e-07 0 2.0716314534601943e-07 0 2.0717314534601944e-07 0.00021 2.0718314534601945e-07 0 2.0718314534601942e-07 0 2.0719314534601944e-07 0.00021 2.0720314534601945e-07 0 2.0720314534601942e-07 0 2.0721314534601943e-07 0.00021 2.0722314534601944e-07 0 2.0722314534601942e-07 0 2.0723314534601943e-07 0.00021 2.0724314534601944e-07 0 2.072431453460194e-07 0 2.0725314534601942e-07 0.00021 2.0726314534601944e-07 0 2.072631453460194e-07 0 2.0727314534601942e-07 0.00021 2.0728314534601943e-07 0 2.072831453460194e-07 0 2.0729314534601942e-07 0.00021 2.0730314534601943e-07 0 2.073031453460194e-07 0 2.073131453460194e-07 0.00021 2.0732314534601942e-07 0 2.073231453460194e-07 0 2.073331453460194e-07 0.00021 2.0734314534601942e-07 0 2.073431453460194e-07 0 2.073531453460194e-07 0.00021 2.0736314534601942e-07 0 2.073631453460194e-07 0 2.073731453460194e-07 0.00021 2.073831453460194e-07 0 2.0738314534601939e-07 0 2.073931453460194e-07 0.00021 2.074031453460194e-07 0 2.0740314534601938e-07 0 2.074131453460194e-07 0.00021 2.074231453460194e-07 0 2.0742314534601938e-07 0 2.074331453460194e-07 0.00021 2.074431453460194e-07 0 2.074653260265943e-07 0 2.074753260265943e-07 0.00021 2.0748532602659432e-07 0 2.0749616873903174e-07 0 2.0750616873903175e-07 0.00021 2.0751616873903176e-07 0 2.0754783239694976e-07 0 2.0755783239694977e-07 0.00021 2.0756783239694978e-07 0 2.0756783239694976e-07 0 2.0757783239694977e-07 0.00021 2.0758783239694978e-07 0 2.075899831076887e-07 0 2.0759998310768872e-07 0.00021 2.0760998310768873e-07 0 2.0764903616071784e-07 0 2.0765903616071785e-07 0.00021 2.0766903616071786e-07 0 2.0768498090199848e-07 0 2.076949809019985e-07 0.00021 2.077049809019985e-07 0 2.0777791920957995e-07 0 2.0778791920957996e-07 0.00021 2.0779791920957998e-07 0 2.0779791920957995e-07 0 2.0780791920957996e-07 0.00021 2.0781791920957997e-07 0 2.0781791920957995e-07 0 2.0782791920957996e-07 0.00021 2.0783791920957997e-07 0 2.0783791920957994e-07 0 2.0784791920957995e-07 0.00021 2.0785791920957996e-07 0 2.0785791920957994e-07 0 2.0786791920957995e-07 0.00021 2.0787791920957996e-07 0 2.0787791920957993e-07 0 2.0788791920957995e-07 0.00021 2.0789791920957996e-07 0 2.079172796996842e-07 0 2.0792727969968422e-07 0.00021 2.0793727969968423e-07 0 2.079372796996842e-07 0 2.0794727969968422e-07 0.00021 2.0795727969968423e-07 0 2.079572796996842e-07 0 2.079672796996842e-07 0.00021 2.0797727969968422e-07 0 2.079772796996842e-07 0 2.079872796996842e-07 0.00021 2.0799727969968422e-07 0 2.079972796996842e-07 0 2.080072796996842e-07 0.00021 2.0801727969968422e-07 0 2.081633751210363e-07 0 2.081733751210363e-07 0.00021 2.081833751210363e-07 0 2.0818337512103629e-07 0 2.081933751210363e-07 0.00021 2.082033751210363e-07 0 2.0820337512103628e-07 0 2.082133751210363e-07 0.00021 2.082233751210363e-07 0 2.0825915694473764e-07 0 2.0826915694473765e-07 0.00021 2.0827915694473766e-07 0 2.0828650828011814e-07 0 2.0829650828011815e-07 0.00021 2.0830650828011817e-07 0 2.0831564187278663e-07 0 2.0832564187278664e-07 0.00021 2.0833564187278665e-07 0 2.0833564187278663e-07 0 2.0834564187278664e-07 0.00021 2.0835564187278665e-07 0 2.0835564187278662e-07 0 2.0836564187278664e-07 0.00021 2.0837564187278665e-07 0 2.0837564187278662e-07 0 2.0838564187278663e-07 0.00021 2.0839564187278664e-07 0 2.0839564187278662e-07 0 2.0840564187278663e-07 0.00021 2.0841564187278664e-07 0 2.0844011025154748e-07 0 2.084501102515475e-07 0.00021 2.084601102515475e-07 0 2.0846011025154748e-07 0 2.084701102515475e-07 0.00021 2.084801102515475e-07 0 2.085483669155181e-07 0 2.0855836691551811e-07 0.00021 2.0856836691551812e-07 0 2.085683669155181e-07 0 2.085783669155181e-07 0.00021 2.0858836691551812e-07 0 2.085883669155181e-07 0 2.085983669155181e-07 0.00021 2.0860836691551812e-07 0 2.086083669155181e-07 0 2.086183669155181e-07 0.00021 2.0862836691551811e-07 0 2.086283669155181e-07 0 2.086383669155181e-07 0.00021 2.086483669155181e-07 0 2.086687929686809e-07 0 2.086787929686809e-07 0.00021 2.0868879296868092e-07 0 2.086887929686809e-07 0 2.086987929686809e-07 0.00021 2.0870879296868091e-07 0 2.087474763037027e-07 0 2.087574763037027e-07 0.00021 2.0876747630370272e-07 0 2.087674763037027e-07 0 2.087774763037027e-07 0.00021 2.0878747630370272e-07 0 2.088254173314841e-07 0 2.088354173314841e-07 0.00021 2.088454173314841e-07 0 2.0884541733148409e-07 0 2.088554173314841e-07 0.00021 2.088654173314841e-07 0 2.0886541733148408e-07 0 2.088754173314841e-07 0.00021 2.088854173314841e-07 0 2.088866798367606e-07 0 2.088966798367606e-07 0.00021 2.0890667983676061e-07 0 2.089066798367606e-07 0 2.089166798367606e-07 0.00021 2.089266798367606e-07 0 2.089358410809712e-07 0 2.0894584108097122e-07 0.00021 2.0895584108097123e-07 0 2.0897292880944017e-07 0 2.0898292880944019e-07 0.00021 2.089929288094402e-07 0 2.0899292880944017e-07 0 2.0900292880944018e-07 0.00021 2.090129288094402e-07 0 2.091506320254675e-07 0 2.0916063202546752e-07 0.00021 2.0917063202546753e-07 0 2.091706320254675e-07 0 2.0918063202546752e-07 0.00021 2.0919063202546753e-07 0 2.091906320254675e-07 0 2.092006320254675e-07 0.00021 2.0921063202546752e-07 0 2.092106320254675e-07 0 2.092206320254675e-07 0.00021 2.0923063202546752e-07 0 2.092306320254675e-07 0 2.092406320254675e-07 0.00021 2.0925063202546752e-07 0 2.092506320254675e-07 0 2.092606320254675e-07 0.00021 2.092706320254675e-07 0 2.0927063202546748e-07 0 2.092806320254675e-07 0.00021 2.092906320254675e-07 0 2.0929063202546748e-07 0 2.093006320254675e-07 0.00021 2.093106320254675e-07 0 2.0931063202546748e-07 0 2.093206320254675e-07 0.00021 2.093306320254675e-07 0 2.0933063202546747e-07 0 2.0934063202546748e-07 0.00021 2.093506320254675e-07 0 2.0935063202546747e-07 0 2.0936063202546748e-07 0.00021 2.093706320254675e-07 0 2.0937063202546747e-07 0 2.0938063202546748e-07 0.00021 2.093906320254675e-07 0 2.0939063202546746e-07 0 2.0940063202546747e-07 0.00021 2.0941063202546748e-07 0 2.0941063202546746e-07 0 2.0942063202546747e-07 0.00021 2.0943063202546748e-07 0 2.0943063202546745e-07 0 2.0944063202546747e-07 0.00021 2.0945063202546748e-07 0 2.094550361480895e-07 0 2.0946503614808952e-07 0.00021 2.0947503614808954e-07 0 2.094750361480895e-07 0 2.0948503614808952e-07 0.00021 2.0949503614808953e-07 0 2.094950361480895e-07 0 2.0950503614808952e-07 0.00021 2.0951503614808953e-07 0 2.0960023224801674e-07 0 2.0961023224801676e-07 0.00021 2.0962023224801677e-07 0 2.0962023224801674e-07 0 2.0963023224801675e-07 0.00021 2.0964023224801676e-07 0 2.0967008127197225e-07 0 2.0968008127197226e-07 0.00021 2.0969008127197227e-07 0 2.0969021831560838e-07 0 2.097002183156084e-07 0.00021 2.097102183156084e-07 0 2.0971021831560838e-07 0 2.097202183156084e-07 0.00021 2.097302183156084e-07 0 2.0973021831560838e-07 0 2.097402183156084e-07 0.00021 2.097502183156084e-07 0 2.0981781200506786e-07 0 2.0982781200506788e-07 0.00021 2.0983781200506789e-07 0 2.098472930906142e-07 0 2.098572930906142e-07 0.00021 2.0986729309061422e-07 0 2.098931387581767e-07 0 2.0990313875817672e-07 0.00021 2.0991313875817674e-07 0 2.099131387581767e-07 0 2.0992313875817672e-07 0.00021 2.0993313875817673e-07 0 2.099331387581767e-07 0 2.0994313875817672e-07 0.00021 2.0995313875817673e-07 0 2.099531387581767e-07 0 2.099631387581767e-07 0.00021 2.0997313875817672e-07 0 2.099731387581767e-07 0 2.099831387581767e-07 0.00021 2.0999313875817672e-07 0 2.099931387581767e-07 0 2.100031387581767e-07 0.00021 2.1001313875817672e-07 0 2.100131387581767e-07 0 2.100231387581767e-07 0.00021 2.100331387581767e-07 0 2.1003313875817669e-07 0 2.100431387581767e-07 0.00021 2.100531387581767e-07 0 2.1005313875817668e-07 0 2.100631387581767e-07 0.00021 2.100731387581767e-07 0 2.1007313875817668e-07 0 2.100831387581767e-07 0.00021 2.100931387581767e-07 0 2.1009313875817667e-07 0 2.1010313875817669e-07 0.00021 2.101131387581767e-07 0 2.1011313875817667e-07 0 2.1012313875817668e-07 0.00021 2.101331387581767e-07 0 2.1013313875817667e-07 0 2.1014313875817668e-07 0.00021 2.101531387581767e-07 0 2.1015313875817666e-07 0 2.1016313875817667e-07 0.00021 2.1017313875817669e-07 0 2.1017313875817666e-07 0 2.1018313875817667e-07 0.00021 2.1019313875817668e-07 0 2.1019313875817666e-07 0 2.1020313875817667e-07 0.00021 2.1021313875817668e-07 0 2.1021313875817665e-07 0 2.1022313875817666e-07 0.00021 2.1023313875817667e-07 0 2.1023313875817665e-07 0 2.1024313875817666e-07 0.00021 2.1025313875817667e-07 0 2.1025313875817664e-07 0 2.1026313875817666e-07 0.00021 2.1027313875817667e-07 0 2.1041595518926045e-07 0 2.1042595518926046e-07 0.00021 2.1043595518926047e-07 0 2.1043595518926045e-07 0 2.1044595518926046e-07 0.00021 2.1045595518926047e-07 0 2.1045595518926044e-07 0 2.1046595518926046e-07 0.00021 2.1047595518926047e-07 0 2.1048406519139127e-07 0 2.1049406519139128e-07 0.00021 2.105040651913913e-07 0 2.1050406519139126e-07 0 2.1051406519139128e-07 0.00021 2.105240651913913e-07 0 2.1052406519139126e-07 0 2.1053406519139127e-07 0.00021 2.1054406519139128e-07 0 2.1054406519139126e-07 0 2.1055406519139127e-07 0.00021 2.1056406519139128e-07 0 2.1056406519139125e-07 0 2.1057406519139126e-07 0.00021 2.1058406519139128e-07 0 2.1058406519139125e-07 0 2.1059406519139126e-07 0.00021 2.1060406519139127e-07 0 2.1060406519139125e-07 0 2.1061406519139126e-07 0.00021 2.1062406519139127e-07 0 2.1062406519139124e-07 0 2.1063406519139125e-07 0.00021 2.1064406519139126e-07 0 2.1064406519139124e-07 0 2.1065406519139125e-07 0.00021 2.1066406519139126e-07 0 2.1066406519139123e-07 0 2.1067406519139125e-07 0.00021 2.1068406519139126e-07 0 2.1068406519139123e-07 0 2.1069406519139124e-07 0.00021 2.1070406519139125e-07 0 2.1070406519139123e-07 0 2.1071406519139124e-07 0.00021 2.1072406519139125e-07 0 2.1077714372182078e-07 0 2.107871437218208e-07 0.00021 2.107971437218208e-07 0 2.1090298054452334e-07 0 2.1091298054452335e-07 0.00021 2.1092298054452336e-07 0 2.1092298054452333e-07 0 2.1093298054452334e-07 0.00021 2.1094298054452335e-07 0 2.1094298054452333e-07 0 2.1095298054452334e-07 0.00021 2.1096298054452335e-07 0 2.1096298054452332e-07 0 2.1097298054452334e-07 0.00021 2.1098298054452335e-07 0 2.1098298054452332e-07 0 2.1099298054452333e-07 0.00021 2.1100298054452334e-07 0 2.1100298054452332e-07 0 2.1101298054452333e-07 0.00021 2.1102298054452334e-07 0 2.110229805445233e-07 0 2.1103298054452332e-07 0.00021 2.1104298054452334e-07 0 2.110429805445233e-07 0 2.1105298054452332e-07 0.00021 2.1106298054452333e-07 0 2.110629805445233e-07 0 2.1107298054452332e-07 0.00021 2.1108298054452333e-07 0 2.110829805445233e-07 0 2.110929805445233e-07 0.00021 2.1110298054452332e-07 0 2.111029805445233e-07 0 2.111129805445233e-07 0.00021 2.1112298054452332e-07 0 2.111229805445233e-07 0 2.111329805445233e-07 0.00021 2.1114298054452332e-07 0 2.111741253721705e-07 0 2.111841253721705e-07 0.00021 2.111941253721705e-07 0 2.1119412537217048e-07 0 2.112041253721705e-07 0.00021 2.112141253721705e-07 0 2.1130381680909735e-07 0 2.1131381680909736e-07 0.00021 2.1132381680909737e-07 0 2.113418812152702e-07 0 2.113518812152702e-07 0.00021 2.1136188121527022e-07 0 2.113618812152702e-07 0 2.113718812152702e-07 0.00021 2.1138188121527022e-07 0 2.113818812152702e-07 0 2.113918812152702e-07 0.00021 2.1140188121527022e-07 0 2.1146326588981934e-07 0 2.1147326588981935e-07 0.00021 2.1148326588981936e-07 0 2.1148326588981933e-07 0 2.1149326588981934e-07 0.00021 2.1150326588981935e-07 0 2.115035610017743e-07 0 2.1151356100177432e-07 0.00021 2.1152356100177433e-07 0 2.1153823169515228e-07 0 2.115482316951523e-07 0.00021 2.115582316951523e-07 0 2.1155823169515228e-07 0 2.1156823169515229e-07 0.00021 2.115782316951523e-07 0 2.1157823169515227e-07 0 2.1158823169515228e-07 0.00021 2.115982316951523e-07 0 2.1159823169515227e-07 0 2.1160823169515228e-07 0.00021 2.116182316951523e-07 0 2.1161823169515226e-07 0 2.1162823169515228e-07 0.00021 2.1163823169515229e-07 0 2.1163823169515226e-07 0 2.1164823169515227e-07 0.00021 2.1165823169515228e-07 0 2.1165823169515226e-07 0 2.1166823169515227e-07 0.00021 2.1167823169515228e-07 0 2.1167823169515225e-07 0 2.1168823169515226e-07 0.00021 2.1169823169515228e-07 0 2.1169823169515225e-07 0 2.1170823169515226e-07 0.00021 2.1171823169515227e-07 0 2.1171823169515224e-07 0 2.1172823169515226e-07 0.00021 2.1173823169515227e-07 0 2.1173823169515224e-07 0 2.1174823169515225e-07 0.00021 2.1175823169515226e-07 0 2.1175823169515224e-07 0 2.1176823169515225e-07 0.00021 2.1177823169515226e-07 0 2.1178683408151175e-07 0 2.1179683408151176e-07 0.00021 2.1180683408151177e-07 0 2.1180910865835758e-07 0 2.118191086583576e-07 0.00021 2.118291086583576e-07 0 2.1188659829614238e-07 0 2.118965982961424e-07 0.00021 2.119065982961424e-07 0 2.119755774628776e-07 0 2.1198557746287762e-07 0.00021 2.1199557746287763e-07 0 2.119955774628776e-07 0 2.1200557746287762e-07 0.00021 2.1201557746287763e-07 0 2.120155774628776e-07 0 2.1202557746287761e-07 0.00021 2.1203557746287763e-07 0 2.120355774628776e-07 0 2.120455774628776e-07 0.00021 2.1205557746287762e-07 0 2.120555774628776e-07 0 2.120655774628776e-07 0.00021 2.1207557746287762e-07 0 2.120755774628776e-07 0 2.120855774628776e-07 0.00021 2.1209557746287761e-07 0 2.120955774628776e-07 0 2.121055774628776e-07 0.00021 2.121155774628776e-07 0 2.1211557746287758e-07 0 2.121255774628776e-07 0.00021 2.121355774628776e-07 0 2.1213557746287758e-07 0 2.121455774628776e-07 0.00021 2.121555774628776e-07 0 2.1215557746287758e-07 0 2.121655774628776e-07 0.00021 2.121755774628776e-07 0 2.1217557746287757e-07 0 2.1218557746287758e-07 0.00021 2.121955774628776e-07 0 2.1219557746287757e-07 0 2.1220557746287758e-07 0.00021 2.122155774628776e-07 0 2.1221557746287757e-07 0 2.1222557746287758e-07 0.00021 2.122355774628776e-07 0 2.1223557746287756e-07 0 2.1224557746287757e-07 0.00021 2.1225557746287758e-07 0 2.1225557746287756e-07 0 2.1226557746287757e-07 0.00021 2.1227557746287758e-07 0 2.1230084112426928e-07 0 2.123108411242693e-07 0.00021 2.123208411242693e-07 0 2.1232084112426928e-07 0 2.123308411242693e-07 0.00021 2.123408411242693e-07 0 2.1234778269010876e-07 0 2.1235778269010877e-07 0.00021 2.1236778269010878e-07 0 2.1236778269010875e-07 0 2.1237778269010877e-07 0.00021 2.1238778269010878e-07 0 2.1238778269010875e-07 0 2.1239778269010876e-07 0.00021 2.1240778269010877e-07 0 2.124313809413315e-07 0 2.124413809413315e-07 0.00021 2.1245138094133151e-07 0 2.124513809413315e-07 0 2.124613809413315e-07 0.00021 2.124713809413315e-07 0 2.1247138094133148e-07 0 2.124813809413315e-07 0.00021 2.124913809413315e-07 0 2.1252462482815212e-07 0 2.1253462482815214e-07 0.00021 2.1254462482815215e-07 0 2.1258384563723608e-07 0 2.125938456372361e-07 0.00021 2.126038456372361e-07 0 2.1260384563723608e-07 0 2.126138456372361e-07 0.00021 2.126238456372361e-07 0 2.12664134705538e-07 0 2.1267413470553802e-07 0.00021 2.1268413470553804e-07 0 2.12684134705538e-07 0 2.1269413470553802e-07 0.00021 2.1270413470553803e-07 0 2.12704134705538e-07 0 2.1271413470553802e-07 0.00021 2.1272413470553803e-07 0 2.12724134705538e-07 0 2.12734134705538e-07 0.00021 2.1274413470553802e-07 0 2.12744134705538e-07 0 2.12754134705538e-07 0.00021 2.1276413470553802e-07 0 2.12764134705538e-07 0 2.12774134705538e-07 0.00021 2.1278413470553802e-07 0 2.12784134705538e-07 0 2.12794134705538e-07 0.00021 2.12804134705538e-07 0 2.1280413470553799e-07 0 2.12814134705538e-07 0.00021 2.12824134705538e-07 0 2.1282413470553798e-07 0 2.12834134705538e-07 0.00021 2.12844134705538e-07 0 2.1299410262899386e-07 0 2.1300410262899387e-07 0.00021 2.1301410262899389e-07 0 2.1301410262899386e-07 0 2.1302410262899387e-07 0.00021 2.1303410262899388e-07 0 2.1303410262899386e-07 0 2.1304410262899387e-07 0.00021 2.1305410262899388e-07 0 2.1307179802258235e-07 0 2.1308179802258236e-07 0.00021 2.1309179802258237e-07 0 2.1309179802258234e-07 0 2.1310179802258235e-07 0.00021 2.1311179802258237e-07 0 2.1319070958014226e-07 0 2.1320070958014227e-07 0.00021 2.1321070958014228e-07 0 2.1321070958014225e-07 0 2.1322070958014227e-07 0.00021 2.1323070958014228e-07 0 2.1323070958014225e-07 0 2.1324070958014226e-07 0.00021 2.1325070958014227e-07 0 2.1325070958014225e-07 0 2.1326070958014226e-07 0.00021 2.1327070958014227e-07 0 2.1327070958014224e-07 0 2.1328070958014225e-07 0.00021 2.1329070958014227e-07 0 2.1329070958014224e-07 0 2.1330070958014225e-07 0.00021 2.1331070958014226e-07 0 2.1331592289914473e-07 0 2.1332592289914474e-07 0.00021 2.1333592289914475e-07 0 2.1333592289914472e-07 0 2.1334592289914474e-07 0.00021 2.1335592289914475e-07 0 2.1336680966597751e-07 0 2.1337680966597752e-07 0.00021 2.1338680966597754e-07 0 2.1341825954552305e-07 0 2.1342825954552306e-07 0.00021 2.1343825954552307e-07 0 2.1343825954552304e-07 0 2.1344825954552305e-07 0.00021 2.1345825954552306e-07 0 2.13509585902625e-07 0 2.1351958590262502e-07 0.00021 2.1352958590262503e-07 0 2.13529585902625e-07 0 2.13539585902625e-07 0.00021 2.1354958590262502e-07 0 2.13549585902625e-07 0 2.13559585902625e-07 0.00021 2.1356958590262502e-07 0 2.13569585902625e-07 0 2.13579585902625e-07 0.00021 2.1358958590262502e-07 0 2.13589585902625e-07 0 2.13599585902625e-07 0.00021 2.13609585902625e-07 0 2.1360958590262499e-07 0 2.13619585902625e-07 0.00021 2.13629585902625e-07 0 2.1362958590262498e-07 0 2.13639585902625e-07 0.00021 2.13649585902625e-07 0 2.1364958590262498e-07 0 2.13659585902625e-07 0.00021 2.13669585902625e-07 0 2.1366958590262497e-07 0 2.1367958590262499e-07 0.00021 2.13689585902625e-07 0 2.1368958590262497e-07 0 2.1369958590262498e-07 0.00021 2.13709585902625e-07 0 2.1372510625473937e-07 0 2.1373510625473938e-07 0.00021 2.137451062547394e-07 0 2.1384847570122742e-07 0 2.1385847570122743e-07 0.00021 2.1386847570122744e-07 0 2.1386847570122742e-07 0 2.1387847570122743e-07 0.00021 2.1388847570122744e-07 0 2.1388847570122741e-07 0 2.1389847570122743e-07 0.00021 2.1390847570122744e-07 0 2.139084757012274e-07 0 2.1391847570122742e-07 0.00021 2.1392847570122743e-07 0 2.139284757012274e-07 0 2.1393847570122742e-07 0.00021 2.1394847570122743e-07 0 2.139484757012274e-07 0 2.1395847570122741e-07 0.00021 2.1396847570122743e-07 0 2.1397717780799136e-07 0 2.1398717780799137e-07 0.00021 2.1399717780799139e-07 0 2.1405856522308734e-07 0 2.1406856522308735e-07 0.00021 2.1407856522308736e-07 0 2.141158223487388e-07 0 2.141258223487388e-07 0.00021 2.141358223487388e-07 0 2.1413582234873879e-07 0 2.141458223487388e-07 0.00021 2.141558223487388e-07 0 2.1415582234873878e-07 0 2.141658223487388e-07 0.00021 2.141758223487388e-07 0 2.1417582234873878e-07 0 2.141858223487388e-07 0.00021 2.141958223487388e-07 0 2.1419582234873877e-07 0 2.1420582234873879e-07 0.00021 2.142158223487388e-07 0 2.1421582234873877e-07 0 2.1422582234873878e-07 0.00021 2.142358223487388e-07 0 2.1423582234873877e-07 0 2.1424582234873878e-07 0.00021 2.142558223487388e-07 0 2.1425582234873876e-07 0 2.1426582234873877e-07 0.00021 2.1427582234873879e-07 0 2.1427582234873876e-07 0 2.1428582234873877e-07 0.00021 2.1429582234873878e-07 0 2.1429582234873876e-07 0 2.1430582234873877e-07 0.00021 2.1431582234873878e-07 0 2.1431582234873875e-07 0 2.1432582234873876e-07 0.00021 2.1433582234873877e-07 0 2.1433582234873875e-07 0 2.1434582234873876e-07 0.00021 2.1435582234873877e-07 0 2.1435582234873874e-07 0 2.1436582234873876e-07 0.00021 2.1437582234873877e-07 0 2.1437582234873874e-07 0 2.1438582234873875e-07 0.00021 2.1439582234873876e-07 0 2.1439582234873874e-07 0 2.1440582234873875e-07 0.00021 2.1441582234873876e-07 0 2.1441582234873873e-07 0 2.1442582234873874e-07 0.00021 2.1443582234873876e-07 0 2.1447088990845394e-07 0 2.1448088990845395e-07 0.00021 2.1449088990845396e-07 0 2.1450663701355346e-07 0 2.1451663701355347e-07 0.00021 2.1452663701355349e-07 0 2.1455272005774456e-07 0 2.1456272005774457e-07 0.00021 2.1457272005774458e-07 0 2.145796531720974e-07 0 2.145896531720974e-07 0.00021 2.1459965317209742e-07 0 2.145996531720974e-07 0 2.146096531720974e-07 0.00021 2.146196531720974e-07 0 2.1461965317209739e-07 0 2.146296531720974e-07 0.00021 2.146396531720974e-07 0 2.1463965317209738e-07 0 2.146496531720974e-07 0.00021 2.146596531720974e-07 0 2.1465965317209738e-07 0 2.146696531720974e-07 0.00021 2.146796531720974e-07 0 2.1474604565904445e-07 0 2.1475604565904447e-07 0.00021 2.1476604565904448e-07 0 2.1476604565904445e-07 0 2.1477604565904446e-07 0.00021 2.1478604565904447e-07 0 2.1478604565904445e-07 0 2.1479604565904446e-07 0.00021 2.1480604565904447e-07 0 2.1480604565904444e-07 0 2.1481604565904445e-07 0.00021 2.1482604565904447e-07 0 2.1482604565904444e-07 0 2.1483604565904445e-07 0.00021 2.1484604565904446e-07 0 2.1496434250189245e-07 0 2.1497434250189246e-07 0.00021 2.1498434250189247e-07 0 2.149890694682323e-07 0 2.149990694682323e-07 0.00021 2.1500906946823232e-07 0 2.1501311291836586e-07 0 2.1502311291836587e-07 0.00021 2.1503311291836588e-07 0 2.1503923142634703e-07 0 2.1504923142634705e-07 0.00021 2.1505923142634706e-07 0 2.1510459195802962e-07 0 2.1511459195802963e-07 0.00021 2.1512459195802964e-07 0 2.1517437930227614e-07 0 2.1518437930227615e-07 0.00021 2.1519437930227616e-07 0 2.1520515171709372e-07 0 2.1521515171709373e-07 0.00021 2.1522515171709374e-07 0 2.1522515171709371e-07 0 2.1523515171709373e-07 0.00021 2.1524515171709374e-07 0 2.153109872202303e-07 0 2.1532098722023032e-07 0.00021 2.1533098722023033e-07 0 2.153361998713983e-07 0 2.153461998713983e-07 0.00021 2.1535619987139832e-07 0 2.153561998713983e-07 0 2.153661998713983e-07 0.00021 2.1537619987139832e-07 0 2.1541470219183084e-07 0 2.1542470219183085e-07 0.00021 2.1543470219183086e-07 0 2.1544977518346463e-07 0 2.1545977518346464e-07 0.00021 2.1546977518346465e-07 0 2.1546977518346462e-07 0 2.1547977518346464e-07 0.00021 2.1548977518346465e-07 0 2.1548977518346462e-07 0 2.1549977518346463e-07 0.00021 2.1550977518346464e-07 0 2.1550977518346462e-07 0 2.1551977518346463e-07 0.00021 2.1552977518346464e-07 0 2.155297751834646e-07 0 2.1553977518346462e-07 0.00021 2.1554977518346464e-07 0 2.155497751834646e-07 0 2.1555977518346462e-07 0.00021 2.1556977518346463e-07 0 2.155697751834646e-07 0 2.1557977518346462e-07 0.00021 2.1558977518346463e-07 0 2.155897751834646e-07 0 2.155997751834646e-07 0.00021 2.1560977518346462e-07 0 2.156097751834646e-07 0 2.156197751834646e-07 0.00021 2.1562977518346462e-07 0 2.156297751834646e-07 0 2.156397751834646e-07 0.00021 2.1564977518346462e-07 0 2.156497751834646e-07 0 2.156597751834646e-07 0.00021 2.156697751834646e-07 0 2.1566977518346459e-07 0 2.156797751834646e-07 0.00021 2.156897751834646e-07 0 2.1568977518346458e-07 0 2.156997751834646e-07 0.00021 2.157097751834646e-07 0 2.1570977518346458e-07 0 2.157197751834646e-07 0.00021 2.157297751834646e-07 0 2.1572977518346457e-07 0 2.1573977518346459e-07 0.00021 2.157497751834646e-07 0 2.1577826539576553e-07 0 2.1578826539576554e-07 0.00021 2.1579826539576555e-07 0 2.158077172609038e-07 0 2.1581771726090382e-07 0.00021 2.1582771726090383e-07 0 2.158277172609038e-07 0 2.158377172609038e-07 0.00021 2.1584771726090382e-07 0 2.1584891726870144e-07 0 2.1585891726870145e-07 0.00021 2.1586891726870146e-07 0 2.1586891726870143e-07 0 2.1587891726870144e-07 0.00021 2.1588891726870145e-07 0 2.1588891726870143e-07 0 2.1589891726870144e-07 0.00021 2.1590891726870145e-07 0 2.1590891726870142e-07 0 2.1591891726870144e-07 0.00021 2.1592891726870145e-07 0 2.1592891726870142e-07 0 2.1593891726870143e-07 0.00021 2.1594891726870144e-07 0 2.1594891726870142e-07 0 2.1595891726870143e-07 0.00021 2.1596891726870144e-07 0 2.159689172687014e-07 0 2.1597891726870142e-07 0.00021 2.1598891726870144e-07 0 2.159889172687014e-07 0 2.1599891726870142e-07 0.00021 2.1600891726870143e-07 0 2.1607907041532106e-07 0 2.1608907041532107e-07 0.00021 2.1609907041532108e-07 0 2.161512426966838e-07 0 2.161612426966838e-07 0.00021 2.1617124269668382e-07 0 2.161712426966838e-07 0 2.161812426966838e-07 0.00021 2.1619124269668382e-07 0 2.161912426966838e-07 0 2.162012426966838e-07 0.00021 2.162112426966838e-07 0 2.1621124269668379e-07 0 2.162212426966838e-07 0.00021 2.162312426966838e-07 0 2.1623124269668378e-07 0 2.162412426966838e-07 0.00021 2.162512426966838e-07 0 2.1625124269668378e-07 0 2.162612426966838e-07 0.00021 2.162712426966838e-07 0 2.1627124269668377e-07 0 2.1628124269668379e-07 0.00021 2.162912426966838e-07 0 2.1629124269668377e-07 0 2.1630124269668378e-07 0.00021 2.163112426966838e-07 0 2.1631124269668377e-07 0 2.1632124269668378e-07 0.00021 2.163312426966838e-07 0 2.1633124269668376e-07 0 2.1634124269668377e-07 0.00021 2.1635124269668379e-07 0 2.1635124269668376e-07 0 2.1636124269668377e-07 0.00021 2.1637124269668378e-07 0 2.1637124269668376e-07 0 2.1638124269668377e-07 0.00021 2.1639124269668378e-07 0 2.164466857129271e-07 0 2.164566857129271e-07 0.00021 2.1646668571292712e-07 0 2.164666857129271e-07 0 2.164766857129271e-07 0.00021 2.164866857129271e-07 0 2.1648668571292708e-07 0 2.164966857129271e-07 0.00021 2.165066857129271e-07 0 2.1650668571292708e-07 0 2.165166857129271e-07 0.00021 2.165266857129271e-07 0 2.1652668571292708e-07 0 2.165366857129271e-07 0.00021 2.165466857129271e-07 0 2.1654668571292707e-07 0 2.1655668571292708e-07 0.00021 2.165666857129271e-07 0 2.1656668571292707e-07 0 2.1657668571292708e-07 0.00021 2.165866857129271e-07 0 2.1658668571292707e-07 0 2.1659668571292708e-07 0.00021 2.166066857129271e-07 0 2.1660668571292706e-07 0 2.1661668571292707e-07 0.00021 2.1662668571292708e-07 0 2.1662668571292706e-07 0 2.1663668571292707e-07 0.00021 2.1664668571292708e-07 0 2.1664668571292705e-07 0 2.1665668571292707e-07 0.00021 2.1666668571292708e-07 0 2.1666668571292705e-07 0 2.1667668571292706e-07 0.00021 2.1668668571292707e-07 0 2.1668668571292705e-07 0 2.1669668571292706e-07 0.00021 2.1670668571292707e-07 0 2.1670668571292704e-07 0 2.1671668571292705e-07 0.00021 2.1672668571292707e-07 0 2.1672668571292704e-07 0 2.1673668571292705e-07 0.00021 2.1674668571292706e-07 0 2.1674668571292704e-07 0 2.1675668571292705e-07 0.00021 2.1676668571292706e-07 0 2.1676668571292703e-07 0 2.1677668571292704e-07 0.00021 2.1678668571292705e-07 0 2.167874175008937e-07 0 2.167974175008937e-07 0.00021 2.1680741750089372e-07 0 2.1681613081520166e-07 0 2.1682613081520167e-07 0.00021 2.1683613081520168e-07 0 2.1683613081520165e-07 0 2.1684613081520166e-07 0.00021 2.1685613081520168e-07 0 2.1685613081520165e-07 0 2.1686613081520166e-07 0.00021 2.1687613081520167e-07 0 2.1687613081520165e-07 0 2.1688613081520166e-07 0.00021 2.1689613081520167e-07 0 2.1689613081520164e-07 0 2.1690613081520165e-07 0.00021 2.1691613081520166e-07 0 2.1691613081520164e-07 0 2.1692613081520165e-07 0.00021 2.1693613081520166e-07 0 2.1696360427384644e-07 0 2.1697360427384645e-07 0.00021 2.1698360427384647e-07 0 2.1704785906621007e-07 0 2.1705785906621008e-07 0.00021 2.170678590662101e-07 0 2.1706785906621006e-07 0 2.1707785906621008e-07 0.00021 2.1708785906621009e-07 0 2.1708785906621006e-07 0 2.1709785906621007e-07 0.00021 2.1710785906621008e-07 0 2.1710785906621006e-07 0 2.1711785906621007e-07 0.00021 2.1712785906621008e-07 0 2.1712785906621005e-07 0 2.1713785906621006e-07 0.00021 2.1714785906621008e-07 0 2.1715520328027482e-07 0 2.1716520328027483e-07 0.00021 2.1717520328027484e-07 0 2.1717520328027482e-07 0 2.1718520328027483e-07 0.00021 2.1719520328027484e-07 0 2.1719520328027481e-07 0 2.1720520328027482e-07 0.00021 2.1721520328027484e-07 0 2.172152032802748e-07 0 2.1722520328027482e-07 0.00021 2.1723520328027483e-07 0 2.172486927490229e-07 0 2.1725869274902292e-07 0.00021 2.1726869274902293e-07 0 2.1747705540472854e-07 0 2.1748705540472855e-07 0.00021 2.1749705540472856e-07 0 2.1749705540472853e-07 0 2.1750705540472855e-07 0.00021 2.1751705540472856e-07 0 2.1751705540472853e-07 0 2.1752705540472854e-07 0.00021 2.1753705540472855e-07 0 2.1755660124880153e-07 0 2.1756660124880154e-07 0.00021 2.1757660124880155e-07 0 2.1757660124880153e-07 0 2.1758660124880154e-07 0.00021 2.1759660124880155e-07 0 2.1759702354613102e-07 0 2.1760702354613103e-07 0.00021 2.1761702354613104e-07 0 2.1761702354613102e-07 0 2.1762702354613103e-07 0.00021 2.1763702354613104e-07 0 2.1763702354613101e-07 0 2.1764702354613102e-07 0.00021 2.1765702354613104e-07 0 2.17657023546131e-07 0 2.1766702354613102e-07 0.00021 2.1767702354613103e-07 0 2.17677023546131e-07 0 2.1768702354613102e-07 0.00021 2.1769702354613103e-07 0 2.17697023546131e-07 0 2.1770702354613101e-07 0.00021 2.1771702354613102e-07 0 2.1773392223139502e-07 0 2.1774392223139503e-07 0.00021 2.1775392223139504e-07 0 2.1775392223139502e-07 0 2.1776392223139503e-07 0.00021 2.1777392223139504e-07 0 2.17773922231395e-07 0 2.1778392223139502e-07 0.00021 2.1779392223139503e-07 0 2.17793922231395e-07 0 2.1780392223139502e-07 0.00021 2.1781392223139503e-07 0 2.17813922231395e-07 0 2.1782392223139502e-07 0.00021 2.1783392223139503e-07 0 2.17833922231395e-07 0 2.17843922231395e-07 0.00021 2.1785392223139502e-07 0 2.1786465885380837e-07 0 2.1787465885380838e-07 0.00021 2.178846588538084e-07 0 2.1797682569982986e-07 0 2.1798682569982988e-07 0.00021 2.179968256998299e-07 0 2.1800212033637288e-07 0 2.180121203363729e-07 0.00021 2.180221203363729e-07 0 2.1803129775731325e-07 0 2.1804129775731326e-07 0.00021 2.1805129775731328e-07 0 2.1805129775731325e-07 0 2.1806129775731326e-07 0.00021 2.1807129775731327e-07 0 2.1807129775731325e-07 0 2.1808129775731326e-07 0.00021 2.1809129775731327e-07 0 2.1809129775731324e-07 0 2.1810129775731325e-07 0.00021 2.1811129775731326e-07 0 2.1811129775731324e-07 0 2.1812129775731325e-07 0.00021 2.1813129775731326e-07 0 2.1813129775731323e-07 0 2.1814129775731325e-07 0.00021 2.1815129775731326e-07 0 2.1815129775731323e-07 0 2.1816129775731324e-07 0.00021 2.1817129775731325e-07 0 2.1817129775731323e-07 0 2.1818129775731324e-07 0.00021 2.1819129775731325e-07 0 2.182367225988949e-07 0 2.1824672259889492e-07 0.00021 2.1825672259889493e-07 0 2.183413503653453e-07 0 2.1835135036534531e-07 0.00021 2.1836135036534533e-07 0 2.183613503653453e-07 0 2.183713503653453e-07 0.00021 2.1838135036534532e-07 0 2.1847966226512372e-07 0 2.1848966226512373e-07 0.00021 2.1849966226512374e-07 0 2.1859349907587564e-07 0 2.1860349907587565e-07 0.00021 2.1861349907587566e-07 0 2.1866491004862414e-07 0 2.1867491004862415e-07 0.00021 2.1868491004862416e-07 0 2.1868593950048932e-07 0 2.1869593950048933e-07 0.00021 2.1870593950048934e-07 0 2.1871744891923316e-07 0 2.1872744891923317e-07 0.00021 2.1873744891923318e-07 0 2.1874601902798148e-07 0 2.187560190279815e-07 0.00021 2.187660190279815e-07 0 2.1877014155609542e-07 0 2.1878014155609543e-07 0.00021 2.1879014155609544e-07 0 2.1879669438478322e-07 0 2.1880669438478323e-07 0.00021 2.1881669438478324e-07 0 2.1881669438478321e-07 0 2.1882669438478323e-07 0.00021 2.1883669438478324e-07 0 2.188366943847832e-07 0 2.1884669438478322e-07 0.00021 2.1885669438478323e-07 0 2.188566943847832e-07 0 2.1886669438478322e-07 0.00021 2.1887669438478323e-07 0 2.188776066292595e-07 0 2.188876066292595e-07 0.00021 2.188976066292595e-07 0 2.189650816539981e-07 0 2.189750816539981e-07 0.00021 2.189850816539981e-07 0 2.1898508165399808e-07 0 2.189950816539981e-07 0.00021 2.190050816539981e-07 0 2.1900508165399808e-07 0 2.190150816539981e-07 0.00021 2.190250816539981e-07 0 2.1902508165399808e-07 0 2.190350816539981e-07 0.00021 2.190450816539981e-07 0 2.1904508165399807e-07 0 2.1905508165399808e-07 0.00021 2.190650816539981e-07 0 2.1906508165399807e-07 0 2.1907508165399808e-07 0.00021 2.190850816539981e-07 0 2.1908508165399806e-07 0 2.1909508165399808e-07 0.00021 2.191050816539981e-07 0 2.1910508165399806e-07 0 2.1911508165399807e-07 0.00021 2.1912508165399808e-07 0 2.1914683904763342e-07 0 2.1915683904763343e-07 0.00021 2.1916683904763345e-07 0 2.1921397684402575e-07 0 2.1922397684402577e-07 0.00021 2.1923397684402578e-07 0 2.1923397684402575e-07 0 2.1924397684402576e-07 0.00021 2.1925397684402577e-07 0 2.1932959589908292e-07 0 2.1933959589908293e-07 0.00021 2.1934959589908294e-07 0 2.1935757991331513e-07 0 2.1936757991331515e-07 0.00021 2.1937757991331516e-07 0 2.194128055325462e-07 0 2.194228055325462e-07 0.00021 2.1943280553254622e-07 0 2.1944913282487072e-07 0 2.1945913282487074e-07 0.00021 2.1946913282487075e-07 0 2.1951860010017287e-07 0 2.1952860010017288e-07 0.00021 2.195386001001729e-07 0 2.1953860010017287e-07 0 2.1954860010017288e-07 0.00021 2.195586001001729e-07 0 2.1957884009994754e-07 0 2.1958884009994756e-07 0.00021 2.1959884009994757e-07 0 2.1967776775190405e-07 0 2.1968776775190406e-07 0.00021 2.1969776775190407e-07 0 2.1975544117205297e-07 0 2.1976544117205298e-07 0.00021 2.19775441172053e-07 0 2.1982710786724055e-07 0 2.1983710786724056e-07 0.00021 2.1984710786724057e-07 0 2.1989718006014616e-07 0 2.1990718006014617e-07 0.00021 2.1991718006014618e-07 0 2.1992565749688168e-07 0 2.199356574968817e-07 0.00021 2.199456574968817e-07 0 2.1994565749688168e-07 0 2.199556574968817e-07 0.00021 2.199656574968817e-07 0 2.1996565749688168e-07 0 2.199756574968817e-07 0.00021 2.199856574968817e-07 0 2.1998565749688167e-07 0 2.1999565749688168e-07 0.00021 2.200056574968817e-07 0 2.200078646286171e-07 0 2.200178646286171e-07 0.00021 2.200278646286171e-07 0 2.201298070592401e-07 0 2.201398070592401e-07 0.00021 2.2014980705924012e-07 0 2.2028279635064863e-07 0 2.2029279635064864e-07 0.00021 2.2030279635064865e-07 0 2.2034401947163445e-07 0 2.2035401947163446e-07 0.00021 2.2036401947163447e-07 0 2.2036401947163445e-07 0 2.2037401947163446e-07 0.00021 2.2038401947163447e-07 0 2.2038401947163444e-07 0 2.2039401947163445e-07 0.00021 2.2040401947163447e-07 0 2.2040445827157423e-07 0 2.2041445827157425e-07 0.00021 2.2042445827157426e-07 0 2.2042445827157423e-07 0 2.2043445827157424e-07 0.00021 2.2044445827157425e-07 0 2.2048667697358118e-07 0 2.2049667697358119e-07 0.00021 2.205066769735812e-07 0 2.2052766703512562e-07 0 2.2053766703512563e-07 0.00021 2.2054766703512564e-07 0 2.2055155278885588e-07 0 2.205615527888559e-07 0.00021 2.205715527888559e-07 0 2.205973520287543e-07 0 2.2060735202875432e-07 0.00021 2.2061735202875434e-07 0 2.206173520287543e-07 0 2.2062735202875432e-07 0.00021 2.2063735202875433e-07 0 2.207530714086641e-07 0 2.2076307140866412e-07 0.00021 2.2077307140866413e-07 0 2.2081608103433066e-07 0 2.2082608103433067e-07 0.00021 2.2083608103433068e-07 0 2.2083608103433065e-07 0 2.2084608103433066e-07 0.00021 2.2085608103433067e-07 0 2.2085653368396712e-07 0 2.2086653368396713e-07 0.00021 2.2087653368396714e-07 0 2.2091877547139866e-07 0 2.2092877547139867e-07 0.00021 2.2093877547139869e-07 0 2.2094845092786344e-07 0 2.2095845092786345e-07 0.00021 2.2096845092786346e-07 0 2.210866405327031e-07 0 2.210966405327031e-07 0.00021 2.211066405327031e-07 0 2.2110664053270308e-07 0 2.211166405327031e-07 0.00021 2.211266405327031e-07 0 2.2112664053270308e-07 0 2.211366405327031e-07 0.00021 2.211466405327031e-07 0 2.2116354147717327e-07 0 2.2117354147717328e-07 0.00021 2.211835414771733e-07 0 2.2121475914235896e-07 0 2.2122475914235897e-07 0.00021 2.2123475914235898e-07 0 2.2123475914235896e-07 0 2.2124475914235897e-07 0.00021 2.2125475914235898e-07 0 2.2125475914235895e-07 0 2.2126475914235896e-07 0.00021 2.2127475914235897e-07 0 2.2129832040479762e-07 0 2.2130832040479764e-07 0.00021 2.2131832040479765e-07 0 2.2131832040479762e-07 0 2.2132832040479763e-07 0.00021 2.2133832040479764e-07 0 2.2135127894677008e-07 0 2.213612789467701e-07 0.00021 2.213712789467701e-07 0 2.214191365870485e-07 0 2.214291365870485e-07 0.00021 2.214391365870485e-07 0 2.2143913658704848e-07 0 2.214491365870485e-07 0.00021 2.214591365870485e-07 0 2.2148266828006082e-07 0 2.2149266828006083e-07 0.00021 2.2150266828006084e-07 0 2.215026682800608e-07 0 2.2151266828006082e-07 0.00021 2.2152266828006083e-07 0 2.215892669886315e-07 0 2.215992669886315e-07 0.00021 2.2160926698863152e-07 0 2.2162475587661312e-07 0 2.2163475587661313e-07 0.00021 2.2164475587661315e-07 0 2.216544435108694e-07 0 2.216644435108694e-07 0.00021 2.2167444351086942e-07 0 2.216744435108694e-07 0 2.216844435108694e-07 0.00021 2.216944435108694e-07 0 2.2169444351086939e-07 0 2.217044435108694e-07 0.00021 2.217144435108694e-07 0 2.2171444351086938e-07 0 2.217244435108694e-07 0.00021 2.217344435108694e-07 0 2.2177964611285968e-07 0 2.217896461128597e-07 0.00021 2.217996461128597e-07 0 2.2179964611285968e-07 0 2.218096461128597e-07 0.00021 2.218196461128597e-07 0 2.2181964611285967e-07 0 2.2182964611285968e-07 0.00021 2.218396461128597e-07 0 2.2184525744691482e-07 0 2.2185525744691484e-07 0.00021 2.2186525744691485e-07 0 2.2186525744691482e-07 0 2.2187525744691483e-07 0.00021 2.2188525744691484e-07 0 2.2189299768453664e-07 0 2.2190299768453665e-07 0.00021 2.2191299768453666e-07 0 2.2191299768453664e-07 0 2.2192299768453665e-07 0.00021 2.2193299768453666e-07 0 2.2193299768453663e-07 0 2.2194299768453664e-07 0.00021 2.2195299768453666e-07 0 2.2195299768453663e-07 0 2.2196299768453664e-07 0.00021 2.2197299768453665e-07 0 2.2197299768453663e-07 0 2.2198299768453664e-07 0.00021 2.2199299768453665e-07 0 2.2199299768453662e-07 0 2.2200299768453663e-07 0.00021 2.2201299768453664e-07 0 2.2201299768453662e-07 0 2.2202299768453663e-07 0.00021 2.2203299768453664e-07 0 2.2203299768453661e-07 0 2.2204299768453663e-07 0.00021 2.2205299768453664e-07 0 2.220529976845366e-07 0 2.2206299768453662e-07 0.00021 2.2207299768453663e-07 0 2.220729976845366e-07 0 2.2208299768453662e-07 0.00021 2.2209299768453663e-07 0 2.2211729060551023e-07 0 2.2212729060551024e-07 0.00021 2.2213729060551026e-07 0 2.2213729060551023e-07 0 2.2214729060551024e-07 0.00021 2.2215729060551025e-07 0 2.2215729060551023e-07 0 2.2216729060551024e-07 0.00021 2.2217729060551025e-07 0 2.2217729060551022e-07 0 2.2218729060551023e-07 0.00021 2.2219729060551024e-07 0 2.2219729060551022e-07 0 2.2220729060551023e-07 0.00021 2.2221729060551024e-07 0 2.2221762240170743e-07 0 2.2222762240170744e-07 0.00021 2.2223762240170745e-07 0 2.2224808527311186e-07 0 2.2225808527311187e-07 0.00021 2.2226808527311188e-07 0 2.2226808527311186e-07 0 2.2227808527311187e-07 0.00021 2.2228808527311188e-07 0 2.2228808527311185e-07 0 2.2229808527311186e-07 0.00021 2.2230808527311188e-07 0 2.223559400022087e-07 0 2.223659400022087e-07 0.00021 2.2237594000220872e-07 0 2.2240392726840003e-07 0 2.2241392726840004e-07 0.00021 2.2242392726840005e-07 0 2.2242392726840003e-07 0 2.2243392726840004e-07 0.00021 2.2244392726840005e-07 0 2.2244392726840002e-07 0 2.2245392726840003e-07 0.00021 2.2246392726840004e-07 0 2.2246392726840002e-07 0 2.2247392726840003e-07 0.00021 2.2248392726840004e-07 0 2.2248392726840001e-07 0 2.2249392726840003e-07 0.00021 2.2250392726840004e-07 0 2.225039272684e-07 0 2.2251392726840002e-07 0.00021 2.2252392726840003e-07 0 2.2253927458377235e-07 0 2.2254927458377236e-07 0.00021 2.2255927458377237e-07 0 2.2257666429936277e-07 0 2.2258666429936278e-07 0.00021 2.225966642993628e-07 0 2.2259666429936277e-07 0 2.2260666429936278e-07 0.00021 2.226166642993628e-07 0 2.2261666429936276e-07 0 2.2262666429936278e-07 0.00021 2.226366642993628e-07 0 2.2268063567657337e-07 0 2.2269063567657338e-07 0.00021 2.227006356765734e-07 0 2.2270063567657337e-07 0 2.2271063567657338e-07 0.00021 2.227206356765734e-07 0 2.2272063567657336e-07 0 2.2273063567657337e-07 0.00021 2.2274063567657339e-07 0 2.2274063567657336e-07 0 2.2275063567657337e-07 0.00021 2.2276063567657338e-07 0 2.2276063567657336e-07 0 2.2277063567657337e-07 0.00021 2.2278063567657338e-07 0 2.2278063567657335e-07 0 2.2279063567657336e-07 0.00021 2.2280063567657337e-07 0 2.2286570629494942e-07 0 2.2287570629494943e-07 0.00021 2.2288570629494944e-07 0 2.2289159240182495e-07 0 2.2290159240182496e-07 0.00021 2.2291159240182497e-07 0 2.229961761736481e-07 0 2.2300617617364812e-07 0.00021 2.2301617617364813e-07 0 2.2306009871267586e-07 0 2.2307009871267588e-07 0.00021 2.230800987126759e-07 0 2.2308009871267586e-07 0 2.2309009871267587e-07 0.00021 2.2310009871267588e-07 0 2.2311078796280902e-07 0 2.2312078796280904e-07 0.00021 2.2313078796280905e-07 0 2.2314801623325182e-07 0 2.2315801623325183e-07 0.00021 2.2316801623325184e-07 0 2.2317353035862634e-07 0 2.2318353035862635e-07 0.00021 2.2319353035862636e-07 0 2.2320794668953825e-07 0 2.2321794668953826e-07 0.00021 2.2322794668953827e-07 0 2.2322926553698459e-07 0 2.232392655369846e-07 0.00021 2.232492655369846e-07 0 2.2324926553698458e-07 0 2.232592655369846e-07 0.00021 2.232692655369846e-07 0 2.2326926553698458e-07 0 2.232792655369846e-07 0.00021 2.232892655369846e-07 0 2.2328926553698457e-07 0 2.2329926553698459e-07 0.00021 2.233092655369846e-07 0 2.2333312427569843e-07 0 2.2334312427569844e-07 0.00021 2.2335312427569845e-07 0 2.2335312427569843e-07 0 2.2336312427569844e-07 0.00021 2.2337312427569845e-07 0 2.2337312427569842e-07 0 2.2338312427569843e-07 0.00021 2.2339312427569844e-07 0 2.2339312427569842e-07 0 2.2340312427569843e-07 0.00021 2.2341312427569844e-07 0 2.2341312427569841e-07 0 2.2342312427569843e-07 0.00021 2.2343312427569844e-07 0 2.2355915122040998e-07 0 2.2356915122041e-07 0.00021 2.2357915122041e-07 0 2.2357915122040998e-07 0 2.2358915122040999e-07 0.00021 2.2359915122041e-07 0 2.2359915122040997e-07 0 2.2360915122040998e-07 0.00021 2.2361915122041e-07 0 2.2361915122040997e-07 0 2.2362915122040998e-07 0.00021 2.2363915122041e-07 0 2.2363915122040996e-07 0 2.2364915122040998e-07 0.00021 2.2365915122040999e-07 0 2.2365915122040996e-07 0 2.2366915122040997e-07 0.00021 2.2367915122040998e-07 0 2.2367915122040996e-07 0 2.2368915122040997e-07 0.00021 2.2369915122040998e-07 0 2.2372236254951775e-07 0 2.2373236254951776e-07 0.00021 2.2374236254951777e-07 0 2.2381272199621685e-07 0 2.2382272199621686e-07 0.00021 2.2383272199621687e-07 0 2.2383455737384985e-07 0 2.2384455737384986e-07 0.00021 2.2385455737384987e-07 0 2.2391596725846693e-07 0 2.2392596725846694e-07 0.00021 2.2393596725846696e-07 0 2.239530424612783e-07 0 2.239630424612783e-07 0.00021 2.2397304246127832e-07 0 2.2400174134541414e-07 0 2.2401174134541415e-07 0.00021 2.2402174134541417e-07 0 2.2408689875349689e-07 0 2.240968987534969e-07 0.00021 2.241068987534969e-07 0 2.241209088422271e-07 0 2.2413090884222711e-07 0.00021 2.2414090884222713e-07 0 2.241409088422271e-07 0 2.241509088422271e-07 0.00021 2.2416090884222712e-07 0 2.241609088422271e-07 0 2.241709088422271e-07 0.00021 2.2418090884222712e-07 0 2.241809088422271e-07 0 2.241909088422271e-07 0.00021 2.2420090884222711e-07 0 2.242009088422271e-07 0 2.242109088422271e-07 0.00021 2.242209088422271e-07 0 2.2423111282846217e-07 0 2.2424111282846219e-07 0.00021 2.242511128284622e-07 0 2.2426489810266566e-07 0 2.2427489810266568e-07 0.00021 2.242848981026657e-07 0 2.2431291059003055e-07 0 2.2432291059003056e-07 0.00021 2.2433291059003057e-07 0 2.2434019577365517e-07 0 2.2435019577365518e-07 0.00021 2.243601957736552e-07 0 2.2436019577365517e-07 0 2.2437019577365518e-07 0.00021 2.243801957736552e-07 0 2.2438019577365517e-07 0 2.2439019577365518e-07 0.00021 2.244001957736552e-07 0 2.2440019577365516e-07 0 2.2441019577365517e-07 0.00021 2.2442019577365518e-07 0 2.2442019577365516e-07 0 2.2443019577365517e-07 0.00021 2.2444019577365518e-07 0 2.2444019577365515e-07 0 2.2445019577365517e-07 0.00021 2.2446019577365518e-07 0 2.2446692700244842e-07 0 2.2447692700244843e-07 0.00021 2.2448692700244844e-07 0 2.245552871786814e-07 0 2.2456528717868142e-07 0.00021 2.2457528717868143e-07 0 2.2457599748243566e-07 0 2.2458599748243567e-07 0.00021 2.2459599748243569e-07 0 2.2459599748243566e-07 0 2.2460599748243567e-07 0.00021 2.2461599748243568e-07 0 2.2461829481977555e-07 0 2.2462829481977556e-07 0.00021 2.2463829481977557e-07 0 2.2463829481977554e-07 0 2.2464829481977555e-07 0.00021 2.2465829481977557e-07 0 2.2465829481977554e-07 0 2.2466829481977555e-07 0.00021 2.2467829481977556e-07 0 2.2468606380768485e-07 0 2.2469606380768486e-07 0.00021 2.2470606380768487e-07 0 2.2472429783099002e-07 0 2.2473429783099004e-07 0.00021 2.2474429783099005e-07 0 2.2474429783099002e-07 0 2.2475429783099003e-07 0.00021 2.2476429783099004e-07 0 2.2476429783099002e-07 0 2.2477429783099003e-07 0.00021 2.2478429783099004e-07 0 2.2478429783099e-07 0 2.2479429783099002e-07 0.00021 2.2480429783099004e-07 0 2.2480429783099e-07 0 2.2481429783099002e-07 0.00021 2.2482429783099003e-07 0 2.2483883635444473e-07 0 2.2484883635444474e-07 0.00021 2.2485883635444475e-07 0 2.2490133346344873e-07 0 2.2491133346344874e-07 0.00021 2.2492133346344875e-07 0 2.2492133346344873e-07 0 2.2493133346344874e-07 0.00021 2.2494133346344875e-07 0 2.2500728526914956e-07 0 2.2501728526914957e-07 0.00021 2.2502728526914958e-07 0 2.2502728526914956e-07 0 2.2503728526914957e-07 0.00021 2.2504728526914958e-07 0 2.2506198453115403e-07 0 2.2507198453115405e-07 0.00021 2.2508198453115406e-07 0 2.2508198453115403e-07 0 2.2509198453115404e-07 0.00021 2.2510198453115405e-07 0 2.2518724335712322e-07 0 2.2519724335712323e-07 0.00021 2.2520724335712325e-07 0 2.2522367211594733e-07 0 2.2523367211594734e-07 0.00021 2.2524367211594735e-07 0 2.2524367211594733e-07 0 2.2525367211594734e-07 0.00021 2.2526367211594735e-07 0 2.2526367211594732e-07 0 2.2527367211594733e-07 0.00021 2.2528367211594734e-07 0 2.2542885319350036e-07 0 2.2543885319350037e-07 0.00021 2.2544885319350038e-07 0 2.2544885319350035e-07 0 2.2545885319350037e-07 0.00021 2.2546885319350038e-07 0 2.2546885319350035e-07 0 2.2547885319350036e-07 0.00021 2.2548885319350037e-07 0 2.2548885319350035e-07 0 2.2549885319350036e-07 0.00021 2.2550885319350037e-07 0 2.2550885319350034e-07 0 2.2551885319350035e-07 0.00021 2.2552885319350037e-07 0 2.2552885319350034e-07 0 2.2553885319350035e-07 0.00021 2.2554885319350036e-07 0 2.2554885319350034e-07 0 2.2555885319350035e-07 0.00021 2.2556885319350036e-07 0 2.2556885319350033e-07 0 2.2557885319350034e-07 0.00021 2.2558885319350035e-07 0 2.2558885319350033e-07 0 2.2559885319350034e-07 0.00021 2.2560885319350035e-07 0 2.2560885319350032e-07 0 2.2561885319350034e-07 0.00021 2.2562885319350035e-07 0 2.2562885319350032e-07 0 2.2563885319350033e-07 0.00021 2.2564885319350034e-07 0 2.2564885319350032e-07 0 2.2565885319350033e-07 0.00021 2.2566885319350034e-07 0 2.2567563439452826e-07 0 2.2568563439452828e-07 0.00021 2.256956343945283e-07 0 2.2569563439452826e-07 0 2.2570563439452827e-07 0.00021 2.2571563439452828e-07 0 2.2571563439452826e-07 0 2.2572563439452827e-07 0.00021 2.2573563439452828e-07 0 2.2573563439452825e-07 0 2.2574563439452826e-07 0.00021 2.2575563439452828e-07 0 2.2575563439452825e-07 0 2.2576563439452826e-07 0.00021 2.2577563439452827e-07 0 2.2577563439452825e-07 0 2.2578563439452826e-07 0.00021 2.2579563439452827e-07 0 2.2579563439452824e-07 0 2.2580563439452825e-07 0.00021 2.2581563439452826e-07 0 2.258214963155039e-07 0 2.2583149631550392e-07 0.00021 2.2584149631550393e-07 0 2.2585511445544212e-07 0 2.2586511445544213e-07 0.00021 2.2587511445544214e-07 0 2.259408701756897e-07 0 2.259508701756897e-07 0.00021 2.2596087017568972e-07 0 2.259722339056456e-07 0 2.259822339056456e-07 0.00021 2.2599223390564562e-07 0 2.259922339056456e-07 0 2.260022339056456e-07 0.00021 2.260122339056456e-07 0 2.2601252782370908e-07 0 2.260225278237091e-07 0.00021 2.260325278237091e-07 0 2.2603252782370908e-07 0 2.260425278237091e-07 0.00021 2.260525278237091e-07 0 2.2605252782370907e-07 0 2.2606252782370908e-07 0.00021 2.260725278237091e-07 0 2.2607252782370907e-07 0 2.2608252782370908e-07 0.00021 2.260925278237091e-07 0 2.2610859778952396e-07 0 2.2611859778952397e-07 0.00021 2.2612859778952398e-07 0 2.2612859778952396e-07 0 2.2613859778952397e-07 0.00021 2.2614859778952398e-07 0 2.2614859778952395e-07 0 2.2615859778952396e-07 0.00021 2.2616859778952398e-07 0 2.2616859778952395e-07 0 2.2617859778952396e-07 0.00021 2.2618859778952397e-07 0 2.2618859778952394e-07 0 2.2619859778952396e-07 0.00021 2.2620859778952397e-07 0 2.2620859778952394e-07 0 2.2621859778952395e-07 0.00021 2.2622859778952396e-07 0 2.2622859778952394e-07 0 2.2623859778952395e-07 0.00021 2.2624859778952396e-07 0 2.2624859778952393e-07 0 2.2625859778952394e-07 0.00021 2.2626859778952396e-07 0 2.2626859778952393e-07 0 2.2627859778952394e-07 0.00021 2.2628859778952395e-07 0 2.2628859778952393e-07 0 2.2629859778952394e-07 0.00021 2.2630859778952395e-07 0 2.263372943936538e-07 0 2.2634729439365381e-07 0.00021 2.2635729439365383e-07 0 2.2638753032304862e-07 0 2.2639753032304863e-07 0.00021 2.2640753032304864e-07 0 2.264075303230486e-07 0 2.2641753032304862e-07 0.00021 2.2642753032304864e-07 0 2.264275303230486e-07 0 2.2643753032304862e-07 0.00021 2.2644753032304863e-07 0 2.264475303230486e-07 0 2.2645753032304862e-07 0.00021 2.2646753032304863e-07 0 2.264675303230486e-07 0 2.264775303230486e-07 0.00021 2.2648753032304862e-07 0 2.264875303230486e-07 0 2.264975303230486e-07 0.00021 2.2650753032304862e-07 0 2.265075303230486e-07 0 2.265175303230486e-07 0.00021 2.2652753032304862e-07 0 2.265275303230486e-07 0 2.265375303230486e-07 0.00021 2.265475303230486e-07 0 2.2654753032304859e-07 0 2.265575303230486e-07 0.00021 2.265675303230486e-07 0 2.265871543095663e-07 0 2.265971543095663e-07 0.00021 2.266071543095663e-07 0 2.2660715430956628e-07 0 2.266171543095663e-07 0.00021 2.266271543095663e-07 0 2.2662715430956628e-07 0 2.266371543095663e-07 0.00021 2.266471543095663e-07 0 2.2664715430956628e-07 0 2.266571543095663e-07 0.00021 2.266671543095663e-07 0 2.2666715430956627e-07 0 2.2667715430956628e-07 0.00021 2.266871543095663e-07 0 2.2668715430956627e-07 0 2.2669715430956628e-07 0.00021 2.267071543095663e-07 0 2.2670715430956627e-07 0 2.2671715430956628e-07 0.00021 2.267271543095663e-07 0 2.2672715430956626e-07 0 2.2673715430956627e-07 0.00021 2.2674715430956628e-07 0 2.2674715430956626e-07 0 2.2675715430956627e-07 0.00021 2.2676715430956628e-07 0 2.2676715430956625e-07 0 2.2677715430956627e-07 0.00021 2.2678715430956628e-07 0 2.2678715430956625e-07 0 2.2679715430956626e-07 0.00021 2.2680715430956627e-07 0 2.2687747303501605e-07 0 2.2688747303501606e-07 0.00021 2.2689747303501607e-07 0 2.2689747303501604e-07 0 2.2690747303501605e-07 0.00021 2.2691747303501607e-07 0 2.2691747303501604e-07 0 2.2692747303501605e-07 0.00021 2.2693747303501606e-07 0 2.2696479436282528e-07 0 2.269747943628253e-07 0.00021 2.269847943628253e-07 0 2.2698479436282528e-07 0 2.269947943628253e-07 0.00021 2.270047943628253e-07 0 2.2700479436282527e-07 0 2.2701479436282528e-07 0.00021 2.270247943628253e-07 0 2.2709677958394714e-07 0 2.2710677958394715e-07 0.00021 2.2711677958394716e-07 0 2.2714673905345397e-07 0 2.2715673905345398e-07 0.00021 2.27166739053454e-07 0 2.272359487635435e-07 0 2.2724594876354352e-07 0.00021 2.2725594876354353e-07 0 2.2725708083286244e-07 0 2.2726708083286245e-07 0.00021 2.2727708083286246e-07 0 2.2727708083286243e-07 0 2.2728708083286244e-07 0.00021 2.2729708083286246e-07 0 2.2729708083286243e-07 0 2.2730708083286244e-07 0.00021 2.2731708083286245e-07 0 2.2731708083286243e-07 0 2.2732708083286244e-07 0.00021 2.2733708083286245e-07 0 2.2733708083286242e-07 0 2.2734708083286243e-07 0.00021 2.2735708083286244e-07 0 2.2735708083286242e-07 0 2.2736708083286243e-07 0.00021 2.2737708083286244e-07 0 2.2737708083286241e-07 0 2.2738708083286243e-07 0.00021 2.2739708083286244e-07 0 2.273970808328624e-07 0 2.2740708083286242e-07 0.00021 2.2741708083286243e-07 0 2.274170808328624e-07 0 2.2742708083286242e-07 0.00021 2.2743708083286243e-07 0 2.2751782567561281e-07 0 2.2752782567561283e-07 0.00021 2.2753782567561284e-07 0 2.275378256756128e-07 0 2.2754782567561282e-07 0.00021 2.2755782567561283e-07 0 2.275578256756128e-07 0 2.2756782567561282e-07 0.00021 2.2757782567561283e-07 0 2.2766216215808046e-07 0 2.2767216215808047e-07 0.00021 2.2768216215808048e-07 0 2.2777835903346402e-07 0 2.2778835903346403e-07 0.00021 2.2779835903346404e-07 0 2.278144893446658e-07 0 2.2782448934466582e-07 0.00021 2.2783448934466583e-07 0 2.278344893446658e-07 0 2.2784448934466582e-07 0.00021 2.2785448934466583e-07 0 2.278544893446658e-07 0 2.2786448934466581e-07 0.00021 2.2787448934466583e-07 0 2.278744893446658e-07 0 2.278844893446658e-07 0.00021 2.2789448934466582e-07 0 2.278944893446658e-07 0 2.279044893446658e-07 0.00021 2.2791448934466582e-07 0 2.279144893446658e-07 0 2.279244893446658e-07 0.00021 2.2793448934466581e-07 0 2.280781791591874e-07 0 2.280881791591874e-07 0.00021 2.2809817915918742e-07 0 2.2812789262996865e-07 0 2.2813789262996866e-07 0.00021 2.2814789262996868e-07 0 2.2823887666821618e-07 0 2.282488766682162e-07 0.00021 2.282588766682162e-07 0 2.282758644298754e-07 0 2.282858644298754e-07 0.00021 2.2829586442987542e-07 0 2.2831341646796954e-07 0 2.2832341646796956e-07 0.00021 2.2833341646796957e-07 0 2.2833341646796954e-07 0 2.2834341646796955e-07 0.00021 2.2835341646796956e-07 0 2.2835341646796954e-07 0 2.2836341646796955e-07 0.00021 2.2837341646796956e-07 0 2.2837341646796953e-07 0 2.2838341646796954e-07 0.00021 2.2839341646796956e-07 0 2.284765526879892e-07 0 2.284865526879892e-07 0.00021 2.2849655268798922e-07 0 2.2857987958953852e-07 0 2.2858987958953853e-07 0.00021 2.2859987958953854e-07 0 2.2865051151204645e-07 0 2.2866051151204646e-07 0.00021 2.2867051151204647e-07 0 2.2867051151204645e-07 0 2.2868051151204646e-07 0.00021 2.2869051151204647e-07 0 2.2869051151204644e-07 0 2.2870051151204646e-07 0.00021 2.2871051151204647e-07 0 2.2871051151204644e-07 0 2.2872051151204645e-07 0.00021 2.2873051151204646e-07 0 2.2873051151204644e-07 0 2.2874051151204645e-07 0.00021 2.2875051151204646e-07 0 2.2875626014345806e-07 0 2.2876626014345807e-07 0.00021 2.2877626014345808e-07 0 2.2877626014345805e-07 0 2.2878626014345806e-07 0.00021 2.2879626014345808e-07 0 2.2879626014345805e-07 0 2.2880626014345806e-07 0.00021 2.2881626014345807e-07 0 2.2881626014345805e-07 0 2.2882626014345806e-07 0.00021 2.2883626014345807e-07 0 2.2883626014345804e-07 0 2.2884626014345805e-07 0.00021 2.2885626014345806e-07 0 2.2885626014345804e-07 0 2.2886626014345805e-07 0.00021 2.2887626014345806e-07 0 2.2895829574151518e-07 0 2.289682957415152e-07 0.00021 2.289782957415152e-07 0 2.2897829574151518e-07 0 2.289882957415152e-07 0.00021 2.289982957415152e-07 0 2.2899829574151518e-07 0 2.290082957415152e-07 0.00021 2.290182957415152e-07 0 2.2901829574151517e-07 0 2.2902829574151518e-07 0.00021 2.290382957415152e-07 0 2.2905000983868902e-07 0 2.2906000983868903e-07 0.00021 2.2907000983868904e-07 0 2.2917803621121784e-07 0 2.2918803621121786e-07 0.00021 2.2919803621121787e-07 0 2.2919803621121784e-07 0 2.2920803621121785e-07 0.00021 2.2921803621121786e-07 0 2.2922683398462505e-07 0 2.2923683398462506e-07 0.00021 2.2924683398462508e-07 0 2.2926598082132625e-07 0 2.2927598082132627e-07 0.00021 2.2928598082132628e-07 0 2.293130584513454e-07 0 2.2932305845134542e-07 0.00021 2.2933305845134543e-07 0 2.2933368442334246e-07 0 2.2934368442334247e-07 0.00021 2.2935368442334248e-07 0 2.2935368442334246e-07 0 2.2936368442334247e-07 0.00021 2.2937368442334248e-07 0 2.2937368442334245e-07 0 2.2938368442334246e-07 0.00021 2.2939368442334248e-07 0 2.2939368442334245e-07 0 2.2940368442334246e-07 0.00021 2.2941368442334247e-07 0 2.2941368442334245e-07 0 2.2942368442334246e-07 0.00021 2.2943368442334247e-07 0 2.2943368442334244e-07 0 2.2944368442334245e-07 0.00021 2.2945368442334246e-07 0 2.2945368442334244e-07 0 2.2946368442334245e-07 0.00021 2.2947368442334246e-07 0 2.2947368442334243e-07 0 2.2948368442334245e-07 0.00021 2.2949368442334246e-07 0 2.2949368442334243e-07 0 2.2950368442334244e-07 0.00021 2.2951368442334245e-07 0 2.2951368442334243e-07 0 2.2952368442334244e-07 0.00021 2.2953368442334245e-07 0 2.2953368442334242e-07 0 2.2954368442334243e-07 0.00021 2.2955368442334245e-07 0 2.2955368442334242e-07 0 2.2956368442334243e-07 0.00021 2.2957368442334244e-07 0 2.2957368442334242e-07 0 2.2958368442334243e-07 0.00021 2.2959368442334244e-07 0 2.295936844233424e-07 0 2.2960368442334242e-07 0.00021 2.2961368442334243e-07 0 2.2961653530303238e-07 0 2.296265353030324e-07 0.00021 2.296365353030324e-07 0 2.2963653530303238e-07 0 2.296465353030324e-07 0.00021 2.296565353030324e-07 0 2.2966885982806873e-07 0 2.2967885982806875e-07 0.00021 2.2968885982806876e-07 0 2.2968885982806873e-07 0 2.2969885982806874e-07 0.00021 2.2970885982806875e-07 0 2.297616200527588e-07 0 2.2977162005275882e-07 0.00021 2.2978162005275883e-07 0 2.297816200527588e-07 0 2.2979162005275882e-07 0.00021 2.2980162005275883e-07 0 2.298016200527588e-07 0 2.2981162005275881e-07 0.00021 2.2982162005275883e-07 0 2.298216200527588e-07 0 2.298316200527588e-07 0.00021 2.2984162005275882e-07 0 2.298909442332725e-07 0 2.299009442332725e-07 0.00021 2.299109442332725e-07 0 2.2994530579425872e-07 0 2.2995530579425874e-07 0.00021 2.2996530579425875e-07 0 2.299664827502999e-07 0 2.299764827502999e-07 0.00021 2.299864827502999e-07 0 2.2999927588016569e-07 0 2.300092758801657e-07 0.00021 2.300192758801657e-07 0 2.3001927588016568e-07 0 2.300292758801657e-07 0.00021 2.300392758801657e-07 0 2.3003927588016568e-07 0 2.300492758801657e-07 0.00021 2.300592758801657e-07 0 2.3005927588016567e-07 0 2.3006927588016569e-07 0.00021 2.300792758801657e-07 0 2.3007927588016567e-07 0 2.3008927588016568e-07 0.00021 2.300992758801657e-07 0 2.3009927588016567e-07 0 2.3010927588016568e-07 0.00021 2.301192758801657e-07 0 2.3011927588016566e-07 0 2.3012927588016567e-07 0.00021 2.3013927588016569e-07 0 2.3020056060628215e-07 0 2.3021056060628216e-07 0.00021 2.3022056060628217e-07 0 2.3022056060628215e-07 0 2.3023056060628216e-07 0.00021 2.3024056060628217e-07 0 2.3024056060628214e-07 0 2.3025056060628216e-07 0.00021 2.3026056060628217e-07 0 2.3026056060628214e-07 0 2.3027056060628215e-07 0.00021 2.3028056060628216e-07 0 2.3028056060628214e-07 0 2.3029056060628215e-07 0.00021 2.3030056060628216e-07 0 2.3043475632227653e-07 0 2.3044475632227654e-07 0.00021 2.3045475632227655e-07 0 2.304964658549524e-07 0 2.3050646585495242e-07 0.00021 2.3051646585495243e-07 0 2.3053443936412022e-07 0 2.3054443936412023e-07 0.00021 2.3055443936412024e-07 0 2.3059782515600466e-07 0 2.3060782515600467e-07 0.00021 2.3061782515600468e-07 0 2.306382513862553e-07 0 2.306482513862553e-07 0.00021 2.3065825138625532e-07 0 2.3069420946054394e-07 0 2.3070420946054395e-07 0.00021 2.3071420946054396e-07 0 2.3071420946054394e-07 0 2.3072420946054395e-07 0.00021 2.3073420946054396e-07 0 2.3073420946054393e-07 0 2.3074420946054395e-07 0.00021 2.3075420946054396e-07 0 2.3075420946054393e-07 0 2.3076420946054394e-07 0.00021 2.3077420946054395e-07 0 2.3077420946054393e-07 0 2.3078420946054394e-07 0.00021 2.3079420946054395e-07 0 2.3080623362533974e-07 0 2.3081623362533975e-07 0.00021 2.3082623362533976e-07 0 2.308554331776014e-07 0 2.308654331776014e-07 0.00021 2.308754331776014e-07 0 2.3087982192580042e-07 0 2.3088982192580043e-07 0.00021 2.3089982192580044e-07 0 2.3090067226026163e-07 0 2.3091067226026164e-07 0.00021 2.3092067226026165e-07 0 2.3092067226026163e-07 0 2.3093067226026164e-07 0.00021 2.3094067226026165e-07 0 2.3100029787744067e-07 0 2.3101029787744068e-07 0.00021 2.310202978774407e-07 0 2.3102029787744067e-07 0 2.3103029787744068e-07 0.00021 2.310402978774407e-07 0 2.3104029787744066e-07 0 2.3105029787744068e-07 0.00021 2.3106029787744069e-07 0 2.3106029787744066e-07 0 2.3107029787744067e-07 0.00021 2.3108029787744068e-07 0 2.3117397079259324e-07 0 2.3118397079259325e-07 0.00021 2.3119397079259326e-07 0 2.3119434317406845e-07 0 2.3120434317406846e-07 0.00021 2.3121434317406847e-07 0 2.3125919218329137e-07 0 2.3126919218329138e-07 0.00021 2.312791921832914e-07 0 2.3127919218329136e-07 0 2.3128919218329137e-07 0.00021 2.3129919218329139e-07 0 2.3129919218329136e-07 0 2.3130919218329137e-07 0.00021 2.3131919218329138e-07 0 2.3131919218329136e-07 0 2.3132919218329137e-07 0.00021 2.3133919218329138e-07 0 2.3133919218329135e-07 0 2.3134919218329136e-07 0.00021 2.3135919218329137e-07 0 2.3135919218329135e-07 0 2.3136919218329136e-07 0.00021 2.3137919218329137e-07 0 2.3137919218329134e-07 0 2.3138919218329136e-07 0.00021 2.3139919218329137e-07 0 2.3139919218329134e-07 0 2.3140919218329135e-07 0.00021 2.3141919218329136e-07 0 2.3141919218329134e-07 0 2.3142919218329135e-07 0.00021 2.3143919218329136e-07 0 2.3144241767991744e-07 0 2.3145241767991745e-07 0.00021 2.3146241767991747e-07 0 2.3148159238046627e-07 0 2.3149159238046628e-07 0.00021 2.315015923804663e-07 0 2.3151696164349346e-07 0 2.3152696164349347e-07 0.00021 2.3153696164349348e-07 0 2.3153696164349345e-07 0 2.3154696164349346e-07 0.00021 2.3155696164349348e-07 0 2.3155696164349345e-07 0 2.3156696164349346e-07 0.00021 2.3157696164349347e-07 0 2.3157696164349345e-07 0 2.3158696164349346e-07 0.00021 2.3159696164349347e-07 0 2.3159696164349344e-07 0 2.3160696164349345e-07 0.00021 2.3161696164349346e-07 0 2.3161696164349344e-07 0 2.3162696164349345e-07 0.00021 2.3163696164349346e-07 0 2.3164032650650484e-07 0 2.3165032650650485e-07 0.00021 2.3166032650650486e-07 0 2.3166951334415477e-07 0 2.3167951334415478e-07 0.00021 2.316895133441548e-07 0 2.3168951334415477e-07 0 2.3169951334415478e-07 0.00021 2.317095133441548e-07 0 2.3170951334415476e-07 0 2.3171951334415477e-07 0.00021 2.3172951334415479e-07 0 2.3172951334415476e-07 0 2.3173951334415477e-07 0.00021 2.3174951334415478e-07 0 2.3182119667020152e-07 0 2.3183119667020153e-07 0.00021 2.3184119667020155e-07 0 2.318625762774801e-07 0 2.318725762774801e-07 0.00021 2.3188257627748012e-07 0 2.3188930835369618e-07 0 2.318993083536962e-07 0.00021 2.319093083536962e-07 0 2.319402006733481e-07 0 2.3195020067334812e-07 0.00021 2.3196020067334813e-07 0 2.319602006733481e-07 0 2.3197020067334812e-07 0.00021 2.3198020067334813e-07 0 2.319802006733481e-07 0 2.319902006733481e-07 0.00021 2.3200020067334812e-07 0 2.320002006733481e-07 0 2.320102006733481e-07 0.00021 2.3202020067334812e-07 0 2.320202006733481e-07 0 2.320302006733481e-07 0.00021 2.3204020067334812e-07 0 2.320402006733481e-07 0 2.320502006733481e-07 0.00021 2.320602006733481e-07 0 2.3206020067334809e-07 0 2.320702006733481e-07 0.00021 2.320802006733481e-07 0 2.3208020067334808e-07 0 2.320902006733481e-07 0.00021 2.321002006733481e-07 0 2.3210020067334808e-07 0 2.321102006733481e-07 0.00021 2.321202006733481e-07 0 2.3212020067334807e-07 0 2.3213020067334809e-07 0.00021 2.321402006733481e-07 0 2.3214020067334807e-07 0 2.3215020067334808e-07 0.00021 2.321602006733481e-07 0 2.3216020067334807e-07 0 2.3217020067334808e-07 0.00021 2.321802006733481e-07 0 2.3218020067334806e-07 0 2.3219020067334807e-07 0.00021 2.3220020067334809e-07 0 2.3220020067334806e-07 0 2.3221020067334807e-07 0.00021 2.3222020067334808e-07 0 2.3222020067334806e-07 0 2.3223020067334807e-07 0.00021 2.3224020067334808e-07 0 2.3224020067334805e-07 0 2.3225020067334806e-07 0.00021 2.3226020067334807e-07 0 2.3226020067334805e-07 0 2.3227020067334806e-07 0.00021 2.3228020067334807e-07 0 2.3228020067334804e-07 0 2.3229020067334806e-07 0.00021 2.3230020067334807e-07 0 2.3230083454418396e-07 0 2.3231083454418397e-07 0.00021 2.3232083454418398e-07 0 2.3232218676849726e-07 0 2.3233218676849728e-07 0.00021 2.3234218676849729e-07 0 2.323484660460045e-07 0 2.3235846604600452e-07 0.00021 2.3236846604600453e-07 0 2.3239154901748367e-07 0 2.3240154901748368e-07 0.00021 2.324115490174837e-07 0 2.3245974831038635e-07 0 2.3246974831038636e-07 0.00021 2.3247974831038637e-07 0 2.325700160754263e-07 0 2.325800160754263e-07 0.00021 2.3259001607542632e-07 0 2.325900160754263e-07 0 2.326000160754263e-07 0.00021 2.3261001607542632e-07 0 2.326100160754263e-07 0 2.326200160754263e-07 0.00021 2.3263001607542632e-07 0 2.326300160754263e-07 0 2.326400160754263e-07 0.00021 2.326500160754263e-07 0 2.3269195573922966e-07 0 2.3270195573922967e-07 0.00021 2.3271195573922968e-07 0 2.3271195573922966e-07 0 2.3272195573922967e-07 0.00021 2.3273195573922968e-07 0 2.3273195573922965e-07 0 2.3274195573922966e-07 0.00021 2.3275195573922968e-07 0 2.3280669407103708e-07 0 2.328166940710371e-07 0.00021 2.328266940710371e-07 0 2.3282669407103708e-07 0 2.328366940710371e-07 0.00021 2.328466940710371e-07 0 2.3290925637584542e-07 0 2.3291925637584543e-07 0.00021 2.3292925637584544e-07 0 2.329509796339895e-07 0 2.3296097963398952e-07 0.00021 2.3297097963398953e-07 0 2.329709796339895e-07 0 2.3298097963398951e-07 0.00021 2.3299097963398952e-07 0 2.3299145883639688e-07 0 2.330014588363969e-07 0.00021 2.330114588363969e-07 0 2.3301978466514836e-07 0 2.3302978466514837e-07 0.00021 2.3303978466514838e-07 0 2.331458105444512e-07 0 2.331558105444512e-07 0.00021 2.3316581054445122e-07 0 2.3317159128066182e-07 0 2.3318159128066183e-07 0.00021 2.3319159128066184e-07 0 2.3320365797451008e-07 0 2.332136579745101e-07 0.00021 2.332236579745101e-07 0 2.3323802513387708e-07 0 2.332480251338771e-07 0.00021 2.332580251338771e-07 0 2.3325846932268577e-07 0 2.3326846932268578e-07 0.00021 2.332784693226858e-07 0 2.3327846932268576e-07 0 2.3328846932268578e-07 0.00021 2.332984693226858e-07 0 2.3329846932268576e-07 0 2.3330846932268577e-07 0.00021 2.3331846932268578e-07 0 2.3342076884978288e-07 0 2.334307688497829e-07 0.00021 2.334407688497829e-07 0 2.3344938275042947e-07 0 2.3345938275042948e-07 0.00021 2.334693827504295e-07 0 2.3352973698378676e-07 0 2.3353973698378677e-07 0.00021 2.3354973698378678e-07 0 2.3354973698378675e-07 0 2.3355973698378676e-07 0.00021 2.3356973698378678e-07 0 2.3356973698378675e-07 0 2.3357973698378676e-07 0.00021 2.3358973698378677e-07 0 2.3363019410500267e-07 0 2.3364019410500269e-07 0.00021 2.336501941050027e-07 0 2.3365019410500267e-07 0 2.3366019410500268e-07 0.00021 2.336701941050027e-07 0 2.3367019410500267e-07 0 2.3368019410500268e-07 0.00021 2.336901941050027e-07 0 2.3369657337605268e-07 0 2.337065733760527e-07 0.00021 2.337165733760527e-07 0 2.337673662864461e-07 0 2.337773662864461e-07 0.00021 2.337873662864461e-07 0 2.3379453445378246e-07 0 2.3380453445378247e-07 0.00021 2.3381453445378248e-07 0 2.3385429544813314e-07 0 2.3386429544813315e-07 0.00021 2.3387429544813316e-07 0 2.3387429544813314e-07 0 2.3388429544813315e-07 0.00021 2.3389429544813316e-07 0 2.339003889388847e-07 0 2.339103889388847e-07 0.00021 2.3392038893888472e-07 0 2.3394336643464704e-07 0 2.3395336643464705e-07 0.00021 2.3396336643464706e-07 0 2.339726111478986e-07 0 2.339826111478986e-07 0.00021 2.339926111478986e-07 0 2.3402145786587378e-07 0 2.340314578658738e-07 0.00021 2.340414578658738e-07 0 2.3404397096467595e-07 0 2.3405397096467596e-07 0.00021 2.3406397096467597e-07 0 2.3406397096467594e-07 0 2.3407397096467596e-07 0.00021 2.3408397096467597e-07 0 2.3408397096467594e-07 0 2.3409397096467595e-07 0.00021 2.3410397096467596e-07 0 2.3410397096467594e-07 0 2.3411397096467595e-07 0.00021 2.3412397096467596e-07 0 2.3414854895035298e-07 0 2.34158548950353e-07 0.00021 2.34168548950353e-07 0 2.3421779093148715e-07 0 2.3422779093148717e-07 0.00021 2.3423779093148718e-07 0 2.342719585606127e-07 0 2.342819585606127e-07 0.00021 2.3429195856061272e-07 0 2.3429616323644745e-07 0 2.3430616323644746e-07 0.00021 2.3431616323644747e-07 0 2.3431616323644745e-07 0 2.3432616323644746e-07 0.00021 2.3433616323644747e-07 0 2.3433616323644744e-07 0 2.3434616323644746e-07 0.00021 2.3435616323644747e-07 0 2.3435616323644744e-07 0 2.3436616323644745e-07 0.00021 2.3437616323644746e-07 0 2.3438103153373994e-07 0 2.3439103153373995e-07 0.00021 2.3440103153373996e-07 0 2.344236543337504e-07 0 2.3443365433375042e-07 0.00021 2.3444365433375043e-07 0 2.344436543337504e-07 0 2.3445365433375042e-07 0.00021 2.3446365433375043e-07 0 2.3448427580149274e-07 0 2.3449427580149275e-07 0.00021 2.3450427580149276e-07 0 2.34517830152125e-07 0 2.34527830152125e-07 0.00021 2.3453783015212502e-07 0 2.34537830152125e-07 0 2.34547830152125e-07 0.00021 2.3455783015212502e-07 0 2.34557830152125e-07 0 2.34567830152125e-07 0.00021 2.3457783015212502e-07 0 2.34577830152125e-07 0 2.34587830152125e-07 0.00021 2.34597830152125e-07 0 2.3459783015212499e-07 0 2.34607830152125e-07 0.00021 2.34617830152125e-07 0 2.3461783015212498e-07 0 2.34627830152125e-07 0.00021 2.34637830152125e-07 0 2.3466614902030815e-07 0 2.3467614902030816e-07 0.00021 2.3468614902030817e-07 0 2.3468614902030814e-07 0 2.3469614902030815e-07 0.00021 2.3470614902030817e-07 0 2.3470614902030814e-07 0 2.3471614902030815e-07 0.00021 2.3472614902030816e-07 0 2.3472614902030814e-07 0 2.3473614902030815e-07 0.00021 2.3474614902030816e-07 0 2.3474672032039968e-07 0 2.347567203203997e-07 0.00021 2.347667203203997e-07 0 2.3476730357641793e-07 0 2.3477730357641794e-07 0.00021 2.3478730357641795e-07 0 2.3478730357641792e-07 0 2.3479730357641793e-07 0.00021 2.3480730357641794e-07 0 2.3480730357641792e-07 0 2.3481730357641793e-07 0.00021 2.3482730357641794e-07 0 2.3482730357641791e-07 0 2.3483730357641793e-07 0.00021 2.3484730357641794e-07 0 2.3487212326076193e-07 0 2.3488212326076195e-07 0.00021 2.3489212326076196e-07 0 2.349259431215035e-07 0 2.349359431215035e-07 0.00021 2.349459431215035e-07 0 2.3494594312150348e-07 0 2.349559431215035e-07 0.00021 2.349659431215035e-07 0 2.3504324460458663e-07 0 2.3505324460458665e-07 0.00021 2.3506324460458666e-07 0 2.3507979414506004e-07 0 2.3508979414506005e-07 0.00021 2.3509979414506006e-07 0 2.3510931618670867e-07 0 2.3511931618670868e-07 0.00021 2.351293161867087e-07 0 2.3518659284488096e-07 0 2.3519659284488097e-07 0.00021 2.3520659284488098e-07 0 2.3520659284488095e-07 0 2.3521659284488096e-07 0.00021 2.3522659284488098e-07 0 2.3522659284488095e-07 0 2.3523659284488096e-07 0.00021 2.3524659284488097e-07 0 2.3524659284488095e-07 0 2.3525659284488096e-07 0.00021 2.3526659284488097e-07 0 2.3526659284488094e-07 0 2.3527659284488095e-07 0.00021 2.3528659284488096e-07 0 2.3528659284488094e-07 0 2.3529659284488095e-07 0.00021 2.3530659284488096e-07 0 2.3530659284488093e-07 0 2.3531659284488095e-07 0.00021 2.3532659284488096e-07 0 2.3532659284488093e-07 0 2.3533659284488094e-07 0.00021 2.3534659284488095e-07 0 2.3534659284488093e-07 0 2.3535659284488094e-07 0.00021 2.3536659284488095e-07 0 2.3539312916383056e-07 0 2.3540312916383057e-07 0.00021 2.3541312916383058e-07 0 2.3541312916383055e-07 0 2.3542312916383057e-07 0.00021 2.3543312916383058e-07 0 2.3543312916383055e-07 0 2.3544312916383056e-07 0.00021 2.3545312916383057e-07 0 2.3545312916383055e-07 0 2.3546312916383056e-07 0.00021 2.3547312916383057e-07 0 2.3547312916383054e-07 0 2.3548312916383055e-07 0.00021 2.3549312916383057e-07 0 2.3549312916383054e-07 0 2.3550312916383055e-07 0.00021 2.3551312916383056e-07 0 2.3551312916383054e-07 0 2.3552312916383055e-07 0.00021 2.3553312916383056e-07 0 2.3553312916383053e-07 0 2.3554312916383054e-07 0.00021 2.3555312916383055e-07 0 2.3555312916383053e-07 0 2.3556312916383054e-07 0.00021 2.3557312916383055e-07 0 2.3558228509574585e-07 0 2.3559228509574586e-07 0.00021 2.3560228509574587e-07 0 2.356065275064835e-07 0 2.356165275064835e-07 0.00021 2.356265275064835e-07 0 2.356770322816441e-07 0 2.3568703228164411e-07 0.00021 2.3569703228164413e-07 0 2.356970322816441e-07 0 2.357070322816441e-07 0.00021 2.3571703228164412e-07 0 2.3575673430123274e-07 0 2.3576673430123275e-07 0.00021 2.3577673430123276e-07 0 2.3577673430123273e-07 0 2.3578673430123274e-07 0.00021 2.3579673430123275e-07 0 2.3579673430123273e-07 0 2.3580673430123274e-07 0.00021 2.3581673430123275e-07 0 2.3581673430123272e-07 0 2.3582673430123274e-07 0.00021 2.3583673430123275e-07 0 2.3583673430123272e-07 0 2.3584673430123273e-07 0.00021 2.3585673430123274e-07 0 2.3585673430123272e-07 0 2.3586673430123273e-07 0.00021 2.3587673430123274e-07 0 2.3587795984127815e-07 0 2.3588795984127816e-07 0.00021 2.3589795984127817e-07 0 2.3589795984127815e-07 0 2.3590795984127816e-07 0.00021 2.3591795984127817e-07 0 2.3595298741618427e-07 0 2.3596298741618428e-07 0.00021 2.359729874161843e-07 0 2.3600204030177384e-07 0 2.3601204030177385e-07 0.00021 2.3602204030177386e-07 0 2.3602204030177384e-07 0 2.3603204030177385e-07 0.00021 2.3604204030177386e-07 0 2.3604204030177383e-07 0 2.3605204030177385e-07 0.00021 2.3606204030177386e-07 0 2.360922047385467e-07 0 2.3610220473854672e-07 0.00021 2.3611220473854673e-07 0 2.3612104825432907e-07 0 2.3613104825432908e-07 0.00021 2.361410482543291e-07 0 2.3614104825432907e-07 0 2.3615104825432908e-07 0.00021 2.361610482543291e-07 0 2.3621404217546086e-07 0 2.3622404217546087e-07 0.00021 2.3623404217546088e-07 0 2.3623404217546085e-07 0 2.3624404217546086e-07 0.00021 2.3625404217546088e-07 0 2.3626308592051435e-07 0 2.3627308592051436e-07 0.00021 2.3628308592051437e-07 0 2.3628308592051434e-07 0 2.3629308592051435e-07 0.00021 2.3630308592051436e-07 0 2.3635607443548175e-07 0 2.3636607443548176e-07 0.00021 2.3637607443548177e-07 0 2.3637734269982817e-07 0 2.3638734269982818e-07 0.00021 2.363973426998282e-07 0 2.3640826699459212e-07 0 2.3641826699459213e-07 0.00021 2.3642826699459214e-07 0 2.3644578521192837e-07 0 2.3645578521192838e-07 0.00021 2.364657852119284e-07 0 2.36470070428169e-07 0 2.3648007042816901e-07 0.00021 2.3649007042816902e-07 0 2.36490070428169e-07 0 2.36500070428169e-07 0.00021 2.3651007042816902e-07 0 2.3656000113395717e-07 0 2.3657000113395719e-07 0.00021 2.365800011339572e-07 0 2.3658329240433295e-07 0 2.3659329240433296e-07 0.00021 2.3660329240433297e-07 0 2.3660537066384573e-07 0 2.3661537066384574e-07 0.00021 2.3662537066384575e-07 0 2.366490756432515e-07 0 2.3665907564325152e-07 0.00021 2.3666907564325153e-07 0 2.3670810604695084e-07 0 2.3671810604695085e-07 0.00021 2.3672810604695087e-07 0 2.3672810604695084e-07 0 2.3673810604695085e-07 0.00021 2.3674810604695086e-07 0 2.3679840403860428e-07 0 2.368084040386043e-07 0.00021 2.368184040386043e-07 0 2.368462836363244e-07 0 2.368562836363244e-07 0.00021 2.3686628363632442e-07 0 2.368662836363244e-07 0 2.368762836363244e-07 0.00021 2.368862836363244e-07 0 2.3690947927799252e-07 0 2.3691947927799253e-07 0.00021 2.3692947927799254e-07 0 2.3692947927799251e-07 0 2.3693947927799253e-07 0.00021 2.3694947927799254e-07 0 2.369494792779925e-07 0 2.3695947927799252e-07 0.00021 2.3696947927799253e-07 0 2.369694792779925e-07 0 2.3697947927799252e-07 0.00021 2.3698947927799253e-07 0 2.369894792779925e-07 0 2.3699947927799251e-07 0.00021 2.3700947927799253e-07 0 2.3704688918162177e-07 0 2.3705688918162178e-07 0.00021 2.370668891816218e-07 0 2.3706688918162177e-07 0 2.3707688918162178e-07 0.00021 2.370868891816218e-07 0 2.3709787640546342e-07 0 2.3710787640546343e-07 0.00021 2.3711787640546344e-07 0 2.3711787640546342e-07 0 2.3712787640546343e-07 0.00021 2.3713787640546344e-07 0 2.371378764054634e-07 0 2.3714787640546342e-07 0.00021 2.3715787640546343e-07 0 2.371578764054634e-07 0 2.3716787640546342e-07 0.00021 2.3717787640546343e-07 0 2.371778764054634e-07 0 2.3718787640546342e-07 0.00021 2.3719787640546343e-07 0 2.371978764054634e-07 0 2.372078764054634e-07 0.00021 2.3721787640546342e-07 0 2.372178764054634e-07 0 2.372278764054634e-07 0.00021 2.3723787640546342e-07 0 2.372378764054634e-07 0 2.372478764054634e-07 0.00021 2.3725787640546342e-07 0 2.372578764054634e-07 0 2.372678764054634e-07 0.00021 2.372778764054634e-07 0 2.3727787640546338e-07 0 2.372878764054634e-07 0.00021 2.372978764054634e-07 0 2.3729787640546338e-07 0 2.373078764054634e-07 0.00021 2.373178764054634e-07 0 2.3731787640546338e-07 0 2.373278764054634e-07 0.00021 2.373378764054634e-07 0 2.3733787640546337e-07 0 2.3734787640546338e-07 0.00021 2.373578764054634e-07 0 2.3735787640546337e-07 0 2.3736787640546338e-07 0.00021 2.373778764054634e-07 0 2.3737787640546337e-07 0 2.3738787640546338e-07 0.00021 2.373978764054634e-07 0 2.3739787640546336e-07 0 2.3740787640546337e-07 0.00021 2.3741787640546338e-07 0 2.3741787640546336e-07 0 2.3742787640546337e-07 0.00021 2.3743787640546338e-07 0 2.3743787640546335e-07 0 2.3744787640546337e-07 0.00021 2.3745787640546338e-07 0 2.3745787640546335e-07 0 2.3746787640546336e-07 0.00021 2.3747787640546337e-07 0 2.3756054909638978e-07 0 2.375705490963898e-07 0.00021 2.375805490963898e-07 0 2.3758054909638978e-07 0 2.3759054909638979e-07 0.00021 2.376005490963898e-07 0 2.376476091190414e-07 0 2.376576091190414e-07 0.00021 2.3766760911904142e-07 0 2.376676091190414e-07 0 2.376776091190414e-07 0.00021 2.3768760911904142e-07 0 2.376876091190414e-07 0 2.376976091190414e-07 0.00021 2.377076091190414e-07 0 2.3770760911904139e-07 0 2.377176091190414e-07 0.00021 2.377276091190414e-07 0 2.3773583989014725e-07 0 2.3774583989014726e-07 0.00021 2.3775583989014727e-07 0 2.3775583989014724e-07 0 2.3776583989014725e-07 0.00021 2.3777583989014726e-07 0 2.3778063565296473e-07 0 2.3779063565296474e-07 0.00021 2.3780063565296475e-07 0 2.3780063565296473e-07 0 2.3781063565296474e-07 0.00021 2.3782063565296475e-07 0 2.3782063565296472e-07 0 2.3783063565296474e-07 0.00021 2.3784063565296475e-07 0 2.3790216598620292e-07 0 2.3791216598620293e-07 0.00021 2.3792216598620294e-07 0 2.3792401078849176e-07 0 2.3793401078849178e-07 0.00021 2.3794401078849179e-07 0 2.3794401078849176e-07 0 2.3795401078849177e-07 0.00021 2.3796401078849178e-07 0 2.3796401078849176e-07 0 2.3797401078849177e-07 0.00021 2.3798401078849178e-07 0 2.3798401078849175e-07 0 2.3799401078849176e-07 0.00021 2.3800401078849178e-07 0 2.3800401078849175e-07 0 2.3801401078849176e-07 0.00021 2.3802401078849177e-07 0 2.3802401078849175e-07 0 2.3803401078849176e-07 0.00021 2.3804401078849177e-07 0 2.3804401078849174e-07 0 2.3805401078849175e-07 0.00021 2.3806401078849176e-07 0 2.3806401078849174e-07 0 2.3807401078849175e-07 0.00021 2.3808401078849176e-07 0 2.3808401078849173e-07 0 2.3809401078849175e-07 0.00021 2.3810401078849176e-07 0 2.3815538921008184e-07 0 2.3816538921008185e-07 0.00021 2.3817538921008186e-07 0 2.3824644269724583e-07 0 2.3825644269724584e-07 0.00021 2.3826644269724585e-07 0 2.3826644269724582e-07 0 2.3827644269724584e-07 0.00021 2.3828644269724585e-07 0 2.3828644269724582e-07 0 2.3829644269724583e-07 0.00021 2.3830644269724584e-07 0 2.3830692847141253e-07 0 2.3831692847141254e-07 0.00021 2.3832692847141255e-07 0 2.3832971676757506e-07 0 2.3833971676757507e-07 0.00021 2.3834971676757508e-07 0 2.3835506868162668e-07 0 2.383650686816267e-07 0.00021 2.383750686816267e-07 0 2.384347840074898e-07 0 2.3844478400748984e-07 0.00021 2.3845478400748985e-07 0 2.3845478400748985e-07 0 2.3846478400748986e-07 0.00021 2.3847478400748987e-07 0 2.384759193230093e-07 0 2.384859193230093e-07 0.00021 2.3849591932300934e-07 0 2.3849591932300934e-07 0 2.3850591932300935e-07 0.00021 2.3851591932300936e-07 0 2.3851591932300936e-07 0 2.3852591932300937e-07 0.00021 2.385359193230094e-07 0 2.385359193230094e-07 0 2.385459193230094e-07 0.00021 2.385559193230094e-07 0 2.385559193230094e-07 0 2.385659193230094e-07 0.00021 2.385759193230094e-07 0 2.385759193230094e-07 0 2.3858591932300944e-07 0.00021 2.3859591932300945e-07 0 2.3859591932300945e-07 0 2.3860591932300946e-07 0.00021 2.3861591932300947e-07 0 2.3861591932300947e-07 0 2.386259193230095e-07 0.00021 2.386359193230095e-07 0 2.386359193230095e-07 0 2.386459193230095e-07 0.00021 2.386559193230095e-07 0 2.386559193230095e-07 0 2.3866591932300953e-07 0.00021 2.3867591932300954e-07 0 2.3867591932300954e-07 0 2.3868591932300955e-07 0.00021 2.3869591932300956e-07 0 2.3869591932300956e-07 0 2.3870591932300957e-07 0.00021 2.387159193230096e-07 0 2.387526710981749e-07 0 2.3876267109817493e-07 0.00021 2.3877267109817494e-07 0 2.3882403505160097e-07 0 2.38834035051601e-07 0.00021 2.38844035051601e-07 0 2.388676913250374e-07 0 2.388776913250374e-07 0.00021 2.3888769132503744e-07 0 2.3888769132503744e-07 0 2.3889769132503745e-07 0.00021 2.3890769132503746e-07 0 2.3890769132503746e-07 0 2.3891769132503747e-07 0.00021 2.389276913250375e-07 0 2.389276913250375e-07 0 2.389376913250375e-07 0.00021 2.389476913250375e-07 0 2.3906198063880907e-07 0 2.390719806388091e-07 0.00021 2.390819806388091e-07 0 2.390819806388091e-07 0 2.390919806388091e-07 0.00021 2.391019806388091e-07 0 2.391019806388091e-07 0 2.391119806388091e-07 0.00021 2.3912198063880914e-07 0 2.3915169909036835e-07 0 2.3916169909036836e-07 0.00021 2.3917169909036837e-07 0 2.392583890730528e-07 0 2.392683890730528e-07 0.00021 2.392783890730528e-07 0 2.3930100865407745e-07 0 2.3931100865407746e-07 0.00021 2.3932100865407747e-07 0 2.3932100865407747e-07 0 2.393310086540775e-07 0.00021 2.393410086540775e-07 0 2.393410086540775e-07 0 2.393510086540775e-07 0.00021 2.393610086540775e-07 0 2.395327293749938e-07 0 2.395427293749938e-07 0.00021 2.395527293749938e-07 0 2.3957950702097766e-07 0 2.3958950702097767e-07 0.00021 2.395995070209777e-07 0 2.396897885148698e-07 0 2.396997885148698e-07 0.00021 2.397097885148698e-07 0 2.397594991263168e-07 0 2.397694991263168e-07 0.00021 2.3977949912631684e-07 0 2.3977949912631684e-07 0 2.3978949912631685e-07 0.00021 2.3979949912631686e-07 0 2.3983966733790777e-07 0 2.398496673379078e-07 0.00021 2.398596673379078e-07 0 2.398596673379078e-07 0 2.398696673379078e-07 0.00021 2.398796673379078e-07 0 2.398796673379078e-07 0 2.3988966733790783e-07 0.00021 2.3989966733790784e-07 0 2.3989966733790784e-07 0 2.3990966733790785e-07 0.00021 2.3991966733790786e-07 0 2.3991966733790786e-07 0 2.399296673379079e-07 0.00021 2.399396673379079e-07 0 2.399396673379079e-07 0 2.399496673379079e-07 0.00021 2.399596673379079e-07 0 2.399596673379079e-07 0 2.399696673379079e-07 0.00021 2.3997966733790793e-07 0 2.3997966733790793e-07 0 2.3998966733790794e-07 0.00021 2.3999966733790795e-07 0 2.3999966733790795e-07 0 2.4000966733790796e-07 0.00021 2.40019667337908e-07 0 2.40019667337908e-07 0 2.40029667337908e-07 0.00021 2.40039667337908e-07 0 2.40039667337908e-07 0 2.40049667337908e-07 0.00021 2.40059667337908e-07 0 2.4011006072291573e-07 0 2.4012006072291574e-07 0.00021 2.4013006072291575e-07 0 2.4017000186354206e-07 0 2.4018000186354207e-07 0.00021 2.401900018635421e-07 0 2.401900018635421e-07 0 2.402000018635421e-07 0.00021 2.402100018635421e-07 0 2.402100018635421e-07 0 2.402200018635421e-07 0.00021 2.4023000186354213e-07 0 2.4023000186354213e-07 0 2.4024000186354214e-07 0.00021 2.4025000186354215e-07 0 2.4029132894912074e-07 0 2.4030132894912075e-07 0.00021 2.4031132894912076e-07 0 2.4031132894912076e-07 0 2.4032132894912077e-07 0.00021 2.403313289491208e-07 0 2.403793835867409e-07 0 2.403893835867409e-07 0.00021 2.4039938358674093e-07 0 2.4039938358674093e-07 0 2.4040938358674095e-07 0.00021 2.4041938358674096e-07 0 2.4041938358674096e-07 0 2.4042938358674097e-07 0.00021 2.40439383586741e-07 0 2.40439383586741e-07 0 2.40449383586741e-07 0.00021 2.40459383586741e-07 0 2.40459383586741e-07 0 2.40469383586741e-07 0.00021 2.40479383586741e-07 0 2.40479383586741e-07 0 2.4048938358674104e-07 0.00021 2.4049938358674105e-07 0 2.405138668313793e-07 0 2.4052386683137934e-07 0.00021 2.4053386683137935e-07 0 2.405853435867039e-07 0 2.405953435867039e-07 0.00021 2.406053435867039e-07 0 2.406152123793991e-07 0 2.4062521237939913e-07 0.00021 2.4063521237939914e-07 0 2.4063521237939914e-07 0 2.4064521237939916e-07 0.00021 2.4065521237939917e-07 0 2.407129704096685e-07 0 2.407229704096685e-07 0.00021 2.4073297040966853e-07 0 2.4073297040966853e-07 0 2.4074297040966854e-07 0.00021 2.4075297040966855e-07 0 2.4075297040966855e-07 0 2.4076297040966856e-07 0.00021 2.407729704096686e-07 0 2.407729704096686e-07 0 2.407829704096686e-07 0.00021 2.407929704096686e-07 0 2.40797074662461e-07 0 2.40807074662461e-07 0.00021 2.40817074662461e-07 0 2.4090249099608785e-07 0 2.4091249099608786e-07 0.00021 2.4092249099608787e-07 0 2.409437432308527e-07 0 2.409537432308527e-07 0.00021 2.409637432308527e-07 0 2.410231033744424e-07 0 2.410331033744424e-07 0.00021 2.4104310337444243e-07 0 2.410528472669949e-07 0 2.410628472669949e-07 0.00021 2.4107284726699493e-07 0 2.4107284726699493e-07 0 2.4108284726699494e-07 0.00021 2.4109284726699495e-07 0 2.4109284726699495e-07 0 2.4110284726699496e-07 0.00021 2.4111284726699497e-07 0 2.4111284726699497e-07 0 2.41122847266995e-07 0.00021 2.41132847266995e-07 0 2.41132847266995e-07 0 2.41142847266995e-07 0.00021 2.41152847266995e-07 0 2.41152847266995e-07 0 2.4116284726699503e-07 0.00021 2.4117284726699504e-07 0 2.4117284726699504e-07 0 2.4118284726699505e-07 0.00021 2.4119284726699506e-07 0 2.4119284726699506e-07 0 2.412028472669951e-07 0.00021 2.412128472669951e-07 0 2.412128472669951e-07 0 2.412228472669951e-07 0.00021 2.412328472669951e-07 0 2.412328472669951e-07 0 2.412428472669951e-07 0.00021 2.4125284726699513e-07 0 2.4125284726699513e-07 0 2.4126284726699514e-07 0.00021 2.4127284726699515e-07 0 2.413052196391738e-07 0 2.4131521963917383e-07 0.00021 2.4132521963917384e-07 0 2.413908328818287e-07 0 2.414008328818287e-07 0.00021 2.4141083288182873e-07 0 2.4141823638690703e-07 0 2.4142823638690704e-07 0.00021 2.4143823638690705e-07 0 2.4143823638690705e-07 0 2.4144823638690706e-07 0.00021 2.414582363869071e-07 0 2.414582363869071e-07 0 2.414682363869071e-07 0.00021 2.414782363869071e-07 0 2.414782363869071e-07 0 2.414882363869071e-07 0.00021 2.414982363869071e-07 0 2.4150756536487633e-07 0 2.4151756536487635e-07 0.00021 2.4152756536487636e-07 0 2.4154730205579845e-07 0 2.4155730205579846e-07 0.00021 2.4156730205579847e-07 0 2.416640041311939e-07 0 2.416740041311939e-07 0.00021 2.416840041311939e-07 0 2.416915297855249e-07 0 2.417015297855249e-07 0.00021 2.417115297855249e-07 0 2.417514334451986e-07 0 2.4176143344519864e-07 0.00021 2.4177143344519865e-07 0 2.4177143344519865e-07 0 2.4178143344519866e-07 0.00021 2.4179143344519867e-07 0 2.4179143344519867e-07 0 2.418014334451987e-07 0.00021 2.418114334451987e-07 0 2.418114334451987e-07 0 2.418214334451987e-07 0.00021 2.418314334451987e-07 0 2.418504993470219e-07 0 2.418604993470219e-07 0.00021 2.418704993470219e-07 0 2.418704993470219e-07 0 2.4188049934702194e-07 0.00021 2.4189049934702195e-07 0 2.4189049934702195e-07 0 2.4190049934702196e-07 0.00021 2.4191049934702197e-07 0 2.4191049934702197e-07 0 2.41920499347022e-07 0.00021 2.41930499347022e-07 0 2.41930499347022e-07 0 2.41940499347022e-07 0.00021 2.41950499347022e-07 0 2.41950499347022e-07 0 2.4196049934702203e-07 0.00021 2.4197049934702204e-07 0 2.4197049934702204e-07 0 2.4198049934702205e-07 0.00021 2.4199049934702206e-07 0 2.4199049934702206e-07 0 2.4200049934702207e-07 0.00021 2.420104993470221e-07 0 2.420104993470221e-07 0 2.420204993470221e-07 0.00021 2.420304993470221e-07 0 2.420304993470221e-07 0 2.420404993470221e-07 0.00021 2.4205049934702213e-07 0 2.4205049934702213e-07 0 2.4206049934702214e-07 0.00021 2.4207049934702215e-07 0 2.4207049934702215e-07 0 2.4208049934702216e-07 0.00021 2.420904993470222e-07 0 2.420904993470222e-07 0 2.421004993470222e-07 0.00021 2.421104993470222e-07 0 2.421104993470222e-07 0 2.421204993470222e-07 0.00021 2.421304993470222e-07 0 2.421304993470222e-07 0 2.4214049934702223e-07 0.00021 2.4215049934702224e-07 0 2.4215049934702224e-07 0 2.4216049934702225e-07 0.00021 2.4217049934702227e-07 0 2.4217049934702227e-07 0 2.421804993470223e-07 0.00021 2.421904993470223e-07 0 2.421904993470223e-07 0 2.422004993470223e-07 0.00021 2.422104993470223e-07 0 2.42215197727649e-07 0 2.42225197727649e-07 0.00021 2.42235197727649e-07 0 2.42235197727649e-07 0 2.4224519772764904e-07 0.00021 2.4225519772764905e-07 0 2.4227094712852164e-07 0 2.4228094712852165e-07 0.00021 2.4229094712852166e-07 0 2.423324451069448e-07 0 2.423424451069448e-07 0.00021 2.423524451069448e-07 0 2.4238138795063824e-07 0 2.4239138795063825e-07 0.00021 2.4240138795063826e-07 0 2.424166560541685e-07 0 2.424266560541685e-07 0.00021 2.4243665605416854e-07 0 2.4243665605416854e-07 0 2.4244665605416855e-07 0.00021 2.4245665605416856e-07 0 2.4245665605416856e-07 0 2.4246665605416857e-07 0.00021 2.424766560541686e-07 0 2.424766560541686e-07 0 2.424866560541686e-07 0.00021 2.424966560541686e-07 0 2.424966560541686e-07 0 2.425066560541686e-07 0.00021 2.4251665605416863e-07 0 2.4251665605416863e-07 0 2.4252665605416864e-07 0.00021 2.4253665605416865e-07 0 2.4253665605416865e-07 0 2.4254665605416866e-07 0.00021 2.4255665605416867e-07 0 2.4255665605416867e-07 0 2.425666560541687e-07 0.00021 2.425766560541687e-07 0 2.425766560541687e-07 0 2.425866560541687e-07 0.00021 2.425966560541687e-07 0 2.425966560541687e-07 0 2.4260665605416873e-07 0.00021 2.4261665605416874e-07 0 2.4261665605416874e-07 0 2.4262665605416875e-07 0.00021 2.4263665605416876e-07 0 2.4263665605416876e-07 0 2.426466560541688e-07 0.00021 2.426566560541688e-07 0 2.426566560541688e-07 0 2.426666560541688e-07 0.00021 2.426766560541688e-07 0 2.426766560541688e-07 0 2.426866560541688e-07 0.00021 2.4269665605416883e-07 0 2.4269665605416883e-07 0 2.4270665605416884e-07 0.00021 2.4271665605416885e-07 0 2.4271665605416885e-07 0 2.4272665605416887e-07 0.00021 2.427366560541689e-07 0 2.427366560541689e-07 0 2.427466560541689e-07 0.00021 2.427566560541689e-07 0 2.427566560541689e-07 0 2.427666560541689e-07 0.00021 2.427766560541689e-07 0 2.427766560541689e-07 0 2.4278665605416893e-07 0.00021 2.4279665605416894e-07 0 2.4279665605416894e-07 0 2.4280665605416896e-07 0.00021 2.4281665605416897e-07 0 2.4281665605416897e-07 0 2.42826656054169e-07 0.00021 2.42836656054169e-07 0 2.42836656054169e-07 0 2.42846656054169e-07 0.00021 2.42856656054169e-07 0 2.42856656054169e-07 0 2.42866656054169e-07 0.00021 2.4287665605416904e-07 0 2.4287665605416904e-07 0 2.4288665605416905e-07 0.00021 2.4289665605416906e-07 0 2.4291422922100856e-07 0 2.4292422922100857e-07 0.00021 2.429342292210086e-07 0 2.429353062406264e-07 0 2.429453062406264e-07 0.00021 2.429553062406264e-07 0 2.429553062406264e-07 0 2.429653062406264e-07 0.00021 2.4297530624062643e-07 0 2.4297530624062643e-07 0 2.4298530624062644e-07 0.00021 2.4299530624062645e-07 0 2.4299530624062645e-07 0 2.4300530624062647e-07 0.00021 2.430153062406265e-07 0 2.430153062406265e-07 0 2.430253062406265e-07 0.00021 2.430353062406265e-07 0 2.430353062406265e-07 0 2.430453062406265e-07 0.00021 2.430553062406265e-07 0 2.430553062406265e-07 0 2.4306530624062653e-07 0.00021 2.4307530624062655e-07 0 2.4307530624062655e-07 0 2.4308530624062656e-07 0.00021 2.4309530624062657e-07 0 2.4309530624062657e-07 0 2.431053062406266e-07 0.00021 2.431153062406266e-07 0 2.431153062406266e-07 0 2.431253062406266e-07 0.00021 2.431353062406266e-07 0 2.431353062406266e-07 0 2.431453062406266e-07 0.00021 2.4315530624062664e-07 0 2.4315530624062664e-07 0 2.4316530624062665e-07 0.00021 2.4317530624062666e-07 0 2.4317530624062666e-07 0 2.4318530624062667e-07 0.00021 2.431953062406267e-07 0 2.431953062406267e-07 0 2.432053062406267e-07 0.00021 2.432153062406267e-07 0 2.432153062406267e-07 0 2.432253062406267e-07 0.00021 2.4323530624062673e-07 0 2.4324429109588784e-07 0 2.4325429109588785e-07 0.00021 2.4326429109588786e-07 0 2.4326429109588786e-07 0 2.4327429109588787e-07 0.00021 2.432842910958879e-07 0 2.433090822418292e-07 0 2.433190822418292e-07 0.00021 2.4332908224182923e-07 0 2.4332908224182923e-07 0 2.4333908224182924e-07 0.00021 2.4334908224182925e-07 0 2.4334908224182925e-07 0 2.4335908224182926e-07 0.00021 2.433690822418293e-07 0 2.433690822418293e-07 0 2.433790822418293e-07 0.00021 2.433890822418293e-07 0 2.433890822418293e-07 0 2.433990822418293e-07 0.00021 2.434090822418293e-07 0 2.434090822418293e-07 0 2.4341908224182933e-07 0.00021 2.4342908224182934e-07 0 2.4342908224182934e-07 0 2.4343908224182936e-07 0.00021 2.4344908224182937e-07 0 2.4344908224182937e-07 0 2.434590822418294e-07 0.00021 2.434690822418294e-07 0 2.434690822418294e-07 0 2.434790822418294e-07 0.00021 2.434890822418294e-07 0 2.434890822418294e-07 0 2.434990822418294e-07 0.00021 2.4350908224182943e-07 0 2.435334139929834e-07 0 2.435434139929834e-07 0.00021 2.435534139929834e-07 0 2.4357337193750194e-07 0 2.4358337193750196e-07 0.00021 2.4359337193750197e-07 0 2.4360404635065936e-07 0 2.4361404635065937e-07 0.00021 2.436240463506594e-07 0 2.4362684468363087e-07 0 2.436368446836309e-07 0.00021 2.436468446836309e-07 0 2.436468446836309e-07 0 2.436568446836309e-07 0.00021 2.436668446836309e-07 0 2.436668446836309e-07 0 2.4367684468363093e-07 0.00021 2.4368684468363094e-07 0 2.4368684468363094e-07 0 2.4369684468363095e-07 0.00021 2.4370684468363096e-07 0 2.43745623183768e-07 0 2.43755623183768e-07 0.00021 2.43765623183768e-07 0 2.4378510371908117e-07 0 2.437951037190812e-07 0.00021 2.438051037190812e-07 0 2.438213007795343e-07 0 2.438313007795343e-07 0.00021 2.438413007795343e-07 0 2.4385440738329946e-07 0 2.4386440738329947e-07 0.00021 2.438744073832995e-07 0 2.439001794637721e-07 0 2.439101794637721e-07 0.00021 2.4392017946377213e-07 0 2.4392017946377213e-07 0 2.4393017946377214e-07 0.00021 2.4394017946377215e-07 0 2.4394017946377215e-07 0 2.4395017946377216e-07 0.00021 2.439601794637722e-07 0 2.439729180966676e-07 0 2.439829180966676e-07 0.00021 2.4399291809666764e-07 0 2.4404982458803956e-07 0 2.440598245880396e-07 0.00021 2.440698245880396e-07 0 2.4407096345268367e-07 0 2.440809634526837e-07 0.00021 2.440909634526837e-07 0 2.440909634526837e-07 0 2.441009634526837e-07 0.00021 2.441109634526837e-07 0 2.4411969749357537e-07 0 2.441296974935754e-07 0.00021 2.441396974935754e-07 0 2.441422637627274e-07 0 2.441522637627274e-07 0.00021 2.4416226376272743e-07 0 2.441809206922769e-07 0 2.441909206922769e-07 0.00021 2.4420092069227694e-07 0 2.4421584310551744e-07 0 2.4422584310551745e-07 0.00021 2.4423584310551747e-07 0 2.4425273897139476e-07 0 2.4426273897139477e-07 0.00021 2.442727389713948e-07 0 2.443563371672589e-07 0 2.443663371672589e-07 0.00021 2.443763371672589e-07 0 2.444820682957249e-07 0 2.444920682957249e-07 0.00021 2.445020682957249e-07 0 2.445020682957249e-07 0 2.445120682957249e-07 0.00021 2.4452206829572494e-07 0 2.4452206829572494e-07 0 2.4453206829572495e-07 0.00021 2.4454206829572496e-07 0 2.4454206829572496e-07 0 2.4455206829572497e-07 0.00021 2.44562068295725e-07 0 2.44562068295725e-07 0 2.44572068295725e-07 0.00021 2.44582068295725e-07 0 2.44582068295725e-07 0 2.44592068295725e-07 0.00021 2.4460206829572503e-07 0 2.4460206829572503e-07 0 2.4461206829572504e-07 0.00021 2.4462206829572505e-07 0 2.4462206829572505e-07 0 2.4463206829572506e-07 0.00021 2.4464206829572507e-07 0 2.4464206829572507e-07 0 2.446520682957251e-07 0.00021 2.446620682957251e-07 0 2.446620682957251e-07 0 2.446720682957251e-07 0.00021 2.446820682957251e-07 0 2.446820682957251e-07 0 2.4469206829572513e-07 0.00021 2.4470206829572514e-07 0 2.4470206829572514e-07 0 2.4471206829572515e-07 0.00021 2.4472206829572516e-07 0 2.4472206829572516e-07 0 2.447320682957252e-07 0.00021 2.447420682957252e-07 0 2.447593674910852e-07 0 2.447693674910852e-07 0.00021 2.447793674910852e-07 0 2.4495435251034565e-07 0 2.4496435251034566e-07 0.00021 2.449743525103457e-07 0 2.450916650446782e-07 0 2.4510166504467823e-07 0.00021 2.4511166504467824e-07 0 2.4511166504467824e-07 0 2.4512166504467825e-07 0.00021 2.4513166504467826e-07 0 2.451705692502158e-07 0 2.4518056925021584e-07 0.00021 2.4519056925021585e-07 0 2.4524837808238533e-07 0 2.4525837808238534e-07 0.00021 2.4526837808238535e-07 0 2.454535879388207e-07 0 2.4546358793882074e-07 0.00021 2.4547358793882075e-07 0 2.4549089762778576e-07 0 2.4550089762778577e-07 0.00021 2.455108976277858e-07 0 2.4552279297736655e-07 0 2.4553279297736656e-07 0.00021 2.4554279297736657e-07 0 2.455451693752966e-07 0 2.455551693752966e-07 0.00021 2.4556516937529663e-07 0 2.4557877861008667e-07 0 2.455887786100867e-07 0.00021 2.455987786100867e-07 0 2.455987786100867e-07 0 2.456087786100867e-07 0.00021 2.456187786100867e-07 0 2.456187786100867e-07 0 2.4562877861008673e-07 0.00021 2.4563877861008674e-07 0 2.4565920810808456e-07 0 2.4566920810808457e-07 0.00021 2.456792081080846e-07 0 2.456792081080846e-07 0 2.456892081080846e-07 0.00021 2.456992081080846e-07 0 2.456992081080846e-07 0 2.457092081080846e-07 0.00021 2.457192081080846e-07 0 2.457192081080846e-07 0 2.4572920810808464e-07 0.00021 2.4573920810808465e-07 0 2.4573920810808465e-07 0 2.4574920810808466e-07 0.00021 2.4575920810808467e-07 0 2.457713183079427e-07 0 2.4578131830794273e-07 0.00021 2.4579131830794274e-07 0 2.4579131830794274e-07 0 2.4580131830794275e-07 0.00021 2.4581131830794276e-07 0 2.4581131830794276e-07 0 2.458213183079428e-07 0.00021 2.458313183079428e-07 0 2.458313183079428e-07 0 2.458413183079428e-07 0.00021 2.458513183079428e-07 0 2.458513183079428e-07 0 2.458613183079428e-07 0.00021 2.4587131830794283e-07 0 2.4587131830794283e-07 0 2.4588131830794284e-07 0.00021 2.4589131830794285e-07 0 2.4589131830794285e-07 0 2.4590131830794287e-07 0.00021 2.459113183079429e-07 0 2.4593619173051964e-07 0 2.4594619173051965e-07 0.00021 2.4595619173051966e-07 0 2.459759915513475e-07 0 2.459859915513475e-07 0.00021 2.4599599155134753e-07 0 2.4599599155134753e-07 0 2.4600599155134754e-07 0.00021 2.4601599155134755e-07 0 2.4601599155134755e-07 0 2.4602599155134757e-07 0.00021 2.460359915513476e-07 0 2.460359915513476e-07 0 2.460459915513476e-07 0.00021 2.460559915513476e-07 0 2.460559915513476e-07 0 2.460659915513476e-07 0.00021 2.460759915513476e-07 0 2.460759915513476e-07 0 2.4608599155134763e-07 0.00021 2.4609599155134764e-07 0 2.4609599155134764e-07 0 2.4610599155134766e-07 0.00021 2.4611599155134767e-07 0 2.4611599155134767e-07 0 2.461259915513477e-07 0.00021 2.461359915513477e-07 0 2.461359915513477e-07 0 2.461459915513477e-07 0.00021 2.461559915513477e-07 0 2.4618493590536494e-07 0 2.4619493590536495e-07 0.00021 2.4620493590536496e-07 0 2.462172356027936e-07 0 2.462272356027936e-07 0.00021 2.4623723560279363e-07 0 2.462491989936654e-07 0 2.462591989936654e-07 0.00021 2.462691989936654e-07 0 2.462691989936654e-07 0 2.462791989936654e-07 0.00021 2.4628919899366543e-07 0 2.4628919899366543e-07 0 2.4629919899366545e-07 0.00021 2.4630919899366546e-07 0 2.4630919899366546e-07 0 2.4631919899366547e-07 0.00021 2.463291989936655e-07 0 2.463291989936655e-07 0 2.463391989936655e-07 0.00021 2.463491989936655e-07 0 2.463491989936655e-07 0 2.463591989936655e-07 0.00021 2.463691989936655e-07 0 2.463691989936655e-07 0 2.4637919899366554e-07 0.00021 2.4638919899366555e-07 0 2.4638919899366555e-07 0 2.4639919899366556e-07 0.00021 2.4640919899366557e-07 0 2.4640919899366557e-07 0 2.464191989936656e-07 0.00021 2.464291989936656e-07 0 2.464291989936656e-07 0 2.464391989936656e-07 0.00021 2.464491989936656e-07 0 2.464491989936656e-07 0 2.4645919899366563e-07 0.00021 2.4646919899366564e-07 0 2.4646919899366564e-07 0 2.4647919899366565e-07 0.00021 2.4648919899366566e-07 0 2.4648919899366566e-07 0 2.4649919899366567e-07 0.00021 2.465091989936657e-07 0 2.465913017560721e-07 0 2.466013017560721e-07 0.00021 2.466113017560721e-07 0 2.466666263944491e-07 0 2.4667662639444913e-07 0.00021 2.4668662639444915e-07 0 2.4668662639444915e-07 0 2.4669662639444916e-07 0.00021 2.4670662639444917e-07 0 2.4670662639444917e-07 0 2.467166263944492e-07 0.00021 2.467266263944492e-07 0 2.467266263944492e-07 0 2.467366263944492e-07 0.00021 2.467466263944492e-07 0 2.467564553498247e-07 0 2.467664553498247e-07 0.00021 2.467764553498247e-07 0 2.467764553498247e-07 0 2.467864553498247e-07 0.00021 2.4679645534982473e-07 0 2.4680098732978973e-07 0 2.4681098732978974e-07 0.00021 2.4682098732978975e-07 0 2.4682098732978975e-07 0 2.4683098732978976e-07 0.00021 2.468409873297898e-07 0 2.468409873297898e-07 0 2.468509873297898e-07 0.00021 2.468609873297898e-07 0 2.468609873297898e-07 0 2.468709873297898e-07 0.00021 2.468809873297898e-07 0 2.4690255996294585e-07 0 2.4691255996294586e-07 0.00021 2.4692255996294587e-07 0 2.4692255996294587e-07 0 2.469325599629459e-07 0.00021 2.469425599629459e-07 0 2.469425599629459e-07 0 2.469525599629459e-07 0.00021 2.469625599629459e-07 0 2.4696896932903605e-07 0 2.4697896932903606e-07 0.00021 2.4698896932903607e-07 0 2.4698896932903607e-07 0 2.469989693290361e-07 0.00021 2.470089693290361e-07 0 2.4701408504300967e-07 0 2.470240850430097e-07 0.00021 2.470340850430097e-07 0 2.4707848105833633e-07 0 2.4708848105833634e-07 0.00021 2.4709848105833635e-07 0 2.471287456310142e-07 0 2.471387456310142e-07 0.00021 2.4714874563101423e-07 0 2.4714874563101423e-07 0 2.4715874563101424e-07 0.00021 2.4716874563101425e-07 0 2.4719775604083806e-07 0 2.4720775604083807e-07 0.00021 2.472177560408381e-07 0 2.472210235489413e-07 0 2.4723102354894133e-07 0.00021 2.4724102354894134e-07 0 2.4724102354894134e-07 0 2.4725102354894135e-07 0.00021 2.4726102354894136e-07 0 2.472725796931462e-07 0 2.4728257969314624e-07 0.00021 2.4729257969314625e-07 0 2.4738998484942914e-07 0 2.4739998484942915e-07 0.00021 2.4740998484942916e-07 0 2.474971342732982e-07 0 2.475071342732982e-07 0.00021 2.475171342732982e-07 0 2.475297557808272e-07 0 2.4753975578082723e-07 0.00021 2.4754975578082724e-07 0 2.4756622244375976e-07 0 2.4757622244375977e-07 0.00021 2.475862224437598e-07 0 2.4763094407328056e-07 0 2.476409440732806e-07 0.00021 2.476509440732806e-07 0 2.476747124189819e-07 0 2.4768471241898193e-07 0.00021 2.4769471241898195e-07 0 2.4773682460225e-07 0 2.4774682460225e-07 0.00021 2.4775682460225e-07 0 2.4775682460225e-07 0 2.4776682460225003e-07 0.00021 2.4777682460225004e-07 0 2.4777682460225004e-07 0 2.4778682460225005e-07 0.00021 2.4779682460225006e-07 0 2.4788918179454943e-07 0 2.4789918179454945e-07 0.00021 2.4790918179454946e-07 0 2.4790918179454946e-07 0 2.4791918179454947e-07 0.00021 2.479291817945495e-07 0 2.4795303412873317e-07 0 2.479630341287332e-07 0.00021 2.479730341287332e-07 0 2.480448464420349e-07 0 2.480548464420349e-07 0.00021 2.480648464420349e-07 0 2.480648464420349e-07 0 2.480748464420349e-07 0.00021 2.4808484644203493e-07 0 2.4808484644203493e-07 0 2.4809484644203494e-07 0.00021 2.4810484644203495e-07 0 2.4810484644203495e-07 0 2.4811484644203496e-07 0.00021 2.48124846442035e-07 0 2.48124846442035e-07 0 2.48134846442035e-07 0.00021 2.48144846442035e-07 0 2.48144846442035e-07 0 2.48154846442035e-07 0.00021 2.48164846442035e-07 0 2.4817544914919913e-07 0 2.4818544914919915e-07 0.00021 2.4819544914919916e-07 0 2.4823643503469414e-07 0 2.4824643503469415e-07 0.00021 2.4825643503469416e-07 0 2.483038505854074e-07 0 2.483138505854074e-07 0.00021 2.483238505854074e-07 0 2.4836619801353566e-07 0 2.4837619801353567e-07 0.00021 2.483861980135357e-07 0 2.483861980135357e-07 0 2.483961980135357e-07 0.00021 2.484061980135357e-07 0 2.484061980135357e-07 0 2.484161980135357e-07 0.00021 2.484261980135357e-07 0 2.484261980135357e-07 0 2.4843619801353574e-07 0.00021 2.4844619801353575e-07 0 2.4844619801353575e-07 0 2.4845619801353576e-07 0.00021 2.4846619801353577e-07 0 2.4846619801353577e-07 0 2.484761980135358e-07 0.00021 2.484861980135358e-07 0 2.484861980135358e-07 0 2.484961980135358e-07 0.00021 2.485061980135358e-07 0 2.4851159456159137e-07 0 2.485215945615914e-07 0.00021 2.485315945615914e-07 0 2.485315945615914e-07 0 2.485415945615914e-07 0.00021 2.485515945615914e-07 0 2.485515945615914e-07 0 2.4856159456159143e-07 0.00021 2.4857159456159144e-07 0 2.4863757532062746e-07 0 2.4864757532062747e-07 0.00021 2.486575753206275e-07 0 2.486575753206275e-07 0 2.486675753206275e-07 0.00021 2.486775753206275e-07 0 2.486775753206275e-07 0 2.486875753206275e-07 0.00021 2.4869757532062753e-07 0 2.4870786736872514e-07 0 2.4871786736872515e-07 0.00021 2.4872786736872516e-07 0 2.4872786736872516e-07 0 2.487378673687252e-07 0.00021 2.487478673687252e-07 0 2.4880054666430706e-07 0 2.4881054666430707e-07 0.00021 2.488205466643071e-07 0 2.488205466643071e-07 0 2.488305466643071e-07 0.00021 2.488405466643071e-07 0 2.488405466643071e-07 0 2.488505466643071e-07 0.00021 2.488605466643071e-07 0 2.488605466643071e-07 0 2.4887054666430714e-07 0.00021 2.4888054666430715e-07 0 2.4888054666430715e-07 0 2.4889054666430716e-07 0.00021 2.4890054666430717e-07 0 2.489432321013755e-07 0 2.4895323210137554e-07 0.00021 2.4896323210137555e-07 0 2.4896323210137555e-07 0 2.4897323210137556e-07 0.00021 2.4898323210137557e-07 0 2.489923399478584e-07 0 2.4900233994785844e-07 0.00021 2.4901233994785845e-07 0 2.4901233994785845e-07 0 2.4902233994785846e-07 0.00021 2.4903233994785847e-07 0 2.4903233994785847e-07 0 2.490423399478585e-07 0.00021 2.490523399478585e-07 0 2.490692217570832e-07 0 2.490792217570832e-07 0.00021 2.4908922175708323e-07 0 2.491512677367976e-07 0 2.491612677367976e-07 0.00021 2.4917126773679764e-07 0 2.4917126773679764e-07 0 2.4918126773679765e-07 0.00021 2.4919126773679766e-07 0 2.491970485873038e-07 0 2.492070485873038e-07 0.00021 2.4921704858730384e-07 0 2.4921704858730384e-07 0 2.4922704858730385e-07 0.00021 2.4923704858730386e-07 0 2.4924816781690224e-07 0 2.4925816781690226e-07 0.00021 2.4926816781690227e-07 0 2.4926816781690227e-07 0 2.492781678169023e-07 0.00021 2.492881678169023e-07 0 2.492881678169023e-07 0 2.492981678169023e-07 0.00021 2.493081678169023e-07 0 2.493081678169023e-07 0 2.493181678169023e-07 0.00021 2.4932816781690234e-07 0 2.4937145197627375e-07 0 2.4938145197627376e-07 0.00021 2.4939145197627377e-07 0 2.4939145197627377e-07 0 2.494014519762738e-07 0.00021 2.494114519762738e-07 0 2.494114519762738e-07 0 2.494214519762738e-07 0.00021 2.494314519762738e-07 0 2.494507143201927e-07 0 2.494607143201927e-07 0.00021 2.494707143201927e-07 0 2.494707143201927e-07 0 2.494807143201927e-07 0.00021 2.4949071432019274e-07 0 2.4949071432019274e-07 0 2.4950071432019275e-07 0.00021 2.4951071432019276e-07 0 2.4951071432019276e-07 0 2.4952071432019277e-07 0.00021 2.495307143201928e-07 0 2.495307143201928e-07 0 2.495407143201928e-07 0.00021 2.495507143201928e-07 0 2.4962492008714025e-07 0 2.4963492008714026e-07 0.00021 2.4964492008714027e-07 0 2.4975237913359237e-07 0 2.497623791335924e-07 0.00021 2.497723791335924e-07 0 2.497723791335924e-07 0 2.497823791335924e-07 0.00021 2.497923791335924e-07 0 2.497923791335924e-07 0 2.498023791335924e-07 0.00021 2.4981237913359243e-07 0 2.4981237913359243e-07 0 2.4982237913359245e-07 0.00021 2.4983237913359246e-07 0 2.4983237913359246e-07 0 2.4984237913359247e-07 0.00021 2.498523791335925e-07 0 2.498523791335925e-07 0 2.498623791335925e-07 0.00021 2.498723791335925e-07 0 2.499613762517941e-07 0 2.499713762517941e-07 0.00021 2.4998137625179413e-07 0 2.500343645244723e-07 0 2.500443645244723e-07 0.00021 2.500543645244723e-07 0 2.500543645244723e-07 0 2.500643645244723e-07 0.00021 2.5007436452447234e-07 0 2.5007436452447234e-07 0 2.5008436452447235e-07 0.00021 2.5009436452447236e-07 0 2.5009436452447236e-07 0 2.5010436452447237e-07 0.00021 2.501143645244724e-07 0 2.5012865500479476e-07 0 2.5013865500479477e-07 0.00021 2.501486550047948e-07 0 2.501846154015603e-07 0 2.501946154015603e-07 0.00021 2.5020461540156034e-07 0 2.502700292204753e-07 0 2.502800292204753e-07 0.00021 2.502900292204753e-07 0 2.502953262247298e-07 0 2.503053262247298e-07 0.00021 2.503153262247298e-07 0 2.5033507044831676e-07 0 2.503450704483168e-07 0.00021 2.503550704483168e-07 0 2.503550704483168e-07 0 2.503650704483168e-07 0.00021 2.503750704483168e-07 0 2.503750704483168e-07 0 2.503850704483168e-07 0.00021 2.5039507044831683e-07 0 2.5039507044831683e-07 0 2.5040507044831684e-07 0.00021 2.5041507044831686e-07 0 2.5041507044831686e-07 0 2.5042507044831687e-07 0.00021 2.504350704483169e-07 0 2.504566176666951e-07 0 2.5046661766669514e-07 0.00021 2.5047661766669515e-07 0 2.505019832783793e-07 0 2.505119832783793e-07 0.00021 2.505219832783793e-07 0 2.5057528966258726e-07 0 2.5058528966258727e-07 0.00021 2.505952896625873e-07 0 2.505952896625873e-07 0 2.506052896625873e-07 0.00021 2.506152896625873e-07 0 2.5062176144823987e-07 0 2.506317614482399e-07 0.00021 2.506417614482399e-07 0 2.506417614482399e-07 0 2.506517614482399e-07 0.00021 2.506617614482399e-07 0 2.507123007553607e-07 0 2.5072230075536073e-07 0.00021 2.5073230075536074e-07 0 2.5074522959445095e-07 0 2.5075522959445096e-07 0.00021 2.5076522959445097e-07 0 2.5076522959445097e-07 0 2.50775229594451e-07 0.00021 2.50785229594451e-07 0 2.50785229594451e-07 0 2.50795229594451e-07 0.00021 2.50805229594451e-07 0 2.5080751696456025e-07 0 2.5081751696456026e-07 0.00021 2.5082751696456027e-07 0 2.5082751696456027e-07 0 2.508375169645603e-07 0.00021 2.508475169645603e-07 0 2.508475169645603e-07 0 2.508575169645603e-07 0.00021 2.508675169645603e-07 0 2.508675169645603e-07 0 2.5087751696456033e-07 0.00021 2.5088751696456034e-07 0 2.5088751696456034e-07 0 2.5089751696456035e-07 0.00021 2.5090751696456036e-07 0 2.5093511196676073e-07 0 2.5094511196676074e-07 0.00021 2.5095511196676076e-07 0 2.5095511196676076e-07 0 2.5096511196676077e-07 0.00021 2.509751119667608e-07 0 2.509751119667608e-07 0 2.509851119667608e-07 0.00021 2.509951119667608e-07 0 2.509951119667608e-07 0 2.510051119667608e-07 0.00021 2.510151119667608e-07 0 2.510151119667608e-07 0 2.5102511196676083e-07 0.00021 2.5103511196676085e-07 0 2.5103511196676085e-07 0 2.5104511196676086e-07 0.00021 2.5105511196676087e-07 0 2.5107447057546037e-07 0 2.510844705754604e-07 0.00021 2.510944705754604e-07 0 2.510944705754604e-07 0 2.511044705754604e-07 0.00021 2.511144705754604e-07 0 2.5112063036646414e-07 0 2.5113063036646415e-07 0.00021 2.5114063036646417e-07 0 2.511989767583995e-07 0 2.512089767583995e-07 0.00021 2.512189767583995e-07 0 2.512189767583995e-07 0 2.512289767583995e-07 0.00021 2.5123897675839954e-07 0 2.5130579579942883e-07 0 2.5131579579942884e-07 0.00021 2.5132579579942886e-07 0 2.514418445661981e-07 0 2.514518445661981e-07 0.00021 2.5146184456619814e-07 0 2.5146184456619814e-07 0 2.5147184456619815e-07 0.00021 2.5148184456619816e-07 0 2.5149475595812574e-07 0 2.5150475595812575e-07 0.00021 2.5151475595812576e-07 0 2.515152235413124e-07 0 2.515252235413124e-07 0.00021 2.515352235413124e-07 0 2.5158040144671094e-07 0 2.5159040144671095e-07 0.00021 2.5160040144671096e-07 0 2.5160040144671096e-07 0 2.51610401446711e-07 0.00021 2.51620401446711e-07 0 2.5162589429740663e-07 0 2.5163589429740664e-07 0.00021 2.5164589429740665e-07 0 2.516603912328573e-07 0 2.516703912328573e-07 0.00021 2.5168039123285733e-07 0 2.5168039123285733e-07 0 2.5169039123285734e-07 0.00021 2.5170039123285735e-07 0 2.5170039123285735e-07 0 2.5171039123285736e-07 0.00021 2.5172039123285737e-07 0 2.5172039123285737e-07 0 2.517303912328574e-07 0.00021 2.517403912328574e-07 0 2.517403912328574e-07 0 2.517503912328574e-07 0.00021 2.517603912328574e-07 0 2.517603912328574e-07 0 2.5177039123285743e-07 0.00021 2.5178039123285744e-07 0 2.5178039123285744e-07 0 2.5179039123285745e-07 0.00021 2.5180039123285746e-07 0 2.5180039123285746e-07 0 2.518103912328575e-07 0.00021 2.518203912328575e-07 0 2.518203912328575e-07 0 2.518303912328575e-07 0.00021 2.518403912328575e-07 0 2.518409196565113e-07 0 2.5185091965651133e-07 0.00021 2.5186091965651134e-07 0 2.5191216776543504e-07 0 2.5192216776543506e-07 0.00021 2.5193216776543507e-07 0 2.519633544154248e-07 0 2.519733544154248e-07 0.00021 2.519833544154248e-07 0 2.520244160549079e-07 0 2.520344160549079e-07 0.00021 2.520444160549079e-07 0 2.520444160549079e-07 0 2.520544160549079e-07 0.00021 2.5206441605490793e-07 0 2.5214871922872585e-07 0 2.5215871922872586e-07 0.00021 2.5216871922872587e-07 0 2.522589338994233e-07 0 2.5226893389942333e-07 0.00021 2.5227893389942334e-07 0 2.522817366671548e-07 0 2.522917366671548e-07 0.00021 2.523017366671548e-07 0 2.523017366671548e-07 0 2.523117366671548e-07 0.00021 2.5232173666715483e-07 0 2.5232173666715483e-07 0 2.5233173666715484e-07 0.00021 2.5234173666715485e-07 0 2.5234173666715485e-07 0 2.5235173666715486e-07 0.00021 2.523617366671549e-07 0 2.523617366671549e-07 0 2.523717366671549e-07 0.00021 2.523817366671549e-07 0 2.524566206927476e-07 0 2.524666206927476e-07 0.00021 2.524766206927476e-07 0 2.525318955875373e-07 0 2.525418955875373e-07 0.00021 2.525518955875373e-07 0 2.52560398339973e-07 0 2.5257039833997304e-07 0.00021 2.5258039833997305e-07 0 2.5259161335609486e-07 0 2.526016133560949e-07 0.00021 2.526116133560949e-07 0 2.526116133560949e-07 0 2.526216133560949e-07 0.00021 2.526316133560949e-07 0 2.526316133560949e-07 0 2.526416133560949e-07 0.00021 2.5265161335609493e-07 0 2.5265161335609493e-07 0 2.5266161335609494e-07 0.00021 2.5267161335609495e-07 0 2.5267161335609495e-07 0 2.5268161335609497e-07 0.00021 2.52691613356095e-07 0 2.52691613356095e-07 0 2.52701613356095e-07 0.00021 2.52711613356095e-07 0 2.52711613356095e-07 0 2.52721613356095e-07 0.00021 2.52731613356095e-07 0 2.52731613356095e-07 0 2.5274161335609503e-07 0.00021 2.5275161335609504e-07 0 2.5275161335609504e-07 0 2.5276161335609506e-07 0.00021 2.5277161335609507e-07 0 2.527823634668396e-07 0 2.527923634668396e-07 0.00021 2.528023634668396e-07 0 2.528023634668396e-07 0 2.528123634668396e-07 0.00021 2.528223634668396e-07 0 2.528223634668396e-07 0 2.5283236346683963e-07 0.00021 2.5284236346683964e-07 0 2.5284236346683964e-07 0 2.5285236346683965e-07 0.00021 2.5286236346683967e-07 0 2.5286236346683967e-07 0 2.528723634668397e-07 0.00021 2.528823634668397e-07 0 2.5288280235676734e-07 0 2.5289280235676735e-07 0.00021 2.5290280235676736e-07 0 2.5290280235676736e-07 0 2.5291280235676737e-07 0.00021 2.529228023567674e-07 0 2.529228023567674e-07 0 2.529328023567674e-07 0.00021 2.529428023567674e-07 0 2.529428023567674e-07 0 2.529528023567674e-07 0.00021 2.5296280235676743e-07 0 2.5296280235676743e-07 0 2.5297280235676744e-07 0.00021 2.5298280235676745e-07 0 2.5299147235756663e-07 0 2.5300147235756664e-07 0.00021 2.5301147235756665e-07 0 2.5315916051727995e-07 0 2.5316916051727996e-07 0.00021 2.5317916051727997e-07 0 2.5317916051727997e-07 0 2.5318916051728e-07 0.00021 2.5319916051728e-07 0 2.5319916051728e-07 0 2.5320916051728e-07 0.00021 2.5321916051728e-07 0 2.5321916051728e-07 0 2.5322916051728e-07 0.00021 2.5323916051728004e-07 0 2.5323916051728004e-07 0 2.5324916051728005e-07 0.00021 2.5325916051728006e-07 0 2.5325916051728006e-07 0 2.5326916051728007e-07 0.00021 2.532791605172801e-07 0 2.532791605172801e-07 0 2.532891605172801e-07 0.00021 2.532991605172801e-07 0 2.532991605172801e-07 0 2.533091605172801e-07 0.00021 2.5331916051728013e-07 0 2.5331916051728013e-07 0 2.5332916051728014e-07 0.00021 2.5333916051728015e-07 0 2.5333916051728015e-07 0 2.5334916051728016e-07 0.00021 2.5335916051728017e-07 0 2.5335916051728017e-07 0 2.533691605172802e-07 0.00021 2.533791605172802e-07 0 2.533791605172802e-07 0 2.533891605172802e-07 0.00021 2.533991605172802e-07 0 2.533991605172802e-07 0 2.5340916051728023e-07 0.00021 2.5341916051728024e-07 0 2.5341916051728024e-07 0 2.5342916051728025e-07 0.00021 2.5343916051728026e-07 0 2.5343916051728026e-07 0 2.534491605172803e-07 0.00021 2.534591605172803e-07 0 2.534591605172803e-07 0 2.534691605172803e-07 0.00021 2.534791605172803e-07 0 2.5350283587224255e-07 0 2.5351283587224257e-07 0.00021 2.535228358722426e-07 0 2.5355817439276716e-07 0 2.5356817439276717e-07 0.00021 2.535781743927672e-07 0 2.536294305880799e-07 0 2.536394305880799e-07 0.00021 2.5364943058807994e-07 0 2.5367553565160925e-07 0 2.5368553565160926e-07 0.00021 2.5369553565160927e-07 0 2.5369553565160927e-07 0 2.537055356516093e-07 0.00021 2.537155356516093e-07 0 2.5377874452039024e-07 0 2.5378874452039025e-07 0.00021 2.5379874452039026e-07 0 2.5379874452039026e-07 0 2.5380874452039027e-07 0.00021 2.538187445203903e-07 0 2.538187445203903e-07 0 2.538287445203903e-07 0.00021 2.538387445203903e-07 0 2.538414130265188e-07 0 2.538514130265188e-07 0.00021 2.538614130265188e-07 0 2.538614130265188e-07 0 2.5387141302651883e-07 0.00021 2.5388141302651884e-07 0 2.5388141302651884e-07 0 2.5389141302651885e-07 0.00021 2.5390141302651886e-07 0 2.5390141302651886e-07 0 2.5391141302651887e-07 0.00021 2.539214130265189e-07 0 2.539520777304588e-07 0 2.539620777304588e-07 0.00021 2.5397207773045883e-07 0 2.5402602710193776e-07 0 2.5403602710193777e-07 0.00021 2.540460271019378e-07 0 2.540460271019378e-07 0 2.540560271019378e-07 0.00021 2.540660271019378e-07 0 2.540660271019378e-07 0 2.540760271019378e-07 0.00021 2.5408602710193783e-07 0 2.5408602710193783e-07 0 2.5409602710193784e-07 0.00021 2.5410602710193785e-07 0 2.5410602710193785e-07 0 2.5411602710193786e-07 0.00021 2.541260271019379e-07 0 2.541260271019379e-07 0 2.541360271019379e-07 0.00021 2.541460271019379e-07 0 2.541460271019379e-07 0 2.541560271019379e-07 0.00021 2.541660271019379e-07 0 2.541789775922743e-07 0 2.541889775922743e-07 0.00021 2.541989775922743e-07 0 2.541989775922743e-07 0 2.5420897759227433e-07 0.00021 2.5421897759227435e-07 0 2.5421897759227435e-07 0 2.5422897759227436e-07 0.00021 2.5423897759227437e-07 0 2.5423897759227437e-07 0 2.542489775922744e-07 0.00021 2.542589775922744e-07 0 2.542589775922744e-07 0 2.542689775922744e-07 0.00021 2.542789775922744e-07 0 2.542789775922744e-07 0 2.542889775922744e-07 0.00021 2.5429897759227444e-07 0 2.5429897759227444e-07 0 2.5430897759227445e-07 0.00021 2.5431897759227446e-07 0 2.5438800778894424e-07 0 2.5439800778894425e-07 0.00021 2.5440800778894426e-07 0 2.5440800778894426e-07 0 2.5441800778894427e-07 0.00021 2.544280077889443e-07 0 2.544280077889443e-07 0 2.544380077889443e-07 0.00021 2.544480077889443e-07 0 2.544480077889443e-07 0 2.544580077889443e-07 0.00021 2.544680077889443e-07 0 2.544680077889443e-07 0 2.5447800778894434e-07 0.00021 2.5448800778894435e-07 0 2.5448800778894435e-07 0 2.5449800778894436e-07 0.00021 2.5450800778894437e-07 0 2.5450800778894437e-07 0 2.545180077889444e-07 0.00021 2.545280077889444e-07 0 2.5454670324328816e-07 0 2.5455670324328817e-07 0.00021 2.545667032432882e-07 0 2.545779698466444e-07 0 2.545879698466444e-07 0.00021 2.5459796984664443e-07 0 2.5459796984664443e-07 0 2.5460796984664444e-07 0.00021 2.5461796984664445e-07 0 2.5462801127885466e-07 0 2.546380112788547e-07 0.00021 2.546480112788547e-07 0 2.546577325587598e-07 0 2.546677325587598e-07 0.00021 2.546777325587598e-07 0 2.546777325587598e-07 0 2.5468773255875983e-07 0.00021 2.5469773255875984e-07 0 2.5469773255875984e-07 0 2.5470773255875986e-07 0.00021 2.5471773255875987e-07 0 2.5471773255875987e-07 0 2.547277325587599e-07 0.00021 2.547377325587599e-07 0 2.547377325587599e-07 0 2.547477325587599e-07 0.00021 2.547577325587599e-07 0 2.547577325587599e-07 0 2.547677325587599e-07 0.00021 2.5477773255875994e-07 0 2.5477773255875994e-07 0 2.5478773255875995e-07 0.00021 2.5479773255875996e-07 0 2.5479773255875996e-07 0 2.5480773255875997e-07 0.00021 2.5481773255876e-07 0 2.5481773255876e-07 0 2.5482773255876e-07 0.00021 2.5483773255876e-07 0 2.548609083609645e-07 0 2.5487090836096454e-07 0.00021 2.5488090836096455e-07 0 2.549523207367449e-07 0 2.549623207367449e-07 0.00021 2.5497232073674493e-07 0 2.549859328075638e-07 0 2.549959328075638e-07 0.00021 2.550059328075638e-07 0 2.550554770226611e-07 0 2.550654770226611e-07 0.00021 2.5507547702266113e-07 0 2.5507547702266113e-07 0 2.5508547702266114e-07 0.00021 2.5509547702266115e-07 0 2.5509547702266115e-07 0 2.5510547702266117e-07 0.00021 2.551154770226612e-07 0 2.551154770226612e-07 0 2.551254770226612e-07 0.00021 2.551354770226612e-07 0 2.551354770226612e-07 0 2.551454770226612e-07 0.00021 2.551554770226612e-07 0 2.551554770226612e-07 0 2.5516547702266123e-07 0.00021 2.5517547702266124e-07 0 2.55188680233535e-07 0 2.55198680233535e-07 0.00021 2.5520868023353503e-07 0 2.552782896842533e-07 0 2.552882896842533e-07 0.00021 2.5529828968425334e-07 0 2.553210832485859e-07 0 2.553310832485859e-07 0.00021 2.553410832485859e-07 0 2.553410832485859e-07 0 2.5535108324858594e-07 0.00021 2.5536108324858595e-07 0 2.5536108324858595e-07 0 2.5537108324858596e-07 0.00021 2.5538108324858597e-07 0 2.5538108324858597e-07 0 2.55391083248586e-07 0.00021 2.55401083248586e-07 0 2.554076840550557e-07 0 2.554176840550557e-07 0.00021 2.5542768405505573e-07 0 2.5542768405505573e-07 0 2.5543768405505574e-07 0.00021 2.5544768405505576e-07 0 2.5544768405505576e-07 0 2.5545768405505577e-07 0.00021 2.554676840550558e-07 0 2.554676840550558e-07 0 2.554776840550558e-07 0.00021 2.554876840550558e-07 0 2.554876840550558e-07 0 2.554976840550558e-07 0.00021 2.555076840550558e-07 0 2.555076840550558e-07 0 2.5551768405505584e-07 0.00021 2.5552768405505585e-07 0 2.556314868150461e-07 0 2.556414868150461e-07 0.00021 2.556514868150461e-07 0 2.556968932580128e-07 0 2.557068932580128e-07 0.00021 2.557168932580128e-07 0 2.557168932580128e-07 0 2.5572689325801283e-07 0.00021 2.5573689325801284e-07 0 2.5573689325801284e-07 0 2.5574689325801286e-07 0.00021 2.5575689325801287e-07 0 2.5577500389393397e-07 0 2.55785003893934e-07 0.00021 2.55795003893934e-07 0 2.55795003893934e-07 0 2.55805003893934e-07 0.00021 2.55815003893934e-07 0 2.558232485075984e-07 0 2.5583324850759843e-07 0.00021 2.5584324850759844e-07 0 2.5584324850759844e-07 0 2.5585324850759845e-07 0.00021 2.5586324850759846e-07 0 2.5586324850759846e-07 0 2.558732485075985e-07 0.00021 2.558832485075985e-07 0 2.558832485075985e-07 0 2.558932485075985e-07 0.00021 2.559032485075985e-07 0 2.559032485075985e-07 0 2.559132485075985e-07 0.00021 2.5592324850759853e-07 0 2.5592324850759853e-07 0 2.5593324850759854e-07 0.00021 2.5594324850759855e-07 0 2.559804385333783e-07 0 2.559904385333783e-07 0.00021 2.560004385333783e-07 0 2.56005169266997e-07 0 2.56015169266997e-07 0.00021 2.56025169266997e-07 0 2.5611962565420903e-07 0 2.5612962565420904e-07 0.00021 2.5613962565420905e-07 0 2.5613962565420905e-07 0 2.5614962565420906e-07 0.00021 2.561596256542091e-07 0 2.562047305948782e-07 0 2.562147305948782e-07 0.00021 2.5622473059487823e-07 0 2.5622473059487823e-07 0 2.5623473059487824e-07 0.00021 2.5624473059487826e-07 0 2.562466487216946e-07 0 2.5625664872169463e-07 0.00021 2.5626664872169464e-07 0 2.5626664872169464e-07 0 2.5627664872169466e-07 0.00021 2.5628664872169467e-07 0 2.5628664872169467e-07 0 2.562966487216947e-07 0.00021 2.563066487216947e-07 0 2.563436555670838e-07 0 2.563536555670838e-07 0.00021 2.563636555670838e-07 0 2.563765904925362e-07 0 2.563865904925362e-07 0.00021 2.563965904925362e-07 0 2.563965904925362e-07 0 2.5640659049253623e-07 0.00021 2.5641659049253625e-07 0 2.5641659049253625e-07 0 2.5642659049253626e-07 0.00021 2.5643659049253627e-07 0 2.564603782587109e-07 0 2.5647037825871093e-07 0.00021 2.5648037825871094e-07 0 2.565100946247897e-07 0 2.565200946247897e-07 0.00021 2.565300946247897e-07 0 2.565404646282877e-07 0 2.565504646282877e-07 0.00021 2.565604646282877e-07 0 2.565604646282877e-07 0 2.565704646282877e-07 0.00021 2.565804646282877e-07 0 2.565804646282877e-07 0 2.5659046462828773e-07 0.00021 2.5660046462828774e-07 0 2.5663243807143224e-07 0 2.5664243807143225e-07 0.00021 2.5665243807143226e-07 0 2.5665243807143226e-07 0 2.5666243807143227e-07 0.00021 2.566724380714323e-07 0 2.5670467975590813e-07 0 2.5671467975590814e-07 0.00021 2.5672467975590815e-07 0 2.5678104303668693e-07 0 2.5679104303668694e-07 0.00021 2.5680104303668695e-07 0 2.569674728531495e-07 0 2.5697747285314953e-07 0.00021 2.5698747285314955e-07 0 2.5698747285314955e-07 0 2.5699747285314956e-07 0.00021 2.5700747285314957e-07 0 2.5704894586902084e-07 0 2.5705894586902085e-07 0.00021 2.5706894586902086e-07 0 2.5710566452229756e-07 0 2.5711566452229757e-07 0.00021 2.571256645222976e-07 0 2.5718879008962026e-07 0 2.5719879008962027e-07 0.00021 2.572087900896203e-07 0 2.572238697593052e-07 0 2.572338697593052e-07 0.00021 2.572438697593052e-07 0 2.572510376500084e-07 0 2.572610376500084e-07 0.00021 2.572710376500084e-07 0 2.5728337035679885e-07 0 2.5729337035679886e-07 0.00021 2.5730337035679887e-07 0 2.5730337035679887e-07 0 2.573133703567989e-07 0.00021 2.573233703567989e-07 0 2.573233703567989e-07 0 2.573333703567989e-07 0.00021 2.573433703567989e-07 0 2.5736992001664145e-07 0 2.5737992001664146e-07 0.00021 2.573899200166415e-07 0 2.5739302129351376e-07 0 2.5740302129351377e-07 0.00021 2.574130212935138e-07 0 2.5746211150201013e-07 0 2.5747211150201014e-07 0.00021 2.5748211150201015e-07 0 2.574836308122882e-07 0 2.5749363081228824e-07 0.00021 2.5750363081228825e-07 0 2.5750363081228825e-07 0 2.5751363081228826e-07 0.00021 2.5752363081228827e-07 0 2.5752363081228827e-07 0 2.575336308122883e-07 0.00021 2.575436308122883e-07 0 2.575436308122883e-07 0 2.575536308122883e-07 0.00021 2.575636308122883e-07 0 2.575636308122883e-07 0 2.575736308122883e-07 0.00021 2.5758363081228834e-07 0 2.5758363081228834e-07 0 2.5759363081228835e-07 0.00021 2.5760363081228836e-07 0 2.5760363081228836e-07 0 2.5761363081228837e-07 0.00021 2.576236308122884e-07 0 2.576236308122884e-07 0 2.576336308122884e-07 0.00021 2.576436308122884e-07 0 2.576436308122884e-07 0 2.576536308122884e-07 0.00021 2.5766363081228843e-07 0 2.5770933385309004e-07 0 2.5771933385309005e-07 0.00021 2.5772933385309006e-07 0 2.5772933385309006e-07 0 2.5773933385309007e-07 0.00021 2.577493338530901e-07 0 2.577493338530901e-07 0 2.577593338530901e-07 0.00021 2.577693338530901e-07 0 2.57780620463622e-07 0 2.57790620463622e-07 0.00021 2.57800620463622e-07 0 2.578091568000095e-07 0 2.578191568000095e-07 0.00021 2.578291568000095e-07 0 2.578291568000095e-07 0 2.5783915680000954e-07 0.00021 2.5784915680000955e-07 0 2.578536297430334e-07 0 2.5786362974303344e-07 0.00021 2.5787362974303345e-07 0 2.5787362974303345e-07 0 2.5788362974303346e-07 0.00021 2.5789362974303347e-07 0 2.5789965780465073e-07 0 2.5790965780465074e-07 0.00021 2.5791965780465075e-07 0 2.580115441993218e-07 0 2.580215441993218e-07 0.00021 2.580315441993218e-07 0 2.580478912763347e-07 0 2.580578912763347e-07 0.00021 2.580678912763347e-07 0 2.582131913374602e-07 0 2.5822319133746023e-07 0.00021 2.5823319133746024e-07 0 2.582427403825409e-07 0 2.582527403825409e-07 0.00021 2.582627403825409e-07 0 2.582627403825409e-07 0 2.582727403825409e-07 0.00021 2.5828274038254093e-07 0 2.5828274038254093e-07 0 2.5829274038254094e-07 0.00021 2.5830274038254095e-07 0 2.5830274038254095e-07 0 2.5831274038254097e-07 0.00021 2.58322740382541e-07 0 2.58322740382541e-07 0 2.58332740382541e-07 0.00021 2.58342740382541e-07 0 2.5846482459532676e-07 0 2.5847482459532677e-07 0.00021 2.584848245953268e-07 0 2.584978309633296e-07 0 2.5850783096332964e-07 0.00021 2.5851783096332965e-07 0 2.5851783096332965e-07 0 2.5852783096332966e-07 0.00021 2.5853783096332967e-07 0 2.5853783096332967e-07 0 2.585478309633297e-07 0.00021 2.585578309633297e-07 0 2.585578309633297e-07 0 2.585678309633297e-07 0.00021 2.585778309633297e-07 0 2.585778309633297e-07 0 2.5858783096332973e-07 0.00021 2.5859783096332974e-07 0 2.586580655893376e-07 0 2.586680655893376e-07 0.00021 2.5867806558933763e-07 0 2.586856797634557e-07 0 2.5869567976345573e-07 0.00021 2.5870567976345574e-07 0 2.5870567976345574e-07 0 2.5871567976345576e-07 0.00021 2.5872567976345577e-07 0 2.5872567976345577e-07 0 2.587356797634558e-07 0.00021 2.587456797634558e-07 0 2.587456797634558e-07 0 2.587556797634558e-07 0.00021 2.587656797634558e-07 0 2.587656797634558e-07 0 2.587756797634558e-07 0.00021 2.5878567976345583e-07 0 2.5878567976345583e-07 0 2.5879567976345585e-07 0.00021 2.5880567976345586e-07 0 2.5903270175488896e-07 0 2.5904270175488897e-07 0.00021 2.59052701754889e-07 0 2.5906445528540485e-07 0 2.5907445528540486e-07 0.00021 2.5908445528540487e-07 0 2.5908445528540487e-07 0 2.590944552854049e-07 0.00021 2.591044552854049e-07 0 2.591177772953971e-07 0 2.5912777729539713e-07 0.00021 2.5913777729539714e-07 0 2.5914471475700444e-07 0 2.5915471475700445e-07 0.00021 2.5916471475700446e-07 0 2.5925190061997375e-07 0 2.5926190061997377e-07 0.00021 2.592719006199738e-07 0 2.5927455442350093e-07 0 2.5928455442350094e-07 0.00021 2.5929455442350095e-07 0 2.5930808082913205e-07 0 2.5931808082913206e-07 0.00021 2.593280808291321e-07 0 2.593280808291321e-07 0 2.593380808291321e-07 0.00021 2.593480808291321e-07 0 2.593480808291321e-07 0 2.593580808291321e-07 0.00021 2.593680808291321e-07 0 2.593680808291321e-07 0 2.5937808082913213e-07 0.00021 2.5938808082913214e-07 0 2.5938808082913214e-07 0 2.5939808082913215e-07 0.00021 2.5940808082913216e-07 0 2.5940808082913216e-07 0 2.594180808291322e-07 0.00021 2.594280808291322e-07 0 2.5944681918187043e-07 0 2.5945681918187044e-07 0.00021 2.5946681918187045e-07 0 2.5953420757893263e-07 0 2.5954420757893264e-07 0.00021 2.5955420757893265e-07 0 2.5956534682615326e-07 0 2.5957534682615327e-07 0.00021 2.595853468261533e-07 0 2.595853468261533e-07 0 2.595953468261533e-07 0.00021 2.596053468261533e-07 0 2.596053468261533e-07 0 2.596153468261533e-07 0.00021 2.5962534682615333e-07 0 2.5964077216776595e-07 0 2.5965077216776596e-07 0.00021 2.5966077216776597e-07 0 2.596699279392095e-07 0 2.596799279392095e-07 0.00021 2.596899279392095e-07 0 2.5970180463301886e-07 0 2.5971180463301887e-07 0.00021 2.597218046330189e-07 0 2.597243933026826e-07 0 2.5973439330268263e-07 0.00021 2.5974439330268264e-07 0 2.5974439330268264e-07 0 2.5975439330268265e-07 0.00021 2.5976439330268266e-07 0 2.59808029959886e-07 0 2.59818029959886e-07 0.00021 2.59828029959886e-07 0 2.59828029959886e-07 0 2.5983802995988603e-07 0.00021 2.5984802995988604e-07 0 2.598566741559187e-07 0 2.598666741559187e-07 0.00021 2.5987667415591873e-07 0 2.5990847205399413e-07 0 2.5991847205399415e-07 0.00021 2.5992847205399416e-07 0 2.5992847205399416e-07 0 2.5993847205399417e-07 0.00021 2.599484720539942e-07 0 2.599780779503126e-07 0 2.5998807795031263e-07 0.00021 2.5999807795031264e-07 0 2.5999807795031264e-07 0 2.6000807795031265e-07 0.00021 2.6001807795031266e-07 0 2.6001807795031266e-07 0 2.6002807795031267e-07 0.00021 2.600380779503127e-07 0 2.600380779503127e-07 0 2.600480779503127e-07 0.00021 2.600580779503127e-07 0 2.6005864022846676e-07 0 2.6006864022846677e-07 0.00021 2.600786402284668e-07 0 2.601070219036759e-07 0 2.601170219036759e-07 0.00021 2.6012702190367593e-07 0 2.6016457240398414e-07 0 2.6017457240398415e-07 0.00021 2.6018457240398416e-07 0 2.6018457240398416e-07 0 2.601945724039842e-07 0.00021 2.602045724039842e-07 0 2.602045724039842e-07 0 2.602145724039842e-07 0.00021 2.602245724039842e-07 0 2.602587424411474e-07 0 2.602687424411474e-07 0.00021 2.602787424411474e-07 0 2.6028351226535195e-07 0 2.6029351226535196e-07 0.00021 2.6030351226535197e-07 0 2.603587950577917e-07 0 2.603687950577917e-07 0.00021 2.603787950577917e-07 0 2.603787950577917e-07 0 2.603887950577917e-07 0.00021 2.6039879505779173e-07 0 2.6046058841388804e-07 0 2.6047058841388806e-07 0.00021 2.6048058841388807e-07 0 2.605284840526478e-07 0 2.605384840526478e-07 0.00021 2.605484840526478e-07 0 2.605484840526478e-07 0 2.605584840526478e-07 0.00021 2.605684840526478e-07 0 2.6058155575658544e-07 0 2.6059155575658545e-07 0.00021 2.6060155575658547e-07 0 2.6060155575658547e-07 0 2.606115557565855e-07 0.00021 2.606215557565855e-07 0 2.606653881616208e-07 0 2.606753881616208e-07 0.00021 2.606853881616208e-07 0 2.606853881616208e-07 0 2.606953881616208e-07 0.00021 2.6070538816162083e-07 0 2.6070538816162083e-07 0 2.6071538816162084e-07 0.00021 2.6072538816162085e-07 0 2.6072538816162085e-07 0 2.6073538816162086e-07 0.00021 2.607453881616209e-07 0 2.607453881616209e-07 0 2.607553881616209e-07 0.00021 2.607653881616209e-07 0 2.607653881616209e-07 0 2.607753881616209e-07 0.00021 2.607853881616209e-07 0 2.6079268060938047e-07 0 2.608026806093805e-07 0.00021 2.608126806093805e-07 0 2.608126806093805e-07 0 2.608226806093805e-07 0.00021 2.608326806093805e-07 0 2.608326806093805e-07 0 2.608426806093805e-07 0.00021 2.6085268060938053e-07 0 2.6085268060938053e-07 0 2.6086268060938054e-07 0.00021 2.6087268060938056e-07 0 2.6087268060938056e-07 0 2.6088268060938057e-07 0.00021 2.608926806093806e-07 0 2.6099304784258666e-07 0 2.6100304784258667e-07 0.00021 2.610130478425867e-07 0 2.610223817228655e-07 0 2.610323817228655e-07 0.00021 2.610423817228655e-07 0 2.610423817228655e-07 0 2.610523817228655e-07 0.00021 2.6106238172286553e-07 0 2.6106238172286553e-07 0 2.6107238172286554e-07 0.00021 2.6108238172286555e-07 0 2.6108238172286555e-07 0 2.6109238172286557e-07 0.00021 2.611023817228656e-07 0 2.6113456833466977e-07 0 2.611445683346698e-07 0.00021 2.611545683346698e-07 0 2.611545683346698e-07 0 2.611645683346698e-07 0.00021 2.611745683346698e-07 0 2.611745683346698e-07 0 2.611845683346698e-07 0.00021 2.6119456833466984e-07 0 2.6125756624329487e-07 0 2.612675662432949e-07 0.00021 2.612775662432949e-07 0 2.612775662432949e-07 0 2.612875662432949e-07 0.00021 2.612975662432949e-07 0 2.613066564047093e-07 0 2.6131665640470933e-07 0.00021 2.6132665640470934e-07 0 2.6137102767716217e-07 0 2.613810276771622e-07 0.00021 2.613910276771622e-07 0 2.6144332320419204e-07 0 2.6145332320419205e-07 0.00021 2.6146332320419206e-07 0 2.6149378093365847e-07 0 2.615037809336585e-07 0.00021 2.615137809336585e-07 0 2.615137809336585e-07 0 2.615237809336585e-07 0.00021 2.615337809336585e-07 0 2.615337809336585e-07 0 2.6154378093365853e-07 0.00021 2.6155378093365854e-07 0 2.6155378093365854e-07 0 2.6156378093365855e-07 0.00021 2.6157378093365856e-07 0 2.616184655151965e-07 0 2.616284655151965e-07 0.00021 2.616384655151965e-07 0 2.616384655151965e-07 0 2.616484655151965e-07 0.00021 2.6165846551519653e-07 0 2.6165846551519653e-07 0 2.6166846551519654e-07 0.00021 2.6167846551519656e-07 0 2.61753790846675e-07 0 2.61763790846675e-07 0.00021 2.61773790846675e-07 0 2.6178325898554413e-07 0 2.6179325898554415e-07 0.00021 2.6180325898554416e-07 0 2.6180325898554416e-07 0 2.6181325898554417e-07 0.00021 2.618232589855442e-07 0 2.6195880897713796e-07 0 2.61968808977138e-07 0.00021 2.61978808977138e-07 0 2.61978808977138e-07 0 2.61988808977138e-07 0.00021 2.61998808977138e-07 0 2.620575898228968e-07 0 2.620675898228968e-07 0.00021 2.620775898228968e-07 0 2.6211836392827104e-07 0 2.6212836392827105e-07 0.00021 2.6213836392827106e-07 0 2.6216724603750306e-07 0 2.6217724603750307e-07 0.00021 2.621872460375031e-07 0 2.6219262228987117e-07 0 2.622026222898712e-07 0.00021 2.622126222898712e-07 0 2.622281022238857e-07 0 2.6223810222388573e-07 0.00021 2.6224810222388574e-07 0 2.622796330847749e-07 0 2.622896330847749e-07 0.00021 2.6229963308477493e-07 0 2.623380092037912e-07 0 2.623480092037912e-07 0.00021 2.623580092037912e-07 0 2.623580092037912e-07 0 2.623680092037912e-07 0.00021 2.6237800920379123e-07 0 2.6246304364675625e-07 0 2.6247304364675626e-07 0.00021 2.624830436467563e-07 0 2.6249931728398996e-07 0 2.6250931728399e-07 0.00021 2.6251931728399e-07 0 2.6251931728399e-07 0 2.6252931728399e-07 0.00021 2.6253931728399e-07 0 2.6253931728399e-07 0 2.6254931728399e-07 0.00021 2.6255931728399003e-07 0 2.6255931728399003e-07 0 2.6256931728399004e-07 0.00021 2.6257931728399005e-07 0 2.6257931728399005e-07 0 2.6258931728399006e-07 0.00021 2.625993172839901e-07 0 2.6262386709432284e-07 0 2.6263386709432285e-07 0.00021 2.6264386709432286e-07 0 2.626617524862968e-07 0 2.626717524862968e-07 0.00021 2.6268175248629683e-07 0 2.6268175248629683e-07 0 2.6269175248629684e-07 0.00021 2.6270175248629685e-07 0 2.6270175248629685e-07 0 2.6271175248629687e-07 0.00021 2.627217524862969e-07 0 2.627217524862969e-07 0 2.627317524862969e-07 0.00021 2.627417524862969e-07 0 2.627417524862969e-07 0 2.627517524862969e-07 0.00021 2.627617524862969e-07 0 2.627617524862969e-07 0 2.6277175248629693e-07 0.00021 2.6278175248629694e-07 0 2.6278175248629694e-07 0 2.6279175248629696e-07 0.00021 2.6280175248629697e-07 0 2.6280175248629697e-07 0 2.62811752486297e-07 0.00021 2.62821752486297e-07 0 2.62821752486297e-07 0 2.62831752486297e-07 0.00021 2.62841752486297e-07 0 2.62841752486297e-07 0 2.62851752486297e-07 0.00021 2.6286175248629704e-07 0 2.629293802998693e-07 0 2.6293938029986933e-07 0.00021 2.6294938029986934e-07 0 2.630329975128465e-07 0 2.630429975128465e-07 0.00021 2.630529975128465e-07 0 2.630529975128465e-07 0 2.630629975128465e-07 0.00021 2.6307299751284653e-07 0 2.6307299751284653e-07 0 2.6308299751284654e-07 0.00021 2.6309299751284655e-07 0 2.631033155827449e-07 0 2.631133155827449e-07 0.00021 2.631233155827449e-07 0 2.6313732224462993e-07 0 2.6314732224462994e-07 0.00021 2.6315732224462995e-07 0 2.631789065117415e-07 0 2.6318890651174154e-07 0.00021 2.6319890651174155e-07 0 2.632785468177136e-07 0 2.6328854681771363e-07 0.00021 2.6329854681771364e-07 0 2.633313803564763e-07 0 2.633413803564763e-07 0.00021 2.633513803564763e-07 0 2.6336439408919564e-07 0 2.6337439408919565e-07 0.00021 2.6338439408919566e-07 0 2.6338439408919566e-07 0 2.633943940891957e-07 0.00021 2.634043940891957e-07 0 2.634043940891957e-07 0 2.634143940891957e-07 0.00021 2.634243940891957e-07 0 2.6342460878766367e-07 0 2.634346087876637e-07 0.00021 2.634446087876637e-07 0 2.63459531773065e-07 0 2.63469531773065e-07 0.00021 2.63479531773065e-07 0 2.634913855143947e-07 0 2.6350138551439474e-07 0.00021 2.6351138551439475e-07 0 2.635299540762417e-07 0 2.6353995407624173e-07 0.00021 2.6354995407624175e-07 0 2.6354995407624175e-07 0 2.6355995407624176e-07 0.00021 2.6356995407624177e-07 0 2.63620660553792e-07 0 2.63630660553792e-07 0.00021 2.63640660553792e-07 0 2.63640660553792e-07 0 2.63650660553792e-07 0.00021 2.63660660553792e-07 0 2.63660660553792e-07 0 2.6367066055379204e-07 0.00021 2.6368066055379205e-07 0 2.637519003982974e-07 0 2.6376190039829743e-07 0.00021 2.6377190039829744e-07 0 2.638125766312333e-07 0 2.638225766312333e-07 0.00021 2.6383257663123333e-07 0 2.6383257663123333e-07 0 2.6384257663123334e-07 0.00021 2.6385257663123335e-07 0 2.6385257663123335e-07 0 2.6386257663123337e-07 0.00021 2.638725766312334e-07 0 2.638725766312334e-07 0 2.638825766312334e-07 0.00021 2.638925766312334e-07 0 2.638939337092457e-07 0 2.6390393370924573e-07 0.00021 2.6391393370924574e-07 0 2.63938249981628e-07 0 2.63948249981628e-07 0.00021 2.63958249981628e-07 0 2.6398710343648227e-07 0 2.639971034364823e-07 0.00021 2.640071034364823e-07 0 2.640071034364823e-07 0 2.640171034364823e-07 0.00021 2.640271034364823e-07 0 2.640271034364823e-07 0 2.640371034364823e-07 0.00021 2.6404710343648234e-07 0 2.6404710343648234e-07 0 2.6405710343648235e-07 0.00021 2.6406710343648236e-07 0 2.6406710343648236e-07 0 2.6407710343648237e-07 0.00021 2.640871034364824e-07 0 2.640871034364824e-07 0 2.640971034364824e-07 0.00021 2.641071034364824e-07 0 2.641243207828675e-07 0 2.641343207828675e-07 0.00021 2.6414432078286754e-07 0 2.6417778142231525e-07 0 2.6418778142231526e-07 0.00021 2.6419778142231527e-07 0 2.64204851982744e-07 0 2.64214851982744e-07 0.00021 2.64224851982744e-07 0 2.642716942579512e-07 0 2.642816942579512e-07 0.00021 2.6429169425795123e-07 0 2.6429640545024337e-07 0 2.643064054502434e-07 0.00021 2.643164054502434e-07 0 2.643164054502434e-07 0 2.643264054502434e-07 0.00021 2.643364054502434e-07 0 2.6435895218249767e-07 0 2.643689521824977e-07 0.00021 2.643789521824977e-07 0 2.643789521824977e-07 0 2.643889521824977e-07 0.00021 2.643989521824977e-07 0 2.643989521824977e-07 0 2.6440895218249773e-07 0.00021 2.6441895218249774e-07 0 2.6441895218249774e-07 0 2.6442895218249775e-07 0.00021 2.6443895218249776e-07 0 2.6443895218249776e-07 0 2.644489521824978e-07 0.00021 2.644589521824978e-07 0 2.644589521824978e-07 0 2.644689521824978e-07 0.00021 2.644789521824978e-07 0 2.6450595279187587e-07 0 2.645159527918759e-07 0.00021 2.645259527918759e-07 0 2.645259527918759e-07 0 2.645359527918759e-07 0.00021 2.645459527918759e-07 0 2.645459527918759e-07 0 2.645559527918759e-07 0.00021 2.6456595279187593e-07 0 2.6456595279187593e-07 0 2.6457595279187595e-07 0.00021 2.6458595279187596e-07 0 2.645948375381026e-07 0 2.646048375381026e-07 0.00021 2.646148375381026e-07 0 2.6463240991482296e-07 0 2.64642409914823e-07 0.00021 2.64652409914823e-07 0 2.64652409914823e-07 0 2.64662409914823e-07 0.00021 2.64672409914823e-07 0 2.64672409914823e-07 0 2.64682409914823e-07 0.00021 2.6469240991482303e-07 0 2.647034349567562e-07 0 2.6471343495675623e-07 0.00021 2.6472343495675624e-07 0 2.6472343495675624e-07 0 2.6473343495675625e-07 0.00021 2.6474343495675626e-07 0 2.6474343495675626e-07 0 2.6475343495675627e-07 0.00021 2.647634349567563e-07 0 2.647634349567563e-07 0 2.647734349567563e-07 0.00021 2.647834349567563e-07 0 2.648117979230921e-07 0 2.6482179792309213e-07 0.00021 2.6483179792309214e-07 0 2.648711334192057e-07 0 2.648811334192057e-07 0.00021 2.6489113341920573e-07 0 2.6489113341920573e-07 0 2.6490113341920574e-07 0.00021 2.6491113341920575e-07 0 2.6491113341920575e-07 0 2.6492113341920576e-07 0.00021 2.649311334192058e-07 0 2.649311334192058e-07 0 2.649411334192058e-07 0.00021 2.649511334192058e-07 0 2.6495497680326437e-07 0 2.649649768032644e-07 0.00021 2.649749768032644e-07 0 2.649749768032644e-07 0 2.649849768032644e-07 0.00021 2.649949768032644e-07 0 2.649949768032644e-07 0 2.6500497680326443e-07 0.00021 2.6501497680326444e-07 0 2.6501497680326444e-07 0 2.6502497680326445e-07 0.00021 2.6503497680326446e-07 0 2.6503497680326446e-07 0 2.6504497680326447e-07 0.00021 2.650549768032645e-07 0 2.650549768032645e-07 0 2.650649768032645e-07 0.00021 2.650749768032645e-07 0 2.650749768032645e-07 0 2.650849768032645e-07 0.00021 2.6509497680326453e-07 0 2.6509497680326453e-07 0 2.6510497680326454e-07 0.00021 2.6511497680326455e-07 0 2.6511497680326455e-07 0 2.6512497680326456e-07 0.00021 2.651349768032646e-07 0 2.651349768032646e-07 0 2.651449768032646e-07 0.00021 2.651549768032646e-07 0 2.651549768032646e-07 0 2.651649768032646e-07 0.00021 2.651749768032646e-07 0 2.651749768032646e-07 0 2.6518497680326463e-07 0.00021 2.6519497680326464e-07 0 2.6519497680326464e-07 0 2.6520497680326465e-07 0.00021 2.6521497680326467e-07 0 2.6521497680326467e-07 0 2.652249768032647e-07 0.00021 2.652349768032647e-07 0 2.652349768032647e-07 0 2.652449768032647e-07 0.00021 2.652549768032647e-07 0 2.652549768032647e-07 0 2.652649768032647e-07 0.00021 2.6527497680326473e-07 0 2.6527497680326473e-07 0 2.6528497680326474e-07 0.00021 2.6529497680326476e-07 0 2.6529497680326476e-07 0 2.6530497680326477e-07 0.00021 2.653149768032648e-07 0 2.653149768032648e-07 0 2.653249768032648e-07 0.00021 2.653349768032648e-07 0 2.653349768032648e-07 0 2.653449768032648e-07 0.00021 2.653549768032648e-07 0 2.653549768032648e-07 0 2.6536497680326484e-07 0.00021 2.6537497680326485e-07 0 2.6537497680326485e-07 0 2.6538497680326486e-07 0.00021 2.6539497680326487e-07 0 2.6539497680326487e-07 0 2.654049768032649e-07 0.00021 2.654149768032649e-07 0 2.654149768032649e-07 0 2.654249768032649e-07 0.00021 2.654349768032649e-07 0 2.654523970275513e-07 0 2.654623970275513e-07 0.00021 2.654723970275513e-07 0 2.655053679995256e-07 0 2.655153679995256e-07 0.00021 2.655253679995256e-07 0 2.655253679995256e-07 0 2.655353679995256e-07 0.00021 2.6554536799952563e-07 0 2.6554536799952563e-07 0 2.6555536799952564e-07 0.00021 2.6556536799952566e-07 0 2.6556536799952566e-07 0 2.6557536799952567e-07 0.00021 2.655853679995257e-07 0 2.6561440024997317e-07 0 2.656244002499732e-07 0.00021 2.656344002499732e-07 0 2.656344002499732e-07 0 2.656444002499732e-07 0.00021 2.656544002499732e-07 0 2.656544002499732e-07 0 2.656644002499732e-07 0.00021 2.6567440024997324e-07 0 2.6567440024997324e-07 0 2.6568440024997325e-07 0.00021 2.6569440024997326e-07 0 2.6569440024997326e-07 0 2.6570440024997327e-07 0.00021 2.657144002499733e-07 0 2.657144002499733e-07 0 2.657244002499733e-07 0.00021 2.657344002499733e-07 0 2.657344002499733e-07 0 2.657444002499733e-07 0.00021 2.657544002499733e-07 0 2.657544002499733e-07 0 2.6576440024997334e-07 0.00021 2.6577440024997335e-07 0 2.6577440024997335e-07 0 2.6578440024997336e-07 0.00021 2.6579440024997337e-07 0 2.6579440024997337e-07 0 2.658044002499734e-07 0.00021 2.658144002499734e-07 0 2.658144002499734e-07 0 2.658244002499734e-07 0.00021 2.658344002499734e-07 0 2.658344002499734e-07 0 2.6584440024997343e-07 0.00021 2.6585440024997344e-07 0 2.6585440024997344e-07 0 2.6586440024997345e-07 0.00021 2.6587440024997346e-07 0 2.6587440024997346e-07 0 2.658844002499735e-07 0.00021 2.658944002499735e-07 0 2.658944002499735e-07 0 2.659044002499735e-07 0.00021 2.659144002499735e-07 0 2.659144002499735e-07 0 2.659244002499735e-07 0.00021 2.6593440024997353e-07 0 2.6593440024997353e-07 0 2.6594440024997354e-07 0.00021 2.6595440024997355e-07 0 2.6595440024997355e-07 0 2.6596440024997356e-07 0.00021 2.659744002499736e-07 0 2.659744002499736e-07 0 2.659844002499736e-07 0.00021 2.659944002499736e-07 0 2.659944002499736e-07 0 2.660044002499736e-07 0.00021 2.660144002499736e-07 0 2.660144002499736e-07 0 2.6602440024997363e-07 0.00021 2.6603440024997364e-07 0 2.6603440024997364e-07 0 2.6604440024997366e-07 0.00021 2.6605440024997367e-07 0 2.6608712466223944e-07 0 2.6609712466223945e-07 0.00021 2.6610712466223946e-07 0 2.6610712466223946e-07 0 2.661171246622395e-07 0.00021 2.661271246622395e-07 0 2.661271246622395e-07 0 2.661371246622395e-07 0.00021 2.661471246622395e-07 0 2.661471246622395e-07 0 2.661571246622395e-07 0.00021 2.6616712466223953e-07 0 2.6616712466223953e-07 0 2.6617712466223954e-07 0.00021 2.6618712466223955e-07 0 2.6618712466223955e-07 0 2.6619712466223957e-07 0.00021 2.662071246622396e-07 0 2.662071246622396e-07 0 2.662171246622396e-07 0.00021 2.662271246622396e-07 0 2.6623420802628765e-07 0 2.6624420802628767e-07 0.00021 2.662542080262877e-07 0 2.662542080262877e-07 0 2.662642080262877e-07 0.00021 2.662742080262877e-07 0 2.662862528351201e-07 0 2.662962528351201e-07 0.00021 2.6630625283512013e-07 0 2.6630625283512013e-07 0 2.6631625283512015e-07 0.00021 2.6632625283512016e-07 0 2.6632625283512016e-07 0 2.6633625283512017e-07 0.00021 2.663462528351202e-07 0 2.663462528351202e-07 0 2.663562528351202e-07 0.00021 2.663662528351202e-07 0 2.663662528351202e-07 0 2.663762528351202e-07 0.00021 2.663862528351202e-07 0 2.663862528351202e-07 0 2.6639625283512024e-07 0.00021 2.6640625283512025e-07 0 2.6640625283512025e-07 0 2.6641625283512026e-07 0.00021 2.6642625283512027e-07 0 2.6642625283512027e-07 0 2.664362528351203e-07 0.00021 2.664462528351203e-07 0 2.664462528351203e-07 0 2.664562528351203e-07 0.00021 2.664662528351203e-07 0 2.664662528351203e-07 0 2.6647625283512033e-07 0.00021 2.6648625283512034e-07 0 2.6648625283512034e-07 0 2.6649625283512035e-07 0.00021 2.6650625283512036e-07 0 2.665075750867345e-07 0 2.665175750867345e-07 0.00021 2.665275750867345e-07 0 2.665275750867345e-07 0 2.6653757508673453e-07 0.00021 2.6654757508673454e-07 0 2.6654757508673454e-07 0 2.6655757508673455e-07 0.00021 2.6656757508673456e-07 0 2.6656757508673456e-07 0 2.6657757508673457e-07 0.00021 2.665875750867346e-07 0 2.665875750867346e-07 0 2.665975750867346e-07 0.00021 2.666075750867346e-07 0 2.666848224702604e-07 0 2.666948224702604e-07 0.00021 2.667048224702604e-07 0 2.667048224702604e-07 0 2.667148224702604e-07 0.00021 2.6672482247026043e-07 0 2.6674169026108156e-07 0 2.6675169026108157e-07 0.00021 2.667616902610816e-07 0 2.667616902610816e-07 0 2.667716902610816e-07 0.00021 2.667816902610816e-07 0 2.667816902610816e-07 0 2.667916902610816e-07 0.00021 2.668016902610816e-07 0 2.668016902610816e-07 0 2.6681169026108163e-07 0.00021 2.6682169026108165e-07 0 2.6687946654551366e-07 0 2.668894665455137e-07 0.00021 2.668994665455137e-07 0 2.6694564413009417e-07 0 2.669556441300942e-07 0.00021 2.669656441300942e-07 0 2.669656441300942e-07 0 2.669756441300942e-07 0.00021 2.669856441300942e-07 0 2.6705826547950103e-07 0 2.6706826547950104e-07 0.00021 2.6707826547950105e-07 0 2.6714352268494024e-07 0 2.6715352268494025e-07 0.00021 2.6716352268494026e-07 0 2.6716352268494026e-07 0 2.6717352268494027e-07 0.00021 2.671835226849403e-07 0 2.671835226849403e-07 0 2.671935226849403e-07 0.00021 2.672035226849403e-07 0 2.672035226849403e-07 0 2.672135226849403e-07 0.00021 2.672235226849403e-07 0 2.6730307575139954e-07 0 2.6731307575139955e-07 0.00021 2.6732307575139956e-07 0 2.673638563564519e-07 0 2.673738563564519e-07 0.00021 2.673838563564519e-07 0 2.673838563564519e-07 0 2.673938563564519e-07 0.00021 2.6740385635645194e-07 0 2.6740385635645194e-07 0 2.6741385635645195e-07 0.00021 2.6742385635645196e-07 0 2.6742385635645196e-07 0 2.6743385635645197e-07 0.00021 2.67443856356452e-07 0 2.67443856356452e-07 0 2.67453856356452e-07 0.00021 2.67463856356452e-07 0 2.67463856356452e-07 0 2.67473856356452e-07 0.00021 2.6748385635645203e-07 0 2.675878469815403e-07 0 2.675978469815403e-07 0.00021 2.676078469815403e-07 0 2.676078469815403e-07 0 2.6761784698154033e-07 0.00021 2.6762784698154034e-07 0 2.6762784698154034e-07 0 2.6763784698154035e-07 0.00021 2.6764784698154036e-07 0 2.6764784698154036e-07 0 2.676578469815404e-07 0.00021 2.676678469815404e-07 0 2.676678469815404e-07 0 2.676778469815404e-07 0.00021 2.676878469815404e-07 0 2.676878469815404e-07 0 2.676978469815404e-07 0.00021 2.6770784698154043e-07 0 2.6770784698154043e-07 0 2.6771784698154044e-07 0.00021 2.6772784698154045e-07 0 2.678819168207596e-07 0 2.678919168207596e-07 0.00021 2.679019168207596e-07 0 2.679287126810744e-07 0 2.679387126810744e-07 0.00021 2.679487126810744e-07 0 2.679570025455311e-07 0 2.679670025455311e-07 0.00021 2.679770025455311e-07 0 2.679770025455311e-07 0 2.6798700254553113e-07 0.00021 2.6799700254553114e-07 0 2.6804818228402464e-07 0 2.6805818228402465e-07 0.00021 2.6806818228402467e-07 0 2.6814490619691263e-07 0 2.6815490619691265e-07 0.00021 2.6816490619691266e-07 0 2.6816490619691266e-07 0 2.6817490619691267e-07 0.00021 2.681849061969127e-07 0 2.682500956526533e-07 0 2.682600956526533e-07 0.00021 2.682700956526533e-07 0 2.682700956526533e-07 0 2.6828009565265333e-07 0.00021 2.6829009565265334e-07 0 2.6829009565265334e-07 0 2.6830009565265335e-07 0.00021 2.6831009565265336e-07 0 2.6831009565265336e-07 0 2.683200956526534e-07 0.00021 2.683300956526534e-07 0 2.683300956526534e-07 0 2.683400956526534e-07 0.00021 2.683500956526534e-07 0 2.683500956526534e-07 0 2.683600956526534e-07 0.00021 2.6837009565265343e-07 0 2.6837009565265343e-07 0 2.6838009565265344e-07 0.00021 2.6839009565265345e-07 0 2.6839009565265345e-07 0 2.6840009565265347e-07 0.00021 2.684100956526535e-07 0 2.684100956526535e-07 0 2.684200956526535e-07 0.00021 2.684300956526535e-07 0 2.684300956526535e-07 0 2.684400956526535e-07 0.00021 2.684500956526535e-07 0 2.684500956526535e-07 0 2.6846009565265353e-07 0.00021 2.6847009565265355e-07 0 2.6847009565265355e-07 0 2.6848009565265356e-07 0.00021 2.6849009565265357e-07 0 2.6849009565265357e-07 0 2.685000956526536e-07 0.00021 2.685100956526536e-07 0 2.685100956526536e-07 0 2.685200956526536e-07 0.00021 2.685300956526536e-07 0 2.685300956526536e-07 0 2.685400956526536e-07 0.00021 2.6855009565265364e-07 0 2.6855009565265364e-07 0 2.6856009565265365e-07 0.00021 2.6857009565265366e-07 0 2.6857009565265366e-07 0 2.6858009565265367e-07 0.00021 2.685900956526537e-07 0 2.685900956526537e-07 0 2.686000956526537e-07 0.00021 2.686100956526537e-07 0 2.686444593858733e-07 0 2.686544593858733e-07 0.00021 2.686644593858733e-07 0 2.6868509373476074e-07 0 2.6869509373476075e-07 0.00021 2.6870509373476076e-07 0 2.687092216219152e-07 0 2.687192216219152e-07 0.00021 2.6872922162191523e-07 0 2.6881438544181324e-07 0 2.6882438544181325e-07 0.00021 2.6883438544181326e-07 0 2.6885400326975674e-07 0 2.6886400326975676e-07 0.00021 2.6887400326975677e-07 0 2.6892337781157056e-07 0 2.6893337781157057e-07 0.00021 2.689433778115706e-07 0 2.689433778115706e-07 0 2.689533778115706e-07 0.00021 2.689633778115706e-07 0 2.6901375957444634e-07 0 2.6902375957444635e-07 0.00021 2.6903375957444636e-07 0 2.69064530749856e-07 0 2.69074530749856e-07 0.00021 2.6908453074985603e-07 0 2.691024059071559e-07 0 2.691124059071559e-07 0.00021 2.6912240590715593e-07 0 2.691369053822418e-07 0 2.691469053822418e-07 0.00021 2.6915690538224183e-07 0 2.691648383264633e-07 0 2.6917483832646333e-07 0.00021 2.6918483832646334e-07 0 2.6918483832646334e-07 0 2.6919483832646335e-07 0.00021 2.6920483832646336e-07 0 2.6924340693854084e-07 0 2.6925340693854085e-07 0.00021 2.6926340693854087e-07 0 2.6926730819869826e-07 0 2.692773081986983e-07 0.00021 2.692873081986983e-07 0 2.6931853526061066e-07 0 2.6932853526061067e-07 0.00021 2.693385352606107e-07 0 2.6934389571502603e-07 0 2.6935389571502605e-07 0.00021 2.6936389571502606e-07 0 2.693684038028488e-07 0 2.693784038028488e-07 0.00021 2.6938840380284883e-07 0 2.6938840380284883e-07 0 2.6939840380284884e-07 0.00021 2.6940840380284886e-07 0 2.6944126537736185e-07 0 2.6945126537736186e-07 0.00021 2.694612653773619e-07 0 2.694612653773619e-07 0 2.694712653773619e-07 0.00021 2.694812653773619e-07 0 2.694812653773619e-07 0 2.694912653773619e-07 0.00021 2.695012653773619e-07 0 2.695012653773619e-07 0 2.6951126537736193e-07 0.00021 2.6952126537736194e-07 0 2.6952126537736194e-07 0 2.6953126537736195e-07 0.00021 2.6954126537736197e-07 0 2.6954126537736197e-07 0 2.69551265377362e-07 0.00021 2.69561265377362e-07 0 2.69583447478928e-07 0 2.69593447478928e-07 0.00021 2.6960344747892803e-07 0 2.6960344747892803e-07 0 2.6961344747892805e-07 0.00021 2.6962344747892806e-07 0 2.6963466822296274e-07 0 2.6964466822296275e-07 0.00021 2.6965466822296276e-07 0 2.696817582971379e-07 0 2.696917582971379e-07 0.00021 2.697017582971379e-07 0 2.697174707058203e-07 0 2.6972747070582033e-07 0.00021 2.6973747070582034e-07 0 2.6973747070582034e-07 0 2.6974747070582035e-07 0.00021 2.6975747070582036e-07 0 2.6988198629318265e-07 0 2.6989198629318266e-07 0.00021 2.6990198629318267e-07 0 2.6990198629318267e-07 0 2.699119862931827e-07 0.00021 2.699219862931827e-07 0 2.6992284317253226e-07 0 2.6993284317253227e-07 0.00021 2.699428431725323e-07 0 2.699428431725323e-07 0 2.699528431725323e-07 0.00021 2.699628431725323e-07 0 2.699628431725323e-07 0 2.699728431725323e-07 0.00021 2.6998284317253233e-07 0 2.7003041806106655e-07 0 2.7004041806106656e-07 0.00021 2.7005041806106657e-07 0 2.700887887920677e-07 0 2.700987887920677e-07 0.00021 2.7010878879206773e-07 0 2.7011327917071235e-07 0 2.7012327917071237e-07 0.00021 2.701332791707124e-07 0 2.701332791707124e-07 0 2.701432791707124e-07 0.00021 2.701532791707124e-07 0 2.701532791707124e-07 0 2.701632791707124e-07 0.00021 2.701732791707124e-07 0 2.701877610959323e-07 0 2.701977610959323e-07 0.00021 2.702077610959323e-07 0 2.702077610959323e-07 0 2.7021776109593233e-07 0.00021 2.7022776109593234e-07 0 2.7022776109593234e-07 0 2.7023776109593235e-07 0.00021 2.7024776109593236e-07 0 2.7024776109593236e-07 0 2.702577610959324e-07 0.00021 2.702677610959324e-07 0 2.702677610959324e-07 0 2.702777610959324e-07 0.00021 2.702877610959324e-07 0 2.702877610959324e-07 0 2.702977610959324e-07 0.00021 2.7030776109593243e-07 0 2.7030776109593243e-07 0 2.7031776109593244e-07 0.00021 2.7032776109593245e-07 0 2.7032776109593245e-07 0 2.7033776109593247e-07 0.00021 2.703477610959325e-07 0 2.704043056930367e-07 0 2.704143056930367e-07 0.00021 2.704243056930367e-07 0 2.704293991131009e-07 0 2.704393991131009e-07 0.00021 2.704493991131009e-07 0 2.7058360539926834e-07 0 2.7059360539926835e-07 0.00021 2.7060360539926836e-07 0 2.7061116371883493e-07 0 2.7062116371883494e-07 0.00021 2.7063116371883495e-07 0 2.7063116371883495e-07 0 2.7064116371883496e-07 0.00021 2.70651163718835e-07 0 2.70651163718835e-07 0 2.70661163718835e-07 0.00021 2.70671163718835e-07 0 2.7069744878046147e-07 0 2.707074487804615e-07 0.00021 2.707174487804615e-07 0 2.707174487804615e-07 0 2.707274487804615e-07 0.00021 2.707374487804615e-07 0 2.7075564705659346e-07 0 2.7076564705659347e-07 0.00021 2.707756470565935e-07 0 2.7079535360819607e-07 0 2.708053536081961e-07 0.00021 2.708153536081961e-07 0 2.708153536081961e-07 0 2.708253536081961e-07 0.00021 2.708353536081961e-07 0 2.708821146152637e-07 0 2.708921146152637e-07 0.00021 2.7090211461526373e-07 0 2.709300200836762e-07 0 2.709400200836762e-07 0.00021 2.709500200836762e-07 0 2.709500200836762e-07 0 2.709600200836762e-07 0.00021 2.7097002008367623e-07 0 2.7097895907158407e-07 0 2.709889590715841e-07 0.00021 2.709989590715841e-07 0 2.709989590715841e-07 0 2.710089590715841e-07 0.00021 2.710189590715841e-07 0 2.7102986863169606e-07 0 2.7103986863169607e-07 0.00021 2.710498686316961e-07 0 2.710498686316961e-07 0 2.710598686316961e-07 0.00021 2.710698686316961e-07 0 2.710698686316961e-07 0 2.710798686316961e-07 0.00021 2.7108986863169613e-07 0 2.7108986863169613e-07 0 2.7109986863169614e-07 0.00021 2.7110986863169615e-07 0 2.7110986863169615e-07 0 2.7111986863169616e-07 0.00021 2.7112986863169617e-07 0 2.7112986863169617e-07 0 2.711398686316962e-07 0.00021 2.711498686316962e-07 0 2.7120758389214796e-07 0 2.7121758389214797e-07 0.00021 2.71227583892148e-07 0 2.712972250903543e-07 0 2.7130722509035433e-07 0.00021 2.7131722509035434e-07 0 2.713539620229316e-07 0 2.713639620229316e-07 0.00021 2.713739620229316e-07 0 2.713739620229316e-07 0 2.7138396202293163e-07 0.00021 2.7139396202293164e-07 0 2.7139396202293164e-07 0 2.7140396202293165e-07 0.00021 2.7141396202293166e-07 0 2.7141396202293166e-07 0 2.714239620229317e-07 0.00021 2.714339620229317e-07 0 2.714339620229317e-07 0 2.714439620229317e-07 0.00021 2.714539620229317e-07 0 2.714539620229317e-07 0 2.714639620229317e-07 0.00021 2.7147396202293173e-07 0 2.7147396202293173e-07 0 2.7148396202293174e-07 0.00021 2.7149396202293175e-07 0 2.7155257024480345e-07 0 2.7156257024480346e-07 0.00021 2.715725702448035e-07 0 2.715885556116358e-07 0 2.715985556116358e-07 0.00021 2.716085556116358e-07 0 2.7162634791752646e-07 0 2.7163634791752647e-07 0.00021 2.716463479175265e-07 0 2.716463479175265e-07 0 2.716563479175265e-07 0.00021 2.716663479175265e-07 0 2.716663479175265e-07 0 2.716763479175265e-07 0.00021 2.716863479175265e-07 0 2.716863479175265e-07 0 2.7169634791752654e-07 0.00021 2.7170634791752655e-07 0 2.717996515311788e-07 0 2.718096515311788e-07 0.00021 2.718196515311788e-07 0 2.718196515311788e-07 0 2.7182965153117883e-07 0.00021 2.7183965153117884e-07 0 2.718969980079836e-07 0 2.719069980079836e-07 0.00021 2.7191699800798363e-07 0 2.7191905674094036e-07 0 2.7192905674094037e-07 0.00021 2.719390567409404e-07 0 2.719390567409404e-07 0 2.719490567409404e-07 0.00021 2.719590567409404e-07 0 2.719590567409404e-07 0 2.719690567409404e-07 0.00021 2.719790567409404e-07 0 2.719790567409404e-07 0 2.7198905674094044e-07 0.00021 2.7199905674094045e-07 0 2.7199905674094045e-07 0 2.7200905674094046e-07 0.00021 2.7201905674094047e-07 0 2.7201905674094047e-07 0 2.720290567409405e-07 0.00021 2.720390567409405e-07 0 2.720390567409405e-07 0 2.720490567409405e-07 0.00021 2.720590567409405e-07 0 2.720999562491476e-07 0 2.721099562491476e-07 0.00021 2.721199562491476e-07 0 2.721509514014892e-07 0 2.721609514014892e-07 0.00021 2.721709514014892e-07 0 2.721709514014892e-07 0 2.721809514014892e-07 0.00021 2.7219095140148924e-07 0 2.7220047745163055e-07 0 2.7221047745163057e-07 0.00021 2.722204774516306e-07 0 2.7224537049141655e-07 0 2.7225537049141656e-07 0.00021 2.7226537049141657e-07 0 2.7233243936138376e-07 0 2.7234243936138377e-07 0.00021 2.723524393613838e-07 0 2.7243842054541734e-07 0 2.7244842054541735e-07 0.00021 2.7245842054541736e-07 0 2.7245842054541736e-07 0 2.7246842054541737e-07 0.00021 2.724784205454174e-07 0 2.7248253435221747e-07 0 2.724925343522175e-07 0.00021 2.725025343522175e-07 0 2.725025343522175e-07 0 2.725125343522175e-07 0.00021 2.725225343522175e-07 0 2.725538483703067e-07 0 2.725638483703067e-07 0.00021 2.725738483703067e-07 0 2.725765816714338e-07 0 2.725865816714338e-07 0.00021 2.7259658167143384e-07 0 2.7259658167143384e-07 0 2.7260658167143385e-07 0.00021 2.7261658167143386e-07 0 2.7262468075947076e-07 0 2.7263468075947077e-07 0.00021 2.726446807594708e-07 0 2.7268958737513636e-07 0 2.7269958737513637e-07 0.00021 2.727095873751364e-07 0 2.727095873751364e-07 0 2.727195873751364e-07 0.00021 2.727295873751364e-07 0 2.7273291331382143e-07 0 2.7274291331382144e-07 0.00021 2.7275291331382145e-07 0 2.7275291331382145e-07 0 2.7276291331382147e-07 0.00021 2.727729133138215e-07 0 2.727729133138215e-07 0 2.727829133138215e-07 0.00021 2.727929133138215e-07 0 2.728000769413417e-07 0 2.7281007694134173e-07 0.00021 2.7282007694134174e-07 0 2.7282007694134174e-07 0 2.7283007694134175e-07 0.00021 2.7284007694134177e-07 0 2.7284007694134177e-07 0 2.728500769413418e-07 0.00021 2.728600769413418e-07 0 2.728600769413418e-07 0 2.728700769413418e-07 0.00021 2.728800769413418e-07 0 2.728800769413418e-07 0 2.728900769413418e-07 0.00021 2.7290007694134183e-07 0 2.729204113850221e-07 0 2.729304113850221e-07 0.00021 2.729404113850221e-07 0 2.729404113850221e-07 0 2.7295041138502214e-07 0.00021 2.7296041138502215e-07 0 2.729642549083948e-07 0 2.7297425490839483e-07 0.00021 2.7298425490839485e-07 0 2.7298425490839485e-07 0 2.7299425490839486e-07 0.00021 2.7300425490839487e-07 0 2.730559114210747e-07 0 2.7306591142107473e-07 0.00021 2.7307591142107474e-07 0 2.7307591142107474e-07 0 2.7308591142107475e-07 0.00021 2.7309591142107476e-07 0 2.731031868716493e-07 0 2.731131868716493e-07 0.00021 2.7312318687164933e-07 0 2.7316020425917026e-07 0 2.7317020425917027e-07 0.00021 2.731802042591703e-07 0 2.731936383454703e-07 0 2.7320363834547033e-07 0.00021 2.7321363834547034e-07 0 2.732144151996909e-07 0 2.732244151996909e-07 0.00021 2.732344151996909e-07 0 2.732344151996909e-07 0 2.7324441519969093e-07 0.00021 2.7325441519969095e-07 0 2.733293124081605e-07 0 2.7333931240816054e-07 0.00021 2.7334931240816055e-07 0 2.7334931240816055e-07 0 2.7335931240816056e-07 0.00021 2.7336931240816057e-07 0 2.73399708631807e-07 0 2.73409708631807e-07 0.00021 2.7341970863180703e-07 0 2.7341970863180703e-07 0 2.7342970863180704e-07 0.00021 2.7343970863180706e-07 0 2.7343970863180706e-07 0 2.7344970863180707e-07 0.00021 2.734597086318071e-07 0 2.7354043267855304e-07 0 2.7355043267855305e-07 0.00021 2.7356043267855307e-07 0 2.735864163941784e-07 0 2.735964163941784e-07 0.00021 2.736064163941784e-07 0 2.7363954758584293e-07 0 2.7364954758584294e-07 0.00021 2.7365954758584295e-07 0 2.7369430179190333e-07 0 2.7370430179190334e-07 0.00021 2.7371430179190335e-07 0 2.7371430179190335e-07 0 2.7372430179190336e-07 0.00021 2.7373430179190337e-07 0 2.737779039438471e-07 0 2.737879039438471e-07 0.00021 2.737979039438471e-07 0 2.737979039438471e-07 0 2.738079039438471e-07 0.00021 2.7381790394384713e-07 0 2.7387940721602795e-07 0 2.7388940721602796e-07 0.00021 2.73899407216028e-07 0 2.73899407216028e-07 0 2.73909407216028e-07 0.00021 2.73919407216028e-07 0 2.73919407216028e-07 0 2.73929407216028e-07 0.00021 2.73939407216028e-07 0 2.73939407216028e-07 0 2.7394940721602803e-07 0.00021 2.7395940721602804e-07 0 2.7395940721602804e-07 0 2.7396940721602805e-07 0.00021 2.7397940721602807e-07 0 2.7397940721602807e-07 0 2.739894072160281e-07 0.00021 2.739994072160281e-07 0 2.7403170680878985e-07 0 2.7404170680878986e-07 0.00021 2.740517068087899e-07 0 2.740517068087899e-07 0 2.740617068087899e-07 0.00021 2.740717068087899e-07 0 2.740717068087899e-07 0 2.740817068087899e-07 0.00021 2.740917068087899e-07 0 2.740917068087899e-07 0 2.7410170680878993e-07 0.00021 2.7411170680878994e-07 0 2.7411170680878994e-07 0 2.7412170680878996e-07 0.00021 2.7413170680878997e-07 0 2.7413170680878997e-07 0 2.7414170680879e-07 0.00021 2.7415170680879e-07 0 2.7415170680879e-07 0 2.7416170680879e-07 0.00021 2.7417170680879e-07 0 2.7417170680879e-07 0 2.7418170680879e-07 0.00021 2.7419170680879004e-07 0 2.7419170680879004e-07 0 2.7420170680879005e-07 0.00021 2.7421170680879006e-07 0 2.7421170680879006e-07 0 2.7422170680879007e-07 0.00021 2.742317068087901e-07 0 2.742317068087901e-07 0 2.742417068087901e-07 0.00021 2.742517068087901e-07 0 2.742517068087901e-07 0 2.742617068087901e-07 0.00021 2.742717068087901e-07 0 2.742717068087901e-07 0 2.7428170680879014e-07 0.00021 2.7429170680879015e-07 0 2.7429170680879015e-07 0 2.7430170680879016e-07 0.00021 2.7431170680879017e-07 0 2.7431170680879017e-07 0 2.743217068087902e-07 0.00021 2.743317068087902e-07 0 2.743317068087902e-07 0 2.743417068087902e-07 0.00021 2.743517068087902e-07 0 2.743517068087902e-07 0 2.7436170680879023e-07 0.00021 2.7437170680879024e-07 0 2.743787002805933e-07 0 2.7438870028059333e-07 0.00021 2.7439870028059334e-07 0 2.7439870028059334e-07 0 2.7440870028059335e-07 0.00021 2.7441870028059336e-07 0 2.744598291796297e-07 0 2.744698291796297e-07 0.00021 2.744798291796297e-07 0 2.744798291796297e-07 0 2.7448982917962973e-07 0.00021 2.7449982917962974e-07 0 2.7449982917962974e-07 0 2.7450982917962975e-07 0.00021 2.7451982917962976e-07 0 2.7451982917962976e-07 0 2.7452982917962977e-07 0.00021 2.745398291796298e-07 0 2.745398291796298e-07 0 2.745498291796298e-07 0.00021 2.745598291796298e-07 0 2.745598291796298e-07 0 2.745698291796298e-07 0.00021 2.7457982917962983e-07 0 2.7457982917962983e-07 0 2.7458982917962984e-07 0.00021 2.7459982917962985e-07 0 2.7459982917962985e-07 0 2.7460982917962986e-07 0.00021 2.746198291796299e-07 0 2.746198291796299e-07 0 2.746298291796299e-07 0.00021 2.746398291796299e-07 0 2.746398291796299e-07 0 2.746498291796299e-07 0.00021 2.746598291796299e-07 0 2.746598291796299e-07 0 2.7466982917962993e-07 0.00021 2.7467982917962994e-07 0 2.7467982917962994e-07 0 2.7468982917962995e-07 0.00021 2.7469982917962997e-07 0 2.7469982917962997e-07 0 2.7470982917963e-07 0.00021 2.7471982917963e-07 0 2.7471982917963e-07 0 2.7472982917963e-07 0.00021 2.7473982917963e-07 0 2.7473982917963e-07 0 2.7474982917963e-07 0.00021 2.7475982917963003e-07 0 2.748496506825265e-07 0 2.748596506825265e-07 0.00021 2.748696506825265e-07 0 2.748773039948048e-07 0 2.748873039948048e-07 0.00021 2.748973039948048e-07 0 2.748973039948048e-07 0 2.749073039948048e-07 0.00021 2.749173039948048e-07 0 2.7497029361329006e-07 0 2.7498029361329007e-07 0.00021 2.749902936132901e-07 0 2.750752450190177e-07 0 2.750852450190177e-07 0.00021 2.750952450190177e-07 0 2.750952450190177e-07 0 2.7510524501901773e-07 0.00021 2.7511524501901774e-07 0 2.751235853545098e-07 0 2.751335853545098e-07 0.00021 2.751435853545098e-07 0 2.751435853545098e-07 0 2.751535853545098e-07 0.00021 2.7516358535450983e-07 0 2.7516358535450983e-07 0 2.7517358535450984e-07 0.00021 2.7518358535450985e-07 0 2.7518358535450985e-07 0 2.7519358535450986e-07 0.00021 2.752035853545099e-07 0 2.752035853545099e-07 0 2.752135853545099e-07 0.00021 2.752235853545099e-07 0 2.752235853545099e-07 0 2.752335853545099e-07 0.00021 2.752435853545099e-07 0 2.752435853545099e-07 0 2.7525358535450993e-07 0.00021 2.7526358535450994e-07 0 2.7526358535450994e-07 0 2.7527358535450995e-07 0.00021 2.7528358535450997e-07 0 2.7528358535450997e-07 0 2.7529358535451e-07 0.00021 2.7530358535451e-07 0 2.7530358535451e-07 0 2.7531358535451e-07 0.00021 2.7532358535451e-07 0 2.7532358535451e-07 0 2.7533358535451e-07 0.00021 2.7534358535451003e-07 0 2.7534358535451003e-07 0 2.7535358535451004e-07 0.00021 2.7536358535451006e-07 0 2.7536358535451006e-07 0 2.7537358535451007e-07 0.00021 2.753835853545101e-07 0 2.753835853545101e-07 0 2.753935853545101e-07 0.00021 2.754035853545101e-07 0 2.754035853545101e-07 0 2.754135853545101e-07 0.00021 2.754235853545101e-07 0 2.754235853545101e-07 0 2.7543358535451014e-07 0.00021 2.7544358535451015e-07 0 2.7544838839354164e-07 0 2.7545838839354165e-07 0.00021 2.7546838839354167e-07 0 2.7547859298271164e-07 0 2.7548859298271165e-07 0.00021 2.7549859298271166e-07 0 2.755775689315364e-07 0 2.755875689315364e-07 0.00021 2.755975689315364e-07 0 2.756135892658881e-07 0 2.756235892658881e-07 0.00021 2.756335892658881e-07 0 2.756335892658881e-07 0 2.7564358926588814e-07 0.00021 2.7565358926588815e-07 0 2.75707071140891e-07 0 2.75717071140891e-07 0.00021 2.75727071140891e-07 0 2.7578322881361973e-07 0 2.7579322881361974e-07 0.00021 2.7580322881361975e-07 0 2.7580322881361975e-07 0 2.7581322881361976e-07 0.00021 2.758232288136198e-07 0 2.758232288136198e-07 0 2.758332288136198e-07 0.00021 2.758432288136198e-07 0 2.758432288136198e-07 0 2.758532288136198e-07 0.00021 2.758632288136198e-07 0 2.758632288136198e-07 0 2.7587322881361983e-07 0.00021 2.7588322881361984e-07 0 2.7588322881361984e-07 0 2.7589322881361985e-07 0.00021 2.7590322881361987e-07 0 2.7590322881361987e-07 0 2.759132288136199e-07 0.00021 2.759232288136199e-07 0 2.759232288136199e-07 0 2.759332288136199e-07 0.00021 2.759432288136199e-07 0 2.759770530029289e-07 0 2.759870530029289e-07 0.00021 2.759970530029289e-07 0 2.759970530029289e-07 0 2.7600705300292893e-07 0.00021 2.7601705300292894e-07 0 2.7601705300292894e-07 0 2.7602705300292895e-07 0.00021 2.7603705300292897e-07 0 2.760716013442032e-07 0 2.760816013442032e-07 0.00021 2.7609160134420324e-07 0 2.762270719267108e-07 0 2.762370719267108e-07 0.00021 2.762470719267108e-07 0 2.762470719267108e-07 0 2.762570719267108e-07 0.00021 2.7626707192671084e-07 0 2.76287489827787e-07 0 2.76297489827787e-07 0.00021 2.76307489827787e-07 0 2.76307489827787e-07 0 2.76317489827787e-07 0.00021 2.76327489827787e-07 0 2.7633210174688447e-07 0 2.763421017468845e-07 0.00021 2.763521017468845e-07 0 2.763525817638776e-07 0 2.763625817638776e-07 0.00021 2.7637258176387763e-07 0 2.7637258176387763e-07 0 2.7638258176387764e-07 0.00021 2.7639258176387765e-07 0 2.7641921110539306e-07 0 2.7642921110539307e-07 0.00021 2.764392111053931e-07 0 2.765284055131386e-07 0 2.765384055131386e-07 0.00021 2.765484055131386e-07 0 2.765484055131386e-07 0 2.765584055131386e-07 0.00021 2.765684055131386e-07 0 2.765684055131386e-07 0 2.7657840551313864e-07 0.00021 2.7658840551313865e-07 0 2.766515432053395e-07 0 2.766615432053395e-07 0.00021 2.766715432053395e-07 0 2.767058990521147e-07 0 2.767158990521147e-07 0.00021 2.767258990521147e-07 0 2.767258990521147e-07 0 2.7673589905211474e-07 0.00021 2.7674589905211475e-07 0 2.767812762620826e-07 0 2.7679127626208264e-07 0.00021 2.7680127626208265e-07 0 2.7684570210681236e-07 0 2.7685570210681237e-07 0.00021 2.768657021068124e-07 0 2.768657021068124e-07 0 2.768757021068124e-07 0.00021 2.768857021068124e-07 0 2.768952716478657e-07 0 2.769052716478657e-07 0.00021 2.769152716478657e-07 0 2.769152716478657e-07 0 2.769252716478657e-07 0.00021 2.7693527164786574e-07 0 2.769521755097817e-07 0 2.769621755097817e-07 0.00021 2.769721755097817e-07 0 2.769721755097817e-07 0 2.7698217550978173e-07 0.00021 2.7699217550978175e-07 0 2.7699217550978175e-07 0 2.7700217550978176e-07 0.00021 2.7701217550978177e-07 0 2.770132718965534e-07 0 2.770232718965534e-07 0.00021 2.770332718965534e-07 0 2.770332718965534e-07 0 2.770432718965534e-07 0.00021 2.770532718965534e-07 0 2.770532718965534e-07 0 2.7706327189655343e-07 0.00021 2.7707327189655344e-07 0 2.7707327189655344e-07 0 2.7708327189655346e-07 0.00021 2.7709327189655347e-07 0 2.7709327189655347e-07 0 2.771032718965535e-07 0.00021 2.771132718965535e-07 0 2.7711412695453414e-07 0 2.7712412695453415e-07 0.00021 2.7713412695453417e-07 0 2.7713412695453417e-07 0 2.771441269545342e-07 0.00021 2.771541269545342e-07 0 2.771541269545342e-07 0 2.771641269545342e-07 0.00021 2.771741269545342e-07 0 2.771741269545342e-07 0 2.771841269545342e-07 0.00021 2.7719412695453423e-07 0 2.7719412695453423e-07 0 2.7720412695453425e-07 0.00021 2.7721412695453426e-07 0 2.7724245312532733e-07 0 2.7725245312532734e-07 0.00021 2.7726245312532735e-07 0 2.7726245312532735e-07 0 2.7727245312532736e-07 0.00021 2.772824531253274e-07 0 2.772824531253274e-07 0 2.772924531253274e-07 0.00021 2.773024531253274e-07 0 2.773024531253274e-07 0 2.773124531253274e-07 0.00021 2.773224531253274e-07 0 2.773224531253274e-07 0 2.7733245312532743e-07 0.00021 2.7734245312532744e-07 0 2.7734245312532744e-07 0 2.7735245312532745e-07 0.00021 2.7736245312532747e-07 0 2.7736245312532747e-07 0 2.773724531253275e-07 0.00021 2.773824531253275e-07 0 2.773824531253275e-07 0 2.773924531253275e-07 0.00021 2.774024531253275e-07 0 2.774024531253275e-07 0 2.774124531253275e-07 0.00021 2.7742245312532753e-07 0 2.7742245312532753e-07 0 2.7743245312532755e-07 0.00021 2.7744245312532756e-07 0 2.7745702168583373e-07 0 2.7746702168583374e-07 0.00021 2.7747702168583375e-07 0 2.7747702168583375e-07 0 2.7748702168583376e-07 0.00021 2.7749702168583377e-07 0 2.7757092441044197e-07 0 2.77580924410442e-07 0.00021 2.77590924410442e-07 0 2.77590924410442e-07 0 2.77600924410442e-07 0.00021 2.77610924410442e-07 0 2.776300528522048e-07 0 2.776400528522048e-07 0.00021 2.776500528522048e-07 0 2.776500528522048e-07 0 2.776600528522048e-07 0.00021 2.776700528522048e-07 0 2.776700528522048e-07 0 2.7768005285220484e-07 0.00021 2.7769005285220485e-07 0 2.7769005285220485e-07 0 2.7770005285220486e-07 0.00021 2.7771005285220487e-07 0 2.7771005285220487e-07 0 2.777200528522049e-07 0.00021 2.777300528522049e-07 0 2.777300528522049e-07 0 2.777400528522049e-07 0.00021 2.777500528522049e-07 0 2.777500528522049e-07 0 2.7776005285220493e-07 0.00021 2.7777005285220494e-07 0 2.7777005285220494e-07 0 2.7778005285220495e-07 0.00021 2.7779005285220496e-07 0 2.7779005285220496e-07 0 2.7780005285220497e-07 0.00021 2.77810052852205e-07 0 2.778549228981416e-07 0 2.7786492289814163e-07 0.00021 2.7787492289814164e-07 0 2.7787492289814164e-07 0 2.7788492289814166e-07 0.00021 2.7789492289814167e-07 0 2.779391300766932e-07 0 2.779491300766932e-07 0.00021 2.779591300766932e-07 0 2.7796099980469004e-07 0 2.7797099980469005e-07 0.00021 2.7798099980469006e-07 0 2.7798574299447547e-07 0 2.779957429944755e-07 0.00021 2.780057429944755e-07 0 2.780057429944755e-07 0 2.780157429944755e-07 0.00021 2.780257429944755e-07 0 2.780257429944755e-07 0 2.7803574299447553e-07 0.00021 2.7804574299447554e-07 0 2.7804574299447554e-07 0 2.7805574299447555e-07 0.00021 2.7806574299447556e-07 0 2.7806574299447556e-07 0 2.780757429944756e-07 0.00021 2.780857429944756e-07 0 2.7810747649083627e-07 0 2.781174764908363e-07 0.00021 2.781274764908363e-07 0 2.781274764908363e-07 0 2.781374764908363e-07 0.00021 2.781474764908363e-07 0 2.7815016697708973e-07 0 2.7816016697708974e-07 0.00021 2.7817016697708975e-07 0 2.7823155433033586e-07 0 2.7824155433033587e-07 0.00021 2.782515543303359e-07 0 2.782515543303359e-07 0 2.782615543303359e-07 0.00021 2.782715543303359e-07 0 2.782738724379382e-07 0 2.782838724379382e-07 0.00021 2.782938724379382e-07 0 2.783034954080033e-07 0 2.783134954080033e-07 0.00021 2.783234954080033e-07 0 2.783234954080033e-07 0 2.7833349540800333e-07 0.00021 2.7834349540800335e-07 0 2.7835165220971086e-07 0 2.783616522097109e-07 0.00021 2.783716522097109e-07 0 2.78382162157845e-07 0 2.78392162157845e-07 0.00021 2.78402162157845e-07 0 2.78402162157845e-07 0 2.7841216215784504e-07 0.00021 2.7842216215784505e-07 0 2.7842216215784505e-07 0 2.7843216215784506e-07 0.00021 2.7844216215784507e-07 0 2.7844216215784507e-07 0 2.784521621578451e-07 0.00021 2.784621621578451e-07 0 2.7847667926774686e-07 0 2.784866792677469e-07 0.00021 2.784966792677469e-07 0 2.784966792677469e-07 0 2.785066792677469e-07 0.00021 2.785166792677469e-07 0 2.785166792677469e-07 0 2.785266792677469e-07 0.00021 2.7853667926774693e-07 0 2.7853667926774693e-07 0 2.7854667926774694e-07 0.00021 2.7855667926774695e-07 0 2.7855667926774695e-07 0 2.7856667926774696e-07 0.00021 2.78576679267747e-07 0 2.78576679267747e-07 0 2.78586679267747e-07 0.00021 2.78596679267747e-07 0 2.78596679267747e-07 0 2.78606679267747e-07 0.00021 2.78616679267747e-07 0 2.786203205303912e-07 0 2.786303205303912e-07 0.00021 2.7864032053039123e-07 0 2.7870053923948504e-07 0 2.7871053923948505e-07 0.00021 2.7872053923948506e-07 0 2.787478630865055e-07 0 2.7875786308650554e-07 0.00021 2.7876786308650555e-07 0 2.7876786308650555e-07 0 2.7877786308650556e-07 0.00021 2.7878786308650557e-07 0 2.7878786308650557e-07 0 2.787978630865056e-07 0.00021 2.788078630865056e-07 0 2.788078630865056e-07 0 2.788178630865056e-07 0.00021 2.788278630865056e-07 0 2.788278630865056e-07 0 2.7883786308650563e-07 0.00021 2.7884786308650564e-07 0 2.788570009214207e-07 0 2.7886700092142074e-07 0.00021 2.7887700092142075e-07 0 2.789238944012121e-07 0 2.789338944012121e-07 0.00021 2.789438944012121e-07 0 2.789438944012121e-07 0 2.789538944012121e-07 0.00021 2.7896389440121213e-07 0 2.7896389440121213e-07 0 2.7897389440121214e-07 0.00021 2.7898389440121216e-07 0 2.79073339424934e-07 0 2.79083339424934e-07 0.00021 2.79093339424934e-07 0 2.790991429485361e-07 0 2.791091429485361e-07 0.00021 2.791191429485361e-07 0 2.791191429485361e-07 0 2.7912914294853613e-07 0.00021 2.7913914294853614e-07 0 2.791600600776814e-07 0 2.7917006007768143e-07 0.00021 2.7918006007768144e-07 0 2.791863819926704e-07 0 2.7919638199267043e-07 0.00021 2.7920638199267044e-07 0 2.792558563676877e-07 0 2.792658563676877e-07 0.00021 2.7927585636768774e-07 0 2.7930812070445236e-07 0 2.7931812070445237e-07 0.00021 2.793281207044524e-07 0 2.793281207044524e-07 0 2.793381207044524e-07 0.00021 2.793481207044524e-07 0 2.793481207044524e-07 0 2.793581207044524e-07 0.00021 2.793681207044524e-07 0 2.793780373761958e-07 0 2.793880373761958e-07 0.00021 2.793980373761958e-07 0 2.793980373761958e-07 0 2.794080373761958e-07 0.00021 2.7941803737619584e-07 0 2.7941803737619584e-07 0 2.7942803737619585e-07 0.00021 2.7943803737619586e-07 0 2.7943803737619586e-07 0 2.7944803737619587e-07 0.00021 2.794580373761959e-07 0 2.7945873254316194e-07 0 2.7946873254316195e-07 0.00021 2.7947873254316196e-07 0 2.7947873254316196e-07 0 2.7948873254316197e-07 0.00021 2.79498732543162e-07 0 2.79498732543162e-07 0 2.79508732543162e-07 0.00021 2.79518732543162e-07 0 2.79518732543162e-07 0 2.79528732543162e-07 0.00021 2.7953873254316203e-07 0 2.7953873254316203e-07 0 2.7954873254316204e-07 0.00021 2.7955873254316205e-07 0 2.7955873254316205e-07 0 2.7956873254316206e-07 0.00021 2.7957873254316207e-07 0 2.7957873254316207e-07 0 2.795887325431621e-07 0.00021 2.795987325431621e-07 0 2.795991586930224e-07 0 2.796091586930224e-07 0.00021 2.7961915869302243e-07 0 2.7961915869302243e-07 0 2.7962915869302244e-07 0.00021 2.7963915869302245e-07 0 2.7963915869302245e-07 0 2.7964915869302246e-07 0.00021 2.7965915869302247e-07 0 2.7967811044876197e-07 0 2.79688110448762e-07 0.00021 2.79698110448762e-07 0 2.79698110448762e-07 0 2.79708110448762e-07 0.00021 2.79718110448762e-07 0 2.79718110448762e-07 0 2.7972811044876203e-07 0.00021 2.7973811044876204e-07 0 2.7976060830853323e-07 0 2.7977060830853324e-07 0.00021 2.7978060830853325e-07 0 2.7978060830853325e-07 0 2.7979060830853326e-07 0.00021 2.7980060830853327e-07 0 2.7980060830853327e-07 0 2.798106083085333e-07 0.00021 2.798206083085333e-07 0 2.798206083085333e-07 0 2.798306083085333e-07 0.00021 2.798406083085333e-07 0 2.798406083085333e-07 0 2.7985060830853333e-07 0.00021 2.7986060830853334e-07 0 2.798758594755188e-07 0 2.798858594755188e-07 0.00021 2.798958594755188e-07 0 2.7990426321055727e-07 0 2.799142632105573e-07 0.00021 2.799242632105573e-07 0 2.8002518487237194e-07 0 2.8003518487237195e-07 0.00021 2.8004518487237196e-07 0 2.80084630742205e-07 0 2.80094630742205e-07 0.00021 2.8010463074220504e-07 0 2.801062667407653e-07 0 2.801162667407653e-07 0.00021 2.801262667407653e-07 0 2.801863286327499e-07 0 2.801963286327499e-07 0.00021 2.8020632863274993e-07 0 2.803118854718703e-07 0 2.803218854718703e-07 0.00021 2.8033188547187033e-07 0 2.8033188547187033e-07 0 2.8034188547187035e-07 0.00021 2.8035188547187036e-07 0 2.803687977760987e-07 0 2.803787977760987e-07 0.00021 2.803887977760987e-07 0 2.803887977760987e-07 0 2.8039879777609873e-07 0.00021 2.8040879777609874e-07 0 2.8042866228260894e-07 0 2.8043866228260895e-07 0.00021 2.8044866228260896e-07 0 2.8047824741533316e-07 0 2.8048824741533317e-07 0.00021 2.804982474153332e-07 0 2.804982474153332e-07 0 2.805082474153332e-07 0.00021 2.805182474153332e-07 0 2.805182474153332e-07 0 2.805282474153332e-07 0.00021 2.805382474153332e-07 0 2.805382474153332e-07 0 2.8054824741533324e-07 0.00021 2.8055824741533325e-07 0 2.8060454727071246e-07 0 2.8061454727071247e-07 0.00021 2.806245472707125e-07 0 2.806576141243016e-07 0 2.806676141243016e-07 0.00021 2.8067761412430163e-07 0 2.8067761412430163e-07 0 2.8068761412430164e-07 0.00021 2.8069761412430165e-07 0 2.8069761412430165e-07 0 2.8070761412430167e-07 0.00021 2.807176141243017e-07 0 2.8071990454989354e-07 0 2.8072990454989355e-07 0.00021 2.8073990454989356e-07 0 2.8073990454989356e-07 0 2.8074990454989357e-07 0.00021 2.807599045498936e-07 0 2.807599045498936e-07 0 2.807699045498936e-07 0.00021 2.807799045498936e-07 0 2.807799045498936e-07 0 2.807899045498936e-07 0.00021 2.807999045498936e-07 0 2.807999045498936e-07 0 2.8080990454989364e-07 0.00021 2.8081990454989365e-07 0 2.8081990454989365e-07 0 2.8082990454989366e-07 0.00021 2.8083990454989367e-07 0 2.808890853210255e-07 0 2.8089908532102554e-07 0.00021 2.8090908532102555e-07 0 2.809732133777063e-07 0 2.809832133777063e-07 0.00021 2.809932133777063e-07 0 2.8104290225881364e-07 0 2.8105290225881365e-07 0.00021 2.8106290225881367e-07 0 2.8107966304251875e-07 0 2.8108966304251876e-07 0.00021 2.8109966304251877e-07 0 2.8109966304251877e-07 0 2.811096630425188e-07 0.00021 2.811196630425188e-07 0 2.811196630425188e-07 0 2.811296630425188e-07 0.00021 2.811396630425188e-07 0 2.811396630425188e-07 0 2.811496630425188e-07 0.00021 2.8115966304251884e-07 0 2.8115966304251884e-07 0 2.8116966304251885e-07 0.00021 2.8117966304251886e-07 0 2.8117966304251886e-07 0 2.8118966304251887e-07 0.00021 2.811996630425189e-07 0 2.811996630425189e-07 0 2.812096630425189e-07 0.00021 2.812196630425189e-07 0 2.812196630425189e-07 0 2.812296630425189e-07 0.00021 2.8123966304251893e-07 0 2.8127416860445246e-07 0 2.8128416860445247e-07 0.00021 2.812941686044525e-07 0 2.81301749961253e-07 0 2.81311749961253e-07 0.00021 2.8132174996125304e-07 0 2.813339464777031e-07 0 2.813439464777031e-07 0.00021 2.813539464777031e-07 0 2.813539464777031e-07 0 2.813639464777031e-07 0.00021 2.8137394647770313e-07 0 2.8137394647770313e-07 0 2.8138394647770315e-07 0.00021 2.8139394647770316e-07 0 2.8139394647770316e-07 0 2.8140394647770317e-07 0.00021 2.814139464777032e-07 0 2.814139464777032e-07 0 2.814239464777032e-07 0.00021 2.814339464777032e-07 0 2.814339464777032e-07 0 2.814439464777032e-07 0.00021 2.814539464777032e-07 0 2.814539464777032e-07 0 2.8146394647770324e-07 0.00021 2.8147394647770325e-07 0 2.8147394647770325e-07 0 2.8148394647770326e-07 0.00021 2.8149394647770327e-07 0 2.8149394647770327e-07 0 2.815039464777033e-07 0.00021 2.815139464777033e-07 0 2.815139464777033e-07 0 2.815239464777033e-07 0.00021 2.815339464777033e-07 0 2.815339464777033e-07 0 2.8154394647770333e-07 0.00021 2.8155394647770334e-07 0 2.815714006235286e-07 0 2.815814006235286e-07 0.00021 2.815914006235286e-07 0 2.815914006235286e-07 0 2.816014006235286e-07 0.00021 2.8161140062352863e-07 0 2.8161140062352863e-07 0 2.8162140062352864e-07 0.00021 2.8163140062352865e-07 0 2.8163140062352865e-07 0 2.8164140062352866e-07 0.00021 2.8165140062352867e-07 0 2.8166418804480814e-07 0 2.8167418804480815e-07 0.00021 2.8168418804480817e-07 0 2.8171395950048113e-07 0 2.8172395950048114e-07 0.00021 2.8173395950048115e-07 0 2.8173395950048115e-07 0 2.8174395950048116e-07 0.00021 2.817539595004812e-07 0 2.817539595004812e-07 0 2.817639595004812e-07 0.00021 2.817739595004812e-07 0 2.817739595004812e-07 0 2.817839595004812e-07 0.00021 2.817939595004812e-07 0 2.817939595004812e-07 0 2.8180395950048123e-07 0.00021 2.8181395950048124e-07 0 2.8181395950048124e-07 0 2.8182395950048126e-07 0.00021 2.8183395950048127e-07 0 2.818971209718323e-07 0 2.819071209718323e-07 0.00021 2.819171209718323e-07 0 2.8193414436803e-07 0 2.8194414436803e-07 0.00021 2.8195414436803e-07 0 2.8201430771904434e-07 0 2.8202430771904435e-07 0.00021 2.8203430771904436e-07 0 2.8203430771904436e-07 0 2.8204430771904437e-07 0.00021 2.820543077190444e-07 0 2.820687000820301e-07 0 2.820787000820301e-07 0.00021 2.820887000820301e-07 0 2.820887000820301e-07 0 2.820987000820301e-07 0.00021 2.8210870008203014e-07 0 2.821494058394646e-07 0 2.821594058394646e-07 0.00021 2.821694058394646e-07 0 2.822446839901686e-07 0 2.822546839901686e-07 0.00021 2.8226468399016863e-07 0 2.8226468399016863e-07 0 2.8227468399016864e-07 0.00021 2.8228468399016866e-07 0 2.8228468399016866e-07 0 2.8229468399016867e-07 0.00021 2.823046839901687e-07 0 2.823046839901687e-07 0 2.823146839901687e-07 0.00021 2.823246839901687e-07 0 2.823246839901687e-07 0 2.823346839901687e-07 0.00021 2.823446839901687e-07 0 2.823819628762774e-07 0 2.823919628762774e-07 0.00021 2.824019628762774e-07 0 2.824019628762774e-07 0 2.824119628762774e-07 0.00021 2.8242196287627743e-07 0 2.8244064076819813e-07 0 2.8245064076819815e-07 0.00021 2.8246064076819816e-07 0 2.8247034574370673e-07 0 2.8248034574370674e-07 0.00021 2.8249034574370675e-07 0 2.825102930066355e-07 0 2.825202930066355e-07 0.00021 2.8253029300663553e-07 0 2.8256929186706516e-07 0 2.8257929186706517e-07 0.00021 2.825892918670652e-07 0 2.8262833910590023e-07 0 2.8263833910590025e-07 0.00021 2.8264833910590026e-07 0 2.8270473860606504e-07 0 2.8271473860606505e-07 0.00021 2.8272473860606506e-07 0 2.8272473860606506e-07 0 2.8273473860606507e-07 0.00021 2.827447386060651e-07 0 2.827447386060651e-07 0 2.827547386060651e-07 0.00021 2.827647386060651e-07 0 2.8286014763406375e-07 0 2.8287014763406377e-07 0.00021 2.828801476340638e-07 0 2.828801476340638e-07 0 2.828901476340638e-07 0.00021 2.829001476340638e-07 0 2.829762254281278e-07 0 2.829862254281278e-07 0.00021 2.829962254281278e-07 0 2.8307307365918696e-07 0 2.83083073659187e-07 0.00021 2.83093073659187e-07 0 2.831321620119048e-07 0 2.831421620119048e-07 0.00021 2.8315216201190483e-07 0 2.8320818498621495e-07 0 2.8321818498621496e-07 0.00021 2.8322818498621497e-07 0 2.8326322059825004e-07 0 2.8327322059825006e-07 0.00021 2.8328322059825007e-07 0 2.8328322059825007e-07 0 2.832932205982501e-07 0.00021 2.833032205982501e-07 0 2.833116612451696e-07 0 2.833216612451696e-07 0.00021 2.8333166124516964e-07 0 2.8333166124516964e-07 0 2.8334166124516965e-07 0.00021 2.8335166124516966e-07 0 2.8335166124516966e-07 0 2.8336166124516967e-07 0.00021 2.833716612451697e-07 0 2.833716612451697e-07 0 2.833816612451697e-07 0.00021 2.833916612451697e-07 0 2.833935480135885e-07 0 2.834035480135885e-07 0.00021 2.834135480135885e-07 0 2.83427991112125e-07 0 2.83437991112125e-07 0.00021 2.83447991112125e-07 0 2.83449897247944e-07 0 2.8345989724794404e-07 0.00021 2.8346989724794405e-07 0 2.8346989724794405e-07 0 2.8347989724794406e-07 0.00021 2.8348989724794407e-07 0 2.8351780594851757e-07 0 2.835278059485176e-07 0.00021 2.835378059485176e-07 0 2.835378059485176e-07 0 2.835478059485176e-07 0.00021 2.835578059485176e-07 0 2.835693197913882e-07 0 2.835793197913882e-07 0.00021 2.835893197913882e-07 0 2.836868489148294e-07 0 2.836968489148294e-07 0.00021 2.837068489148294e-07 0 2.8373747211184457e-07 0 2.837474721118446e-07 0.00021 2.837574721118446e-07 0 2.837574721118446e-07 0 2.837674721118446e-07 0.00021 2.837774721118446e-07 0 2.838253791639837e-07 0 2.838353791639837e-07 0.00021 2.8384537916398374e-07 0 2.8384537916398374e-07 0 2.8385537916398375e-07 0.00021 2.8386537916398376e-07 0 2.8386537916398376e-07 0 2.8387537916398377e-07 0.00021 2.838853791639838e-07 0 2.838853791639838e-07 0 2.838953791639838e-07 0.00021 2.839053791639838e-07 0 2.839053791639838e-07 0 2.839153791639838e-07 0.00021 2.839253791639838e-07 0 2.839253791639838e-07 0 2.8393537916398384e-07 0.00021 2.8394537916398385e-07 0 2.839763484619869e-07 0 2.839863484619869e-07 0.00021 2.839963484619869e-07 0 2.839967688698769e-07 0 2.840067688698769e-07 0.00021 2.840167688698769e-07 0 2.840167688698769e-07 0 2.840267688698769e-07 0.00021 2.840367688698769e-07 0 2.840367688698769e-07 0 2.8404676886987693e-07 0.00021 2.8405676886987694e-07 0 2.84063144782018e-07 0 2.8407314478201803e-07 0.00021 2.8408314478201804e-07 0 2.8408314478201804e-07 0 2.8409314478201805e-07 0.00021 2.8410314478201807e-07 0 2.8410314478201807e-07 0 2.841131447820181e-07 0.00021 2.841231447820181e-07 0 2.841231447820181e-07 0 2.841331447820181e-07 0.00021 2.841431447820181e-07 0 2.8414569470463846e-07 0 2.8415569470463847e-07 0.00021 2.841656947046385e-07 0 2.842399141697686e-07 0 2.842499141697686e-07 0.00021 2.8425991416976863e-07 0 2.8426067471596825e-07 0 2.8427067471596826e-07 0.00021 2.8428067471596827e-07 0 2.8429514677850305e-07 0 2.8430514677850306e-07 0.00021 2.843151467785031e-07 0 2.843151467785031e-07 0 2.843251467785031e-07 0.00021 2.843351467785031e-07 0 2.843351467785031e-07 0 2.843451467785031e-07 0.00021 2.843551467785031e-07 0 2.843551467785031e-07 0 2.8436514677850313e-07 0.00021 2.8437514677850314e-07 0 2.8437514677850314e-07 0 2.8438514677850315e-07 0.00021 2.8439514677850316e-07 0 2.844322425455075e-07 0 2.844422425455075e-07 0.00021 2.844522425455075e-07 0 2.844522425455075e-07 0 2.844622425455075e-07 0.00021 2.844722425455075e-07 0 2.844936083975454e-07 0 2.8450360839754544e-07 0.00021 2.8451360839754545e-07 0 2.845159109405626e-07 0 2.845259109405626e-07 0.00021 2.845359109405626e-07 0 2.8454405633257105e-07 0 2.8455405633257106e-07 0.00021 2.8456405633257107e-07 0 2.8456405633257107e-07 0 2.845740563325711e-07 0.00021 2.845840563325711e-07 0 2.84599285430892e-07 0 2.84609285430892e-07 0.00021 2.8461928543089203e-07 0 2.8461928543089203e-07 0 2.8462928543089204e-07 0.00021 2.8463928543089205e-07 0 2.8471401759287756e-07 0 2.8472401759287757e-07 0.00021 2.847340175928776e-07 0 2.8474059673519086e-07 0 2.8475059673519087e-07 0.00021 2.847605967351909e-07 0 2.847605967351909e-07 0 2.847705967351909e-07 0.00021 2.847805967351909e-07 0 2.847805967351909e-07 0 2.847905967351909e-07 0.00021 2.8480059673519093e-07 0 2.8480059673519093e-07 0 2.8481059673519094e-07 0.00021 2.8482059673519095e-07 0 2.848265735808943e-07 0 2.848365735808943e-07 0.00021 2.848465735808943e-07 0 2.848465735808943e-07 0 2.8485657358089433e-07 0.00021 2.8486657358089434e-07 0 2.8486657358089434e-07 0 2.8487657358089435e-07 0.00021 2.8488657358089436e-07 0 2.8488657358089436e-07 0 2.848965735808944e-07 0.00021 2.849065735808944e-07 0 2.8494673403937695e-07 0 2.8495673403937696e-07 0.00021 2.84966734039377e-07 0 2.84966734039377e-07 0 2.84976734039377e-07 0.00021 2.84986734039377e-07 0 2.84986734039377e-07 0 2.84996734039377e-07 0.00021 2.85006734039377e-07 0 2.8501441982183655e-07 0 2.8502441982183656e-07 0.00021 2.8503441982183657e-07 0 2.8503441982183657e-07 0 2.850444198218366e-07 0.00021 2.850544198218366e-07 0 2.850544198218366e-07 0 2.850644198218366e-07 0.00021 2.850744198218366e-07 0 2.850744198218366e-07 0 2.8508441982183663e-07 0.00021 2.8509441982183664e-07 0 2.851030318769696e-07 0 2.851130318769696e-07 0.00021 2.851230318769696e-07 0 2.851230318769696e-07 0 2.8513303187696963e-07 0.00021 2.8514303187696964e-07 0 2.8514303187696964e-07 0 2.8515303187696965e-07 0.00021 2.8516303187696966e-07 0 2.851752099444471e-07 0 2.851852099444471e-07 0.00021 2.851952099444471e-07 0 2.851952099444471e-07 0 2.852052099444471e-07 0.00021 2.8521520994444713e-07 0 2.8521520994444713e-07 0 2.8522520994444714e-07 0.00021 2.8523520994444715e-07 0 2.852358693819693e-07 0 2.8524586938196934e-07 0.00021 2.8525586938196935e-07 0 2.853490184805641e-07 0 2.8535901848056414e-07 0.00021 2.8536901848056415e-07 0 2.8536901848056415e-07 0 2.8537901848056416e-07 0.00021 2.8538901848056417e-07 0 2.8539150475482425e-07 0 2.8540150475482426e-07 0.00021 2.8541150475482427e-07 0 2.8541150475482427e-07 0 2.854215047548243e-07 0.00021 2.854315047548243e-07 0 2.854813639208028e-07 0 2.854913639208028e-07 0.00021 2.855013639208028e-07 0 2.855013639208028e-07 0 2.8551136392080283e-07 0.00021 2.8552136392080285e-07 0 2.8553220989444166e-07 0 2.8554220989444167e-07 0.00021 2.855522098944417e-07 0 2.855713100172522e-07 0 2.855813100172522e-07 0.00021 2.855913100172522e-07 0 2.855913100172522e-07 0 2.856013100172522e-07 0.00021 2.856113100172522e-07 0 2.856113100172522e-07 0 2.8562131001725223e-07 0.00021 2.8563131001725225e-07 0 2.8563131001725225e-07 0 2.8564131001725226e-07 0.00021 2.8565131001725227e-07 0 2.8565131001725227e-07 0 2.856613100172523e-07 0.00021 2.856713100172523e-07 0 2.856713100172523e-07 0 2.856813100172523e-07 0.00021 2.856913100172523e-07 0 2.856913100172523e-07 0 2.857013100172523e-07 0.00021 2.8571131001725234e-07 0 2.8571131001725234e-07 0 2.8572131001725235e-07 0.00021 2.8573131001725236e-07 0 2.8573131001725236e-07 0 2.8574131001725237e-07 0.00021 2.857513100172524e-07 0 2.857832555408036e-07 0 2.857932555408036e-07 0.00021 2.858032555408036e-07 0 2.858313014378198e-07 0 2.858413014378198e-07 0.00021 2.8585130143781983e-07 0 2.859007134508672e-07 0 2.859107134508672e-07 0.00021 2.859207134508672e-07 0 2.859439976628214e-07 0 2.859539976628214e-07 0.00021 2.8596399766282143e-07 0 2.859802401684536e-07 0 2.8599024016845363e-07 0.00021 2.8600024016845364e-07 0 2.860135602909688e-07 0 2.860235602909688e-07 0.00021 2.860335602909688e-07 0 2.860335602909688e-07 0 2.860435602909688e-07 0.00021 2.8605356029096883e-07 0 2.8605356029096883e-07 0 2.8606356029096885e-07 0.00021 2.8607356029096886e-07 0 2.861242779681506e-07 0 2.861342779681506e-07 0.00021 2.861442779681506e-07 0 2.861442779681506e-07 0 2.861542779681506e-07 0.00021 2.8616427796815063e-07 0 2.8616427796815063e-07 0 2.8617427796815064e-07 0.00021 2.8618427796815065e-07 0 2.8618427796815065e-07 0 2.8619427796815067e-07 0.00021 2.862042779681507e-07 0 2.862042779681507e-07 0 2.862142779681507e-07 0.00021 2.862242779681507e-07 0 2.862242779681507e-07 0 2.862342779681507e-07 0.00021 2.862442779681507e-07 0 2.862442779681507e-07 0 2.8625427796815073e-07 0.00021 2.8626427796815074e-07 0 2.8626427796815074e-07 0 2.8627427796815076e-07 0.00021 2.8628427796815077e-07 0 2.8629313530123376e-07 0 2.863031353012338e-07 0.00021 2.863131353012338e-07 0 2.8635289528669083e-07 0 2.8636289528669085e-07 0.00021 2.8637289528669086e-07 0 2.8637289528669086e-07 0 2.8638289528669087e-07 0.00021 2.863928952866909e-07 0 2.865026588356738e-07 0 2.865126588356738e-07 0.00021 2.865226588356738e-07 0 2.8659847075480053e-07 0 2.8660847075480054e-07 0.00021 2.8661847075480055e-07 0 2.86624203937894e-07 0 2.8663420393789403e-07 0.00021 2.8664420393789404e-07 0 2.8664420393789404e-07 0 2.8665420393789405e-07 0.00021 2.8666420393789407e-07 0 2.8666420393789407e-07 0 2.866742039378941e-07 0.00021 2.866842039378941e-07 0 2.866842039378941e-07 0 2.866942039378941e-07 0.00021 2.867042039378941e-07 0 2.867042039378941e-07 0 2.867142039378941e-07 0.00021 2.8672420393789413e-07 0 2.8672420393789413e-07 0 2.8673420393789415e-07 0.00021 2.8674420393789416e-07 0 2.8674670615922384e-07 0 2.8675670615922385e-07 0.00021 2.8676670615922386e-07 0 2.8676670615922386e-07 0 2.8677670615922387e-07 0.00021 2.867867061592239e-07 0 2.867867061592239e-07 0 2.867967061592239e-07 0.00021 2.868067061592239e-07 0 2.868067061592239e-07 0 2.868167061592239e-07 0.00021 2.8682670615922393e-07 0 2.8682670615922393e-07 0 2.8683670615922394e-07 0.00021 2.8684670615922395e-07 0 2.8684670615922395e-07 0 2.8685670615922396e-07 0.00021 2.8686670615922397e-07 0 2.8686670615922397e-07 0 2.86876706159224e-07 0.00021 2.86886706159224e-07 0 2.86886706159224e-07 0 2.86896706159224e-07 0.00021 2.86906706159224e-07 0 2.86906706159224e-07 0 2.8691670615922403e-07 0.00021 2.8692670615922404e-07 0 2.8692670615922404e-07 0 2.8693670615922405e-07 0.00021 2.8694670615922406e-07 0 2.8694670615922406e-07 0 2.869567061592241e-07 0.00021 2.869667061592241e-07 0 2.869667061592241e-07 0 2.869767061592241e-07 0.00021 2.869867061592241e-07 0 2.869867061592241e-07 0 2.869967061592241e-07 0.00021 2.8700670615922413e-07 0 2.8700670615922413e-07 0 2.8701670615922414e-07 0.00021 2.8702670615922415e-07 0 2.8702670615922415e-07 0 2.8703670615922417e-07 0.00021 2.870467061592242e-07 0 2.8712254094025596e-07 0 2.8713254094025597e-07 0.00021 2.87142540940256e-07 0 2.872388645452772e-07 0 2.872488645452772e-07 0.00021 2.872588645452772e-07 0 2.8729953278515945e-07 0 2.8730953278515946e-07 0.00021 2.8731953278515947e-07 0 2.8731953278515947e-07 0 2.873295327851595e-07 0.00021 2.873395327851595e-07 0 2.873395327851595e-07 0 2.873495327851595e-07 0.00021 2.873595327851595e-07 0 2.873595327851595e-07 0 2.8736953278515953e-07 0.00021 2.8737953278515954e-07 0 2.8737953278515954e-07 0 2.8738953278515955e-07 0.00021 2.8739953278515956e-07 0 2.8739953278515956e-07 0 2.8740953278515957e-07 0.00021 2.874195327851596e-07 0 2.87438543680621e-07 0 2.87448543680621e-07 0.00021 2.87458543680621e-07 0 2.87458543680621e-07 0 2.87468543680621e-07 0.00021 2.8747854368062103e-07 0 2.8747854368062103e-07 0 2.8748854368062104e-07 0.00021 2.8749854368062105e-07 0 2.8749854368062105e-07 0 2.8750854368062106e-07 0.00021 2.875185436806211e-07 0 2.875185436806211e-07 0 2.875285436806211e-07 0.00021 2.875385436806211e-07 0 2.8754945277901305e-07 0 2.8755945277901306e-07 0.00021 2.875694527790131e-07 0 2.875694527790131e-07 0 2.875794527790131e-07 0.00021 2.875894527790131e-07 0 2.876320640599503e-07 0 2.876420640599503e-07 0.00021 2.876520640599503e-07 0 2.876520640599503e-07 0 2.8766206405995034e-07 0.00021 2.8767206405995035e-07 0 2.8767206405995035e-07 0 2.8768206405995036e-07 0.00021 2.8769206405995037e-07 0 2.876965622096523e-07 0 2.877065622096523e-07 0.00021 2.877165622096523e-07 0 2.877165622096523e-07 0 2.877265622096523e-07 0.00021 2.8773656220965233e-07 0 2.8773677689667587e-07 0 2.877467768966759e-07 0.00021 2.877567768966759e-07 0 2.877567768966759e-07 0 2.877667768966759e-07 0.00021 2.877767768966759e-07 0 2.878729832621912e-07 0 2.878829832621912e-07 0.00021 2.878929832621912e-07 0 2.878929832621912e-07 0 2.879029832621912e-07 0.00021 2.879129832621912e-07 0 2.879129832621912e-07 0 2.8792298326219123e-07 0.00021 2.8793298326219125e-07 0 2.8793298326219125e-07 0 2.8794298326219126e-07 0.00021 2.8795298326219127e-07 0 2.8795298326219127e-07 0 2.879629832621913e-07 0.00021 2.879729832621913e-07 0 2.879729832621913e-07 0 2.879829832621913e-07 0.00021 2.879929832621913e-07 0 2.879929832621913e-07 0 2.880029832621913e-07 0.00021 2.8801298326219134e-07 0 2.8801298326219134e-07 0 2.8802298326219135e-07 0.00021 2.8803298326219136e-07 0 2.8803298326219136e-07 0 2.8804298326219137e-07 0.00021 2.880529832621914e-07 0 2.880529832621914e-07 0 2.880629832621914e-07 0.00021 2.880729832621914e-07 0 2.880729832621914e-07 0 2.880829832621914e-07 0.00021 2.8809298326219143e-07 0 2.8809298326219143e-07 0 2.8810298326219144e-07 0.00021 2.8811298326219145e-07 0 2.881226786255449e-07 0 2.881326786255449e-07 0.00021 2.881426786255449e-07 0 2.881426786255449e-07 0 2.881526786255449e-07 0.00021 2.8816267862554493e-07 0 2.881969713482222e-07 0 2.882069713482222e-07 0.00021 2.882169713482222e-07 0 2.8849176996340603e-07 0 2.8850176996340604e-07 0.00021 2.8851176996340605e-07 0 2.8851176996340605e-07 0 2.8852176996340607e-07 0.00021 2.885317699634061e-07 0 2.8857123610768275e-07 0 2.8858123610768276e-07 0.00021 2.8859123610768277e-07 0 2.885960786509696e-07 0 2.886060786509696e-07 0.00021 2.886160786509696e-07 0 2.886160786509696e-07 0 2.886260786509696e-07 0.00021 2.8863607865096963e-07 0 2.8863607865096963e-07 0 2.8864607865096964e-07 0.00021 2.8865607865096965e-07 0 2.8865607865096965e-07 0 2.8866607865096967e-07 0.00021 2.886760786509697e-07 0 2.887132870314313e-07 0 2.887232870314313e-07 0.00021 2.887332870314313e-07 0 2.887332870314313e-07 0 2.887432870314313e-07 0.00021 2.8875328703143133e-07 0 2.8875328703143133e-07 0 2.8876328703143134e-07 0.00021 2.8877328703143135e-07 0 2.8877328703143135e-07 0 2.8878328703143136e-07 0.00021 2.887932870314314e-07 0 2.8880768037406077e-07 0 2.888176803740608e-07 0.00021 2.888276803740608e-07 0 2.888276803740608e-07 0 2.888376803740608e-07 0.00021 2.888476803740608e-07 0 2.888489561267505e-07 0 2.888589561267505e-07 0.00021 2.8886895612675053e-07 0 2.8886930557181806e-07 0 2.8887930557181807e-07 0.00021 2.888893055718181e-07 0 2.888893055718181e-07 0 2.888993055718181e-07 0.00021 2.889093055718181e-07 0 2.889093055718181e-07 0 2.889193055718181e-07 0.00021 2.889293055718181e-07 0 2.889855042914498e-07 0 2.889955042914498e-07 0.00021 2.890055042914498e-07 0 2.890055042914498e-07 0 2.890155042914498e-07 0.00021 2.8902550429144983e-07 0 2.8910133095133084e-07 0 2.8911133095133085e-07 0.00021 2.8912133095133086e-07 0 2.8912133095133086e-07 0 2.8913133095133087e-07 0.00021 2.891413309513309e-07 0 2.8914455904452945e-07 0 2.8915455904452946e-07 0.00021 2.8916455904452947e-07 0 2.8918183845988256e-07 0 2.8919183845988257e-07 0.00021 2.892018384598826e-07 0 2.892018384598826e-07 0 2.892118384598826e-07 0.00021 2.892218384598826e-07 0 2.8927579600400366e-07 0 2.892857960040037e-07 0.00021 2.892957960040037e-07 0 2.894319475856853e-07 0 2.894419475856853e-07 0.00021 2.8945194758568534e-07 0 2.894590331004924e-07 0 2.894690331004924e-07 0.00021 2.894790331004924e-07 0 2.8956911887259306e-07 0 2.8957911887259307e-07 0.00021 2.895891188725931e-07 0 2.895891188725931e-07 0 2.895991188725931e-07 0.00021 2.896091188725931e-07 0 2.89716056389101e-07 0 2.89726056389101e-07 0.00021 2.8973605638910103e-07 0 2.8973605638910103e-07 0 2.8974605638910105e-07 0.00021 2.8975605638910106e-07 0 2.8975605638910106e-07 0 2.8976605638910107e-07 0.00021 2.897760563891011e-07 0 2.897760563891011e-07 0 2.897860563891011e-07 0.00021 2.897960563891011e-07 0 2.897960563891011e-07 0 2.898060563891011e-07 0.00021 2.898160563891011e-07 0 2.898160563891011e-07 0 2.8982605638910114e-07 0.00021 2.8983605638910115e-07 0 2.8983605638910115e-07 0 2.8984605638910116e-07 0.00021 2.8985605638910117e-07 0 2.8985605638910117e-07 0 2.898660563891012e-07 0.00021 2.898760563891012e-07 0 2.898760563891012e-07 0 2.898860563891012e-07 0.00021 2.898960563891012e-07 0 2.898960563891012e-07 0 2.8990605638910123e-07 0.00021 2.8991605638910124e-07 0 2.8991605638910124e-07 0 2.8992605638910125e-07 0.00021 2.8993605638910126e-07 0 2.8993605638910126e-07 0 2.8994605638910127e-07 0.00021 2.899560563891013e-07 0 2.899560563891013e-07 0 2.899660563891013e-07 0.00021 2.899760563891013e-07 0 2.899760563891013e-07 0 2.899860563891013e-07 0.00021 2.8999605638910133e-07 0 2.8999605638910133e-07 0 2.9000605638910134e-07 0.00021 2.9001605638910135e-07 0 2.900309222019524e-07 0 2.9004092220195243e-07 0.00021 2.9005092220195244e-07 0 2.9005092220195244e-07 0 2.9006092220195245e-07 0.00021 2.9007092220195247e-07 0 2.9007092220195247e-07 0 2.900809222019525e-07 0.00021 2.900909222019525e-07 0 2.900909222019525e-07 0 2.901009222019525e-07 0.00021 2.901109222019525e-07 0 2.901109222019525e-07 0 2.901209222019525e-07 0.00021 2.9013092220195253e-07 0 2.9013092220195253e-07 0 2.9014092220195255e-07 0.00021 2.9015092220195256e-07 0 2.9015092220195256e-07 0 2.9016092220195257e-07 0.00021 2.901709222019526e-07 0 2.901855628960326e-07 0 2.901955628960326e-07 0.00021 2.9020556289603264e-07 0 2.902093282251826e-07 0 2.902193282251826e-07 0.00021 2.902293282251826e-07 0 2.90263052755314e-07 0 2.90273052755314e-07 0.00021 2.9028305275531403e-07 0 2.9028305275531403e-07 0 2.9029305275531404e-07 0.00021 2.9030305275531405e-07 0 2.9030305275531405e-07 0 2.9031305275531407e-07 0.00021 2.903230527553141e-07 0 2.903230527553141e-07 0 2.903330527553141e-07 0.00021 2.903430527553141e-07 0 2.903430527553141e-07 0 2.903530527553141e-07 0.00021 2.903630527553141e-07 0 2.903630527553141e-07 0 2.9037305275531413e-07 0.00021 2.9038305275531415e-07 0 2.9038305275531415e-07 0 2.9039305275531416e-07 0.00021 2.9040305275531417e-07 0 2.9040305275531417e-07 0 2.904130527553142e-07 0.00021 2.904230527553142e-07 0 2.9043378027953897e-07 0 2.90443780279539e-07 0.00021 2.90453780279539e-07 0 2.905130212895376e-07 0 2.905230212895376e-07 0.00021 2.905330212895376e-07 0 2.9058191319713115e-07 0 2.9059191319713116e-07 0.00021 2.9060191319713117e-07 0 2.9061366692735697e-07 0 2.90623666927357e-07 0.00021 2.90633666927357e-07 0 2.90633666927357e-07 0 2.90643666927357e-07 0.00021 2.90653666927357e-07 0 2.9067400209753744e-07 0 2.9068400209753745e-07 0.00021 2.9069400209753746e-07 0 2.9077433135909913e-07 0 2.9078433135909914e-07 0.00021 2.9079433135909915e-07 0 2.909406239862223e-07 0 2.909506239862223e-07 0.00021 2.909606239862223e-07 0 2.909606239862223e-07 0 2.909706239862223e-07 0.00021 2.9098062398622234e-07 0 2.9098062398622234e-07 0 2.9099062398622235e-07 0.00021 2.9100062398622236e-07 0 2.9100062398622236e-07 0 2.9101062398622237e-07 0.00021 2.910206239862224e-07 0 2.910206239862224e-07 0 2.910306239862224e-07 0.00021 2.910406239862224e-07 0 2.910406239862224e-07 0 2.910506239862224e-07 0.00021 2.9106062398622243e-07 0 2.9111285586304997e-07 0 2.9112285586305e-07 0.00021 2.9113285586305e-07 0 2.9118995809296415e-07 0 2.9119995809296416e-07 0.00021 2.912099580929642e-07 0 2.9127144346061046e-07 0 2.9128144346061047e-07 0.00021 2.912914434606105e-07 0 2.912914434606105e-07 0 2.913014434606105e-07 0.00021 2.913114434606105e-07 0 2.913114434606105e-07 0 2.913214434606105e-07 0.00021 2.9133144346061053e-07 0 2.91340355603822e-07 0 2.9135035560382204e-07 0.00021 2.9136035560382205e-07 0 2.913684196387666e-07 0 2.913784196387666e-07 0.00021 2.913884196387666e-07 0 2.913884196387666e-07 0 2.913984196387666e-07 0.00021 2.914084196387666e-07 0 2.914084196387666e-07 0 2.9141841963876664e-07 0.00021 2.9142841963876665e-07 0 2.9142841963876665e-07 0 2.9143841963876666e-07 0.00021 2.9144841963876667e-07 0 2.9144841963876667e-07 0 2.914584196387667e-07 0.00021 2.914684196387667e-07 0 2.914684196387667e-07 0 2.914784196387667e-07 0.00021 2.914884196387667e-07 0 2.914884196387667e-07 0 2.9149841963876673e-07 0.00021 2.9150841963876674e-07 0 2.9150841963876674e-07 0 2.9151841963876675e-07 0.00021 2.9152841963876676e-07 0 2.9155214728091376e-07 0 2.9156214728091377e-07 0.00021 2.915721472809138e-07 0 2.915721472809138e-07 0 2.915821472809138e-07 0.00021 2.915921472809138e-07 0 2.9163487954895966e-07 0 2.9164487954895967e-07 0.00021 2.916548795489597e-07 0 2.916548795489597e-07 0 2.916648795489597e-07 0.00021 2.916748795489597e-07 0 2.916894420139757e-07 0 2.916994420139757e-07 0.00021 2.917094420139757e-07 0 2.9171623889589397e-07 0 2.91726238895894e-07 0.00021 2.91736238895894e-07 0 2.91736238895894e-07 0 2.91746238895894e-07 0.00021 2.91756238895894e-07 0 2.918014028924432e-07 0 2.918114028924432e-07 0.00021 2.918214028924432e-07 0 2.918635804540798e-07 0 2.918735804540798e-07 0.00021 2.918835804540798e-07 0 2.9188675118949733e-07 0 2.9189675118949734e-07 0.00021 2.9190675118949736e-07 0 2.9194601820035746e-07 0 2.919560182003575e-07 0.00021 2.919660182003575e-07 0 2.919805478147648e-07 0 2.919905478147648e-07 0.00021 2.920005478147648e-07 0 2.920005478147648e-07 0 2.920105478147648e-07 0.00021 2.920205478147648e-07 0 2.920205478147648e-07 0 2.9203054781476483e-07 0.00021 2.9204054781476484e-07 0 2.9204054781476484e-07 0 2.9205054781476485e-07 0.00021 2.9206054781476486e-07 0 2.9207113264523335e-07 0 2.9208113264523337e-07 0.00021 2.920911326452334e-07 0 2.920911326452334e-07 0 2.921011326452334e-07 0.00021 2.921111326452334e-07 0 2.9211171864449866e-07 0 2.9212171864449867e-07 0.00021 2.921317186444987e-07 0 2.921393295512585e-07 0 2.921493295512585e-07 0.00021 2.921593295512585e-07 0 2.922210292936088e-07 0 2.922310292936088e-07 0.00021 2.9224102929360883e-07 0 2.9224102929360883e-07 0 2.9225102929360884e-07 0.00021 2.9226102929360886e-07 0 2.9226102929360886e-07 0 2.9227102929360887e-07 0.00021 2.922810292936089e-07 0 2.922810292936089e-07 0 2.922910292936089e-07 0.00021 2.923010292936089e-07 0 2.923010292936089e-07 0 2.923110292936089e-07 0.00021 2.923210292936089e-07 0 2.923210292936089e-07 0 2.9233102929360893e-07 0.00021 2.9234102929360895e-07 0 2.9236725409662974e-07 0 2.9237725409662975e-07 0.00021 2.9238725409662976e-07 0 2.9243643243241235e-07 0 2.9244643243241236e-07 0.00021 2.9245643243241237e-07 0 2.9245643243241237e-07 0 2.924664324324124e-07 0.00021 2.924764324324124e-07 0 2.924764324324124e-07 0 2.924864324324124e-07 0.00021 2.924964324324124e-07 0 2.924964324324124e-07 0 2.9250643243241243e-07 0.00021 2.9251643243241244e-07 0 2.9256003092964383e-07 0 2.9257003092964384e-07 0.00021 2.9258003092964385e-07 0 2.9258003092964385e-07 0 2.9259003092964386e-07 0.00021 2.926000309296439e-07 0 2.926000309296439e-07 0 2.926100309296439e-07 0.00021 2.926200309296439e-07 0 2.926316606508758e-07 0 2.9264166065087583e-07 0.00021 2.9265166065087584e-07 0 2.926640574368183e-07 0 2.926740574368183e-07 0.00021 2.9268405743681833e-07 0 2.9270407414560955e-07 0 2.9271407414560956e-07 0.00021 2.9272407414560957e-07 0 2.927929222490181e-07 0 2.928029222490181e-07 0.00021 2.928129222490181e-07 0 2.928129222490181e-07 0 2.928229222490181e-07 0.00021 2.928329222490181e-07 0 2.928329222490181e-07 0 2.9284292224901814e-07 0.00021 2.9285292224901815e-07 0 2.9287488041987447e-07 0 2.928848804198745e-07 0.00021 2.928948804198745e-07 0 2.928975064115553e-07 0 2.929075064115553e-07 0.00021 2.929175064115553e-07 0 2.930267460124719e-07 0 2.930367460124719e-07 0.00021 2.930467460124719e-07 0 2.930467460124719e-07 0 2.9305674601247193e-07 0.00021 2.9306674601247194e-07 0 2.9306674601247194e-07 0 2.9307674601247195e-07 0.00021 2.9308674601247197e-07 0 2.931940139474814e-07 0 2.932040139474814e-07 0.00021 2.9321401394748143e-07 0 2.932762167770846e-07 0 2.9328621677708463e-07 0.00021 2.9329621677708465e-07 0 2.9329621677708465e-07 0 2.9330621677708466e-07 0.00021 2.9331621677708467e-07 0 2.9331621677708467e-07 0 2.933262167770847e-07 0.00021 2.933362167770847e-07 0 2.933362167770847e-07 0 2.933462167770847e-07 0.00021 2.933562167770847e-07 0 2.933562167770847e-07 0 2.933662167770847e-07 0.00021 2.9337621677708474e-07 0 2.9343960999078685e-07 0 2.9344960999078686e-07 0.00021 2.9345960999078687e-07 0 2.9345960999078687e-07 0 2.934696099907869e-07 0.00021 2.934796099907869e-07 0 2.935340259036974e-07 0 2.935440259036974e-07 0.00021 2.935540259036974e-07 0 2.9358948121331534e-07 0 2.9359948121331535e-07 0.00021 2.9360948121331536e-07 0 2.9364372487685617e-07 0 2.936537248768562e-07 0.00021 2.936637248768562e-07 0 2.936637248768562e-07 0 2.936737248768562e-07 0.00021 2.936837248768562e-07 0 2.9368902252391834e-07 0 2.9369902252391835e-07 0.00021 2.9370902252391836e-07 0 2.937119207019701e-07 0 2.9372192070197013e-07 0.00021 2.9373192070197014e-07 0 2.9373192070197014e-07 0 2.9374192070197015e-07 0.00021 2.9375192070197016e-07 0 2.937750556832661e-07 0 2.937850556832661e-07 0.00021 2.937950556832661e-07 0 2.938122147155937e-07 0 2.938222147155937e-07 0.00021 2.938322147155937e-07 0 2.9385135144601677e-07 0 2.938613514460168e-07 0.00021 2.938713514460168e-07 0 2.9392289370946774e-07 0 2.9393289370946775e-07 0.00021 2.9394289370946776e-07 0 2.9395305689108494e-07 0 2.9396305689108495e-07 0.00021 2.9397305689108496e-07 0 2.9397305689108496e-07 0 2.9398305689108497e-07 0.00021 2.93993056891085e-07 0 2.93993056891085e-07 0 2.94003056891085e-07 0.00021 2.94013056891085e-07 0 2.940997477442796e-07 0 2.941097477442796e-07 0.00021 2.941197477442796e-07 0 2.9416998776127266e-07 0 2.9417998776127267e-07 0.00021 2.941899877612727e-07 0 2.941899877612727e-07 0 2.941999877612727e-07 0.00021 2.942099877612727e-07 0 2.942099877612727e-07 0 2.942199877612727e-07 0.00021 2.9422998776127273e-07 0 2.9424251813703606e-07 0 2.9425251813703607e-07 0.00021 2.942625181370361e-07 0 2.9428150831768937e-07 0 2.942915083176894e-07 0.00021 2.943015083176894e-07 0 2.943015083176894e-07 0 2.943115083176894e-07 0.00021 2.943215083176894e-07 0 2.943215083176894e-07 0 2.9433150831768943e-07 0.00021 2.9434150831768944e-07 0 2.9434150831768944e-07 0 2.9435150831768945e-07 0.00021 2.9436150831768946e-07 0 2.9436150831768946e-07 0 2.9437150831768947e-07 0.00021 2.943815083176895e-07 0 2.943815083176895e-07 0 2.943915083176895e-07 0.00021 2.944015083176895e-07 0 2.9443039760448356e-07 0 2.9444039760448357e-07 0.00021 2.944503976044836e-07 0 2.9447004678294175e-07 0 2.9448004678294176e-07 0.00021 2.9449004678294177e-07 0 2.945148856834215e-07 0 2.945248856834215e-07 0.00021 2.945348856834215e-07 0 2.945715198502768e-07 0 2.945815198502768e-07 0.00021 2.945915198502768e-07 0 2.945915198502768e-07 0 2.9460151985027683e-07 0.00021 2.9461151985027684e-07 0 2.9461151985027684e-07 0 2.9462151985027685e-07 0.00021 2.9463151985027686e-07 0 2.946651303474858e-07 0 2.946751303474858e-07 0.00021 2.946851303474858e-07 0 2.946851303474858e-07 0 2.946951303474858e-07 0.00021 2.9470513034748583e-07 0 2.9470513034748583e-07 0 2.9471513034748584e-07 0.00021 2.9472513034748585e-07 0 2.947634982070522e-07 0 2.947734982070522e-07 0.00021 2.947834982070522e-07 0 2.947834982070522e-07 0 2.947934982070522e-07 0.00021 2.9480349820705223e-07 0 2.9480349820705223e-07 0 2.9481349820705224e-07 0.00021 2.9482349820705225e-07 0 2.948675171549523e-07 0 2.948775171549523e-07 0.00021 2.948875171549523e-07 0 2.9491185399891324e-07 0 2.9492185399891326e-07 0.00021 2.9493185399891327e-07 0 2.9497079201094506e-07 0 2.9498079201094507e-07 0.00021 2.949907920109451e-07 0 2.9503319184221963e-07 0 2.9504319184221964e-07 0.00021 2.9505319184221965e-07 0 2.950560010194621e-07 0 2.950660010194621e-07 0.00021 2.9507600101946214e-07 0 2.9510086007096546e-07 0 2.951108600709655e-07 0.00021 2.951208600709655e-07 0 2.9521892178991224e-07 0 2.9522892178991226e-07 0.00021 2.9523892178991227e-07 0 2.952594568060635e-07 0 2.952694568060635e-07 0.00021 2.952794568060635e-07 0 2.952794568060635e-07 0 2.9528945680606353e-07 0.00021 2.9529945680606354e-07 0 2.953291994316523e-07 0 2.9533919943165233e-07 0.00021 2.9534919943165234e-07 0 2.9534919943165234e-07 0 2.9535919943165236e-07 0.00021 2.9536919943165237e-07 0 2.954147232926989e-07 0 2.954247232926989e-07 0.00021 2.9543472329269893e-07 0 2.9543472329269893e-07 0 2.9544472329269894e-07 0.00021 2.9545472329269895e-07 0 2.9545472329269895e-07 0 2.9546472329269896e-07 0.00021 2.95474723292699e-07 0 2.95474723292699e-07 0 2.95484723292699e-07 0.00021 2.95494723292699e-07 0 2.9565934366788414e-07 0 2.9566934366788415e-07 0.00021 2.9567934366788417e-07 0 2.956956531509424e-07 0 2.9570565315094244e-07 0.00021 2.9571565315094245e-07 0 2.95727757868148e-07 0 2.95737757868148e-07 0.00021 2.95747757868148e-07 0 2.95747757868148e-07 0 2.95757757868148e-07 0.00021 2.95767757868148e-07 0 2.95767757868148e-07 0 2.9577775786814803e-07 0.00021 2.9578775786814804e-07 0 2.9578775786814804e-07 0 2.9579775786814805e-07 0.00021 2.9580775786814807e-07 0 2.9580775786814807e-07 0 2.958177578681481e-07 0.00021 2.958277578681481e-07 0 2.9592359853123444e-07 0 2.9593359853123445e-07 0.00021 2.9594359853123446e-07 0 2.9604770425823445e-07 0 2.9605770425823446e-07 0.00021 2.9606770425823447e-07 0 2.961299649182443e-07 0 2.961399649182443e-07 0.00021 2.961499649182443e-07 0 2.9615424824274463e-07 0 2.9616424824274464e-07 0.00021 2.9617424824274465e-07 0 2.961887894636831e-07 0 2.961987894636831e-07 0.00021 2.962087894636831e-07 0 2.962087894636831e-07 0 2.9621878946368314e-07 0.00021 2.9622878946368315e-07 0 2.9624941633708996e-07 0 2.9625941633709e-07 0.00021 2.9626941633709e-07 0 2.9626941633709e-07 0 2.9627941633709e-07 0.00021 2.9628941633709e-07 0 2.9632759633280726e-07 0 2.9633759633280727e-07 0.00021 2.963475963328073e-07 0 2.963475963328073e-07 0 2.963575963328073e-07 0.00021 2.963675963328073e-07 0 2.964054679172679e-07 0 2.9641546791726794e-07 0.00021 2.9642546791726795e-07 0 2.9646373033152015e-07 0 2.9647373033152016e-07 0.00021 2.9648373033152017e-07 0 2.96554798349546e-07 0 2.9656479834954603e-07 0.00021 2.9657479834954604e-07 0 2.965752482961964e-07 0 2.965852482961964e-07 0.00021 2.965952482961964e-07 0 2.967026996660108e-07 0 2.967126996660108e-07 0.00021 2.967226996660108e-07 0 2.967226996660108e-07 0 2.967326996660108e-07 0.00021 2.9674269966601083e-07 0 2.9674269966601083e-07 0 2.9675269966601084e-07 0.00021 2.9676269966601085e-07 0 2.9676269966601085e-07 0 2.9677269966601086e-07 0.00021 2.967826996660109e-07 0 2.967826996660109e-07 0 2.967926996660109e-07 0.00021 2.968026996660109e-07 0 2.968026996660109e-07 0 2.968126996660109e-07 0.00021 2.968226996660109e-07 0 2.968226996660109e-07 0 2.9683269966601093e-07 0.00021 2.9684269966601094e-07 0 2.968706737800967e-07 0 2.968806737800967e-07 0.00021 2.968906737800967e-07 0 2.969308981488376e-07 0 2.969408981488376e-07 0.00021 2.969508981488376e-07 0 2.9695421578038147e-07 0 2.969642157803815e-07 0.00021 2.969742157803815e-07 0 2.969742157803815e-07 0 2.969842157803815e-07 0.00021 2.969942157803815e-07 0 2.970274686161603e-07 0 2.970374686161603e-07 0.00021 2.970474686161603e-07 0 2.970502463624335e-07 0 2.970602463624335e-07 0.00021 2.9707024636243353e-07 0 2.9707024636243353e-07 0 2.9708024636243354e-07 0.00021 2.9709024636243355e-07 0 2.970996498215556e-07 0 2.971096498215556e-07 0.00021 2.971196498215556e-07 0 2.971196498215556e-07 0 2.9712964982155564e-07 0.00021 2.9713964982155565e-07 0 2.9713964982155565e-07 0 2.9714964982155566e-07 0.00021 2.9715964982155567e-07 0 2.9722218716507714e-07 0 2.9723218716507715e-07 0.00021 2.9724218716507716e-07 0 2.9724218716507716e-07 0 2.972521871650772e-07 0.00021 2.972621871650772e-07 0 2.972768874174062e-07 0 2.972868874174062e-07 0.00021 2.972968874174062e-07 0 2.9736330423951977e-07 0 2.973733042395198e-07 0.00021 2.973833042395198e-07 0 2.973833042395198e-07 0 2.973933042395198e-07 0.00021 2.974033042395198e-07 0 2.974033042395198e-07 0 2.9741330423951983e-07 0.00021 2.9742330423951984e-07 0 2.9742330423951984e-07 0 2.9743330423951985e-07 0.00021 2.9744330423951986e-07 0 2.9744330423951986e-07 0 2.974533042395199e-07 0.00021 2.974633042395199e-07 0 2.975032320730862e-07 0 2.9751323207308623e-07 0.00021 2.9752323207308624e-07 0 2.975642615658869e-07 0 2.975742615658869e-07 0.00021 2.9758426156588693e-07 0 2.976067123336753e-07 0 2.976167123336753e-07 0.00021 2.976267123336753e-07 0 2.976267123336753e-07 0 2.9763671233367534e-07 0.00021 2.9764671233367535e-07 0 2.9764671233367535e-07 0 2.9765671233367536e-07 0.00021 2.9766671233367537e-07 0 2.9777157701619903e-07 0 2.9778157701619904e-07 0.00021 2.9779157701619905e-07 0 2.9783239032123407e-07 0 2.978423903212341e-07 0.00021 2.978523903212341e-07 0 2.978523903212341e-07 0 2.978623903212341e-07 0.00021 2.978723903212341e-07 0 2.978723903212341e-07 0 2.9788239032123413e-07 0.00021 2.9789239032123414e-07 0 2.9789239032123414e-07 0 2.9790239032123415e-07 0.00021 2.9791239032123416e-07 0 2.980209532944542e-07 0 2.980309532944542e-07 0.00021 2.980409532944542e-07 0 2.980631885231004e-07 0 2.9807318852310044e-07 0.00021 2.9808318852310045e-07 0 2.981692187395953e-07 0 2.981792187395953e-07 0.00021 2.981892187395953e-07 0 2.981892187395953e-07 0 2.981992187395953e-07 0.00021 2.9820921873959533e-07 0 2.982203832312972e-07 0 2.982303832312972e-07 0.00021 2.9824038323129724e-07 0 2.9824038323129724e-07 0 2.9825038323129725e-07 0.00021 2.9826038323129726e-07 0 2.982664665719548e-07 0 2.982764665719548e-07 0.00021 2.982864665719548e-07 0 2.9830344184204584e-07 0 2.9831344184204585e-07 0.00021 2.9832344184204586e-07 0 2.983781582185022e-07 0 2.983881582185022e-07 0.00021 2.983981582185022e-07 0 2.984484191440143e-07 0 2.984584191440143e-07 0.00021 2.984684191440143e-07 0 2.9848426692364287e-07 0 2.984942669236429e-07 0.00021 2.985042669236429e-07 0 2.985733048938682e-07 0 2.985833048938682e-07 0.00021 2.985933048938682e-07 0 2.9864937910772905e-07 0 2.9865937910772906e-07 0.00021 2.986693791077291e-07 0 2.9874632339743157e-07 0 2.987563233974316e-07 0.00021 2.987663233974316e-07 0 2.987663233974316e-07 0 2.987763233974316e-07 0.00021 2.987863233974316e-07 0 2.9879336714813916e-07 0 2.9880336714813917e-07 0.00021 2.988133671481392e-07 0 2.988509622275733e-07 0 2.988609622275733e-07 0.00021 2.988709622275733e-07 0 2.9891662520353383e-07 0 2.9892662520353384e-07 0.00021 2.9893662520353385e-07 0 2.9893662520353385e-07 0 2.9894662520353386e-07 0.00021 2.989566252035339e-07 0 2.9899676048603054e-07 0 2.9900676048603055e-07 0.00021 2.9901676048603056e-07 0 2.990416447512102e-07 0 2.9905164475121023e-07 0.00021 2.9906164475121024e-07 0 2.9909069066817445e-07 0 2.9910069066817446e-07 0.00021 2.991106906681745e-07 0 2.991290075082997e-07 0 2.991390075082997e-07 0.00021 2.9914900750829973e-07 0 2.991690804376372e-07 0 2.991790804376372e-07 0.00021 2.991890804376372e-07 0 2.991890804376372e-07 0 2.9919908043763723e-07 0.00021 2.9920908043763724e-07 0 2.9920908043763724e-07 0 2.9921908043763725e-07 0.00021 2.9922908043763727e-07 0 2.9922908043763727e-07 0 2.992390804376373e-07 0.00021 2.992490804376373e-07 0 2.9927299294744093e-07 0 2.9928299294744094e-07 0.00021 2.9929299294744095e-07 0 2.993102004706374e-07 0 2.993202004706374e-07 0.00021 2.993302004706374e-07 0 2.993302004706374e-07 0 2.993402004706374e-07 0.00021 2.993502004706374e-07 0 2.993502004706374e-07 0 2.9936020047063743e-07 0.00021 2.9937020047063744e-07 0 2.9937020047063744e-07 0 2.9938020047063745e-07 0.00021 2.9939020047063747e-07 0 2.9939020047063747e-07 0 2.994002004706375e-07 0.00021 2.994102004706375e-07 0 2.994102004706375e-07 0 2.994202004706375e-07 0.00021 2.994302004706375e-07 0 2.994302004706375e-07 0 2.994402004706375e-07 0.00021 2.9945020047063753e-07 0 2.9945020047063753e-07 0 2.9946020047063755e-07 0.00021 2.9947020047063756e-07 0 2.995467961267574e-07 0 2.995567961267574e-07 0.00021 2.995667961267574e-07 0 2.9959215279570113e-07 0 2.9960215279570114e-07 0.00021 2.9961215279570115e-07 0 2.996190288081847e-07 0 2.996290288081847e-07 0.00021 2.996390288081847e-07 0 2.9967761072380274e-07 0 2.9968761072380275e-07 0.00021 2.9969761072380276e-07 0 2.9969761072380276e-07 0 2.9970761072380277e-07 0.00021 2.997176107238028e-07 0 2.997176107238028e-07 0 2.997276107238028e-07 0.00021 2.997376107238028e-07 0 2.997376107238028e-07 0 2.997476107238028e-07 0.00021 2.9975761072380283e-07 0 2.99758115072821e-07 0 2.99768115072821e-07 0.00021 2.99778115072821e-07 0 2.99778115072821e-07 0 2.99788115072821e-07 0.00021 2.99798115072821e-07 0 2.9980865459359775e-07 0 2.9981865459359776e-07 0.00021 2.9982865459359777e-07 0 2.9982865459359777e-07 0 2.998386545935978e-07 0.00021 2.998486545935978e-07 0 2.999075083224775e-07 0 2.9991750832247753e-07 0.00021 2.9992750832247754e-07 0 3.000313789746517e-07 0 3.000413789746517e-07 0.00021 3.000513789746517e-07 0 3.000513789746517e-07 0 3.000613789746517e-07 0.00021 3.0007137897465173e-07 0 3.0007137897465173e-07 0 3.0008137897465174e-07 0.00021 3.0009137897465175e-07 0 3.0009137897465175e-07 0 3.0010137897465176e-07 0.00021 3.001113789746518e-07 0 3.001113789746518e-07 0 3.001213789746518e-07 0.00021 3.001313789746518e-07 0 3.001313789746518e-07 0 3.001413789746518e-07 0.00021 3.001513789746518e-07 0 3.0017102695965607e-07 0 3.001810269596561e-07 0.00021 3.001910269596561e-07 0 3.0020613979118434e-07 0 3.0021613979118435e-07 0.00021 3.0022613979118437e-07 0 3.0022613979118437e-07 0 3.002361397911844e-07 0.00021 3.002461397911844e-07 0 3.002461397911844e-07 0 3.002561397911844e-07 0.00021 3.002661397911844e-07 0 3.003185506208356e-07 0 3.0032855062083563e-07 0.00021 3.0033855062083564e-07 0 3.003396640223252e-07 0 3.003496640223252e-07 0.00021 3.003596640223252e-07 0 3.003780557265144e-07 0 3.003880557265144e-07 0.00021 3.003980557265144e-07 0 3.003980557265144e-07 0 3.004080557265144e-07 0.00021 3.004180557265144e-07 0 3.0042409433625934e-07 0 3.0043409433625935e-07 0.00021 3.0044409433625936e-07 0 3.0047653222198385e-07 0 3.0048653222198386e-07 0.00021 3.004965322219839e-07 0 3.005049144316835e-07 0 3.0051491443168353e-07 0.00021 3.0052491443168354e-07 0 3.005401383987683e-07 0 3.005501383987683e-07 0.00021 3.005601383987683e-07 0 3.006006217658951e-07 0 3.006106217658951e-07 0.00021 3.006206217658951e-07 0 3.00630381352606e-07 0 3.0064038135260603e-07 0.00021 3.0065038135260604e-07 0 3.0075356511343963e-07 0 3.0076356511343964e-07 0.00021 3.0077356511343966e-07 0 3.007992942957902e-07 0 3.008092942957902e-07 0.00021 3.008192942957902e-07 0 3.0082421038900474e-07 0 3.0083421038900475e-07 0.00021 3.0084421038900476e-07 0 3.008638214921985e-07 0 3.008738214921985e-07 0.00021 3.0088382149219853e-07 0 3.0088382149219853e-07 0 3.0089382149219854e-07 0.00021 3.0090382149219856e-07 0 3.0090382149219856e-07 0 3.0091382149219857e-07 0.00021 3.009238214921986e-07 0 3.009401887015766e-07 0 3.0095018870157664e-07 0.00021 3.0096018870157665e-07 0 3.0097150071995134e-07 0 3.0098150071995135e-07 0.00021 3.0099150071995136e-07 0 3.0099150071995136e-07 0 3.010015007199514e-07 0.00021 3.010115007199514e-07 0 3.010115007199514e-07 0 3.010215007199514e-07 0.00021 3.010315007199514e-07 0 3.010315007199514e-07 0 3.010415007199514e-07 0.00021 3.0105150071995143e-07 0 3.0107773422371276e-07 0 3.010877342237128e-07 0.00021 3.010977342237128e-07 0 3.010977342237128e-07 0 3.011077342237128e-07 0.00021 3.011177342237128e-07 0 3.011177342237128e-07 0 3.011277342237128e-07 0.00021 3.0113773422371283e-07 0 3.0113773422371283e-07 0 3.0114773422371284e-07 0.00021 3.0115773422371285e-07 0 3.0115773422371285e-07 0 3.0116773422371286e-07 0.00021 3.011777342237129e-07 0 3.011777342237129e-07 0 3.011877342237129e-07 0.00021 3.011977342237129e-07 0 3.011977342237129e-07 0 3.012077342237129e-07 0.00021 3.012177342237129e-07 0 3.012177342237129e-07 0 3.0122773422371293e-07 0.00021 3.0123773422371294e-07 0 3.0123773422371294e-07 0 3.0124773422371296e-07 0.00021 3.0125773422371297e-07 0 3.0125773422371297e-07 0 3.01267734223713e-07 0.00021 3.01277734223713e-07 0 3.01277734223713e-07 0 3.01287734223713e-07 0.00021 3.01297734223713e-07 0 3.01297734223713e-07 0 3.01307734223713e-07 0.00021 3.0131773422371303e-07 0 3.0131773422371303e-07 0 3.0132773422371305e-07 0.00021 3.0133773422371306e-07 0 3.0133773422371306e-07 0 3.0134773422371307e-07 0.00021 3.013577342237131e-07 0 3.0138444599147853e-07 0 3.0139444599147854e-07 0.00021 3.0140444599147855e-07 0 3.0140444599147855e-07 0 3.0141444599147856e-07 0.00021 3.0142444599147857e-07 0 3.0142444599147857e-07 0 3.014344459914786e-07 0.00021 3.014444459914786e-07 0 3.014444459914786e-07 0 3.014544459914786e-07 0.00021 3.014644459914786e-07 0 3.014644459914786e-07 0 3.0147444599147863e-07 0.00021 3.0148444599147864e-07 0 3.0148444599147864e-07 0 3.0149444599147865e-07 0.00021 3.0150444599147866e-07 0 3.0150444599147866e-07 0 3.015144459914787e-07 0.00021 3.015244459914787e-07 0 3.015244459914787e-07 0 3.015344459914787e-07 0.00021 3.015444459914787e-07 0 3.0156242152297794e-07 0 3.0157242152297795e-07 0.00021 3.0158242152297797e-07 0 3.0158242152297797e-07 0 3.01592421522978e-07 0.00021 3.01602421522978e-07 0 3.0178485662968475e-07 0 3.0179485662968476e-07 0.00021 3.0180485662968477e-07 0 3.0182543240926085e-07 0 3.0183543240926086e-07 0.00021 3.018454324092609e-07 0 3.020107657388545e-07 0 3.0202076573885453e-07 0.00021 3.0203076573885454e-07 0 3.0203076573885454e-07 0 3.0204076573885455e-07 0.00021 3.0205076573885456e-07 0 3.020550836449383e-07 0 3.020650836449383e-07 0.00021 3.020750836449383e-07 0 3.020750836449383e-07 0 3.0208508364493833e-07 0.00021 3.0209508364493834e-07 0 3.0209508364493834e-07 0 3.0210508364493835e-07 0.00021 3.0211508364493836e-07 0 3.0212000038989166e-07 0 3.0213000038989167e-07 0.00021 3.021400003898917e-07 0 3.0215657734552414e-07 0 3.0216657734552415e-07 0.00021 3.0217657734552416e-07 0 3.021941618143898e-07 0 3.0220416181438983e-07 0.00021 3.0221416181438984e-07 0 3.0221416181438984e-07 0 3.0222416181438985e-07 0.00021 3.0223416181438987e-07 0 3.022448622945704e-07 0 3.0225486229457043e-07 0.00021 3.0226486229457044e-07 0 3.0227383925488563e-07 0 3.0228383925488564e-07 0.00021 3.0229383925488565e-07 0 3.0229383925488565e-07 0 3.0230383925488566e-07 0.00021 3.023138392548857e-07 0 3.023138392548857e-07 0 3.023238392548857e-07 0.00021 3.023338392548857e-07 0 3.023338392548857e-07 0 3.023438392548857e-07 0.00021 3.023538392548857e-07 0 3.023538392548857e-07 0 3.0236383925488573e-07 0.00021 3.0237383925488574e-07 0 3.0237383925488574e-07 0 3.0238383925488575e-07 0.00021 3.0239383925488577e-07 0 3.0239383925488577e-07 0 3.024038392548858e-07 0.00021 3.024138392548858e-07 0 3.024138392548858e-07 0 3.024238392548858e-07 0.00021 3.024338392548858e-07 0 3.024338392548858e-07 0 3.024438392548858e-07 0.00021 3.0245383925488583e-07 0 3.0245383925488583e-07 0 3.0246383925488585e-07 0.00021 3.0247383925488586e-07 0 3.0247383925488586e-07 0 3.0248383925488587e-07 0.00021 3.024938392548859e-07 0 3.024938392548859e-07 0 3.025038392548859e-07 0.00021 3.025138392548859e-07 0 3.0255428651328625e-07 0 3.0256428651328626e-07 0.00021 3.0257428651328627e-07 0 3.0258827571346565e-07 0 3.0259827571346566e-07 0.00021 3.0260827571346567e-07 0 3.0260827571346567e-07 0 3.026182757134657e-07 0.00021 3.026282757134657e-07 0 3.026628902547866e-07 0 3.026728902547866e-07 0.00021 3.026828902547866e-07 0 3.026828902547866e-07 0 3.0269289025478663e-07 0.00021 3.0270289025478664e-07 0 3.0272508197097113e-07 0 3.0273508197097115e-07 0.00021 3.0274508197097116e-07 0 3.0274508197097116e-07 0 3.0275508197097117e-07 0.00021 3.027650819709712e-07 0 3.027650819709712e-07 0 3.027750819709712e-07 0.00021 3.027850819709712e-07 0 3.0283214987758773e-07 0 3.0284214987758775e-07 0.00021 3.0285214987758776e-07 0 3.0287540586819107e-07 0 3.028854058681911e-07 0.00021 3.028954058681911e-07 0 3.029002495848875e-07 0 3.0291024958488753e-07 0.00021 3.0292024958488754e-07 0 3.029314785782447e-07 0 3.029414785782447e-07 0.00021 3.0295147857824473e-07 0 3.029578145073955e-07 0 3.0296781450739553e-07 0.00021 3.0297781450739554e-07 0 3.030210538776368e-07 0 3.030310538776368e-07 0.00021 3.0304105387763683e-07 0 3.0304105387763683e-07 0 3.0305105387763684e-07 0.00021 3.0306105387763685e-07 0 3.0307367271782173e-07 0 3.0308367271782174e-07 0.00021 3.0309367271782175e-07 0 3.031145163901448e-07 0 3.031245163901448e-07 0.00021 3.031345163901448e-07 0 3.031345163901448e-07 0 3.0314451639014483e-07 0.00021 3.0315451639014484e-07 0 3.0315451639014484e-07 0 3.0316451639014485e-07 0.00021 3.0317451639014486e-07 0 3.0317451639014486e-07 0 3.031845163901449e-07 0.00021 3.031945163901449e-07 0 3.031945163901449e-07 0 3.032045163901449e-07 0.00021 3.032145163901449e-07 0 3.032229061593099e-07 0 3.032329061593099e-07 0.00021 3.032429061593099e-07 0 3.032429061593099e-07 0 3.0325290615930993e-07 0.00021 3.0326290615930994e-07 0 3.032751083093371e-07 0 3.032851083093371e-07 0.00021 3.0329510830933713e-07 0 3.0329510830933713e-07 0 3.0330510830933714e-07 0.00021 3.0331510830933715e-07 0 3.033160641365139e-07 0 3.0332606413651394e-07 0.00021 3.0333606413651395e-07 0 3.033364660408196e-07 0 3.033464660408196e-07 0.00021 3.033564660408196e-07 0 3.033673696041758e-07 0 3.0337736960417584e-07 0.00021 3.0338736960417585e-07 0 3.0338736960417585e-07 0 3.0339736960417586e-07 0.00021 3.0340736960417587e-07 0 3.0340736960417587e-07 0 3.034173696041759e-07 0.00021 3.034273696041759e-07 0 3.034273696041759e-07 0 3.034373696041759e-07 0.00021 3.034473696041759e-07 0 3.0345926074394857e-07 0 3.034692607439486e-07 0.00021 3.034792607439486e-07 0 3.0349174470040477e-07 0 3.035017447004048e-07 0.00021 3.035117447004048e-07 0 3.035117447004048e-07 0 3.035217447004048e-07 0.00021 3.035317447004048e-07 0 3.035844337856532e-07 0 3.035944337856532e-07 0.00021 3.036044337856532e-07 0 3.036867295164466e-07 0 3.036967295164466e-07 0.00021 3.0370672951644663e-07 0 3.0370672951644663e-07 0 3.0371672951644664e-07 0.00021 3.0372672951644666e-07 0 3.0372672951644666e-07 0 3.0373672951644667e-07 0.00021 3.037467295164467e-07 0 3.037467295164467e-07 0 3.037567295164467e-07 0.00021 3.037667295164467e-07 0 3.037667295164467e-07 0 3.037767295164467e-07 0.00021 3.037867295164467e-07 0 3.037867295164467e-07 0 3.0379672951644673e-07 0.00021 3.0380672951644675e-07 0 3.0380672951644675e-07 0 3.0381672951644676e-07 0.00021 3.0382672951644677e-07 0 3.038300100933056e-07 0 3.038400100933056e-07 0.00021 3.038500100933056e-07 0 3.038500100933056e-07 0 3.038600100933056e-07 0.00021 3.038700100933056e-07 0 3.0387245915594925e-07 0 3.0388245915594927e-07 0.00021 3.038924591559493e-07 0 3.038924591559493e-07 0 3.039024591559493e-07 0.00021 3.039124591559493e-07 0 3.039124591559493e-07 0 3.039224591559493e-07 0.00021 3.039324591559493e-07 0 3.039324591559493e-07 0 3.0394245915594933e-07 0.00021 3.0395245915594935e-07 0 3.0395245915594935e-07 0 3.0396245915594936e-07 0.00021 3.0397245915594937e-07 0 3.0397245915594937e-07 0 3.039824591559494e-07 0.00021 3.039924591559494e-07 0 3.04040376017124e-07 0 3.04050376017124e-07 0.00021 3.04060376017124e-07 0 3.0410749488226814e-07 0 3.0411749488226816e-07 0.00021 3.0412749488226817e-07 0 3.0412749488226817e-07 0 3.041374948822682e-07 0.00021 3.041474948822682e-07 0 3.0428959491836486e-07 0 3.042995949183649e-07 0.00021 3.043095949183649e-07 0 3.043095949183649e-07 0 3.043195949183649e-07 0.00021 3.043295949183649e-07 0 3.043295949183649e-07 0 3.043395949183649e-07 0.00021 3.0434959491836493e-07 0 3.0434959491836493e-07 0 3.0435959491836494e-07 0.00021 3.0436959491836495e-07 0 3.0436959491836495e-07 0 3.0437959491836497e-07 0.00021 3.04389594918365e-07 0 3.04389594918365e-07 0 3.04399594918365e-07 0.00021 3.04409594918365e-07 0 3.04409594918365e-07 0 3.04419594918365e-07 0.00021 3.04429594918365e-07 0 3.04429594918365e-07 0 3.0443959491836503e-07 0.00021 3.0444959491836505e-07 0 3.0444959491836505e-07 0 3.0445959491836506e-07 0.00021 3.0446959491836507e-07 0 3.0446959491836507e-07 0 3.044795949183651e-07 0.00021 3.044895949183651e-07 0 3.044895949183651e-07 0 3.044995949183651e-07 0.00021 3.045095949183651e-07 0 3.045095949183651e-07 0 3.045195949183651e-07 0.00021 3.0452959491836514e-07 0 3.0453519506644284e-07 0 3.0454519506644285e-07 0.00021 3.0455519506644286e-07 0 3.0455519506644286e-07 0 3.0456519506644287e-07 0.00021 3.045751950664429e-07 0 3.045751950664429e-07 0 3.045851950664429e-07 0.00021 3.045951950664429e-07 0 3.045951950664429e-07 0 3.046051950664429e-07 0.00021 3.0461519506644293e-07 0 3.0461519506644293e-07 0 3.0462519506644294e-07 0.00021 3.0463519506644295e-07 0 3.0463519506644295e-07 0 3.0464519506644296e-07 0.00021 3.04655195066443e-07 0 3.04655195066443e-07 0 3.04665195066443e-07 0.00021 3.04675195066443e-07 0 3.04675195066443e-07 0 3.04685195066443e-07 0.00021 3.04695195066443e-07 0 3.04695195066443e-07 0 3.0470519506644303e-07 0.00021 3.0471519506644304e-07 0 3.0471519506644304e-07 0 3.0472519506644305e-07 0.00021 3.0473519506644307e-07 0 3.0474086529147465e-07 0 3.0475086529147467e-07 0.00021 3.047608652914747e-07 0 3.047608652914747e-07 0 3.047708652914747e-07 0.00021 3.047808652914747e-07 0 3.047808652914747e-07 0 3.047908652914747e-07 0.00021 3.048008652914747e-07 0 3.048008652914747e-07 0 3.0481086529147473e-07 0.00021 3.0482086529147474e-07 0 3.048217722940479e-07 0 3.048317722940479e-07 0.00021 3.048417722940479e-07 0 3.048417722940479e-07 0 3.048517722940479e-07 0.00021 3.048617722940479e-07 0 3.048617722940479e-07 0 3.0487177229404794e-07 0.00021 3.0488177229404795e-07 0 3.0488177229404795e-07 0 3.0489177229404796e-07 0.00021 3.0490177229404797e-07 0 3.0490177229404797e-07 0 3.04911772294048e-07 0.00021 3.04921772294048e-07 0 3.04921772294048e-07 0 3.04931772294048e-07 0.00021 3.04941772294048e-07 0 3.04941772294048e-07 0 3.0495177229404803e-07 0.00021 3.0496177229404804e-07 0 3.050399061554733e-07 0 3.050499061554733e-07 0.00021 3.050599061554733e-07 0 3.0515340066288804e-07 0 3.0516340066288805e-07 0.00021 3.0517340066288806e-07 0 3.052216992300386e-07 0 3.052316992300386e-07 0.00021 3.052416992300386e-07 0 3.0528518643417523e-07 0 3.0529518643417524e-07 0.00021 3.0530518643417525e-07 0 3.0530518643417525e-07 0 3.0531518643417526e-07 0.00021 3.053251864341753e-07 0 3.0533412507961144e-07 0 3.0534412507961145e-07 0.00021 3.0535412507961146e-07 0 3.0538846275230337e-07 0 3.053984627523034e-07 0.00021 3.054084627523034e-07 0 3.054084627523034e-07 0 3.054184627523034e-07 0.00021 3.054284627523034e-07 0 3.054432722616229e-07 0 3.054532722616229e-07 0.00021 3.054632722616229e-07 0 3.056400070932872e-07 0 3.056500070932872e-07 0.00021 3.056600070932872e-07 0 3.056625740018144e-07 0 3.0567257400181443e-07 0.00021 3.0568257400181444e-07 0 3.0578677434025375e-07 0 3.0579677434025377e-07 0.00021 3.058067743402538e-07 0 3.058067743402538e-07 0 3.058167743402538e-07 0.00021 3.058267743402538e-07 0 3.058267743402538e-07 0 3.058367743402538e-07 0.00021 3.058467743402538e-07 0 3.058467743402538e-07 0 3.0585677434025383e-07 0.00021 3.0586677434025385e-07 0 3.0586677434025385e-07 0 3.0587677434025386e-07 0.00021 3.0588677434025387e-07 0 3.0588677434025387e-07 0 3.058967743402539e-07 0.00021 3.059067743402539e-07 0 3.059067743402539e-07 0 3.059167743402539e-07 0.00021 3.059267743402539e-07 0 3.059639787768604e-07 0 3.059739787768604e-07 0.00021 3.059839787768604e-07 0 3.059839787768604e-07 0 3.0599397877686043e-07 0.00021 3.0600397877686044e-07 0 3.0600397877686044e-07 0 3.0601397877686045e-07 0.00021 3.0602397877686046e-07 0 3.0602397877686046e-07 0 3.060339787768605e-07 0.00021 3.060439787768605e-07 0 3.060439787768605e-07 0 3.060539787768605e-07 0.00021 3.060639787768605e-07 0 3.060715370220821e-07 0 3.060815370220821e-07 0.00021 3.060915370220821e-07 0 3.0610826576252604e-07 0 3.0611826576252606e-07 0.00021 3.0612826576252607e-07 0 3.06158311571168e-07 0 3.0616831157116804e-07 0.00021 3.0617831157116805e-07 0 3.061885784444383e-07 0 3.061985784444383e-07 0.00021 3.062085784444383e-07 0 3.062085784444383e-07 0 3.062185784444383e-07 0.00021 3.0622857844443833e-07 0 3.062663799933864e-07 0 3.0627637999338643e-07 0.00021 3.0628637999338644e-07 0 3.0629764921579274e-07 0 3.0630764921579275e-07 0.00021 3.0631764921579276e-07 0 3.0631764921579276e-07 0 3.0632764921579277e-07 0.00021 3.063376492157928e-07 0 3.063376492157928e-07 0 3.063476492157928e-07 0.00021 3.063576492157928e-07 0 3.063576492157928e-07 0 3.063676492157928e-07 0.00021 3.0637764921579283e-07 0 3.0637764921579283e-07 0 3.0638764921579284e-07 0.00021 3.0639764921579285e-07 0 3.0639764921579285e-07 0 3.0640764921579286e-07 0.00021 3.064176492157929e-07 0 3.064176492157929e-07 0 3.064276492157929e-07 0.00021 3.064376492157929e-07 0 3.0643957427315084e-07 0 3.0644957427315085e-07 0.00021 3.0645957427315086e-07 0 3.06479824816553e-07 0 3.0648982481655303e-07 0.00021 3.0649982481655304e-07 0 3.0656078873870904e-07 0 3.0657078873870905e-07 0.00021 3.0658078873870906e-07 0 3.0658078873870906e-07 0 3.065907887387091e-07 0.00021 3.066007887387091e-07 0 3.066007887387091e-07 0 3.066107887387091e-07 0.00021 3.066207887387091e-07 0 3.066207887387091e-07 0 3.066307887387091e-07 0.00021 3.0664078873870913e-07 0 3.0664078873870913e-07 0 3.0665078873870914e-07 0.00021 3.0666078873870915e-07 0 3.0671457837201137e-07 0 3.067245783720114e-07 0.00021 3.067345783720114e-07 0 3.067376893406257e-07 0 3.067476893406257e-07 0.00021 3.0675768934062573e-07 0 3.068954302495973e-07 0 3.069054302495973e-07 0.00021 3.069154302495973e-07 0 3.0693120401693244e-07 0 3.0694120401693245e-07 0.00021 3.0695120401693246e-07 0 3.0695120401693246e-07 0 3.0696120401693247e-07 0.00021 3.069712040169325e-07 0 3.0709732699149164e-07 0 3.0710732699149165e-07 0.00021 3.0711732699149166e-07 0 3.0714374706237235e-07 0 3.0715374706237236e-07 0.00021 3.071637470623724e-07 0 3.071637470623724e-07 0 3.071737470623724e-07 0.00021 3.071837470623724e-07 0 3.071837470623724e-07 0 3.071937470623724e-07 0.00021 3.072037470623724e-07 0 3.072037470623724e-07 0 3.0721374706237243e-07 0.00021 3.0722374706237244e-07 0 3.072683645532549e-07 0 3.072783645532549e-07 0.00021 3.072883645532549e-07 0 3.0736842293651364e-07 0 3.0737842293651365e-07 0.00021 3.0738842293651366e-07 0 3.0738842293651366e-07 0 3.0739842293651367e-07 0.00021 3.074084229365137e-07 0 3.074084229365137e-07 0 3.074184229365137e-07 0.00021 3.074284229365137e-07 0 3.074284229365137e-07 0 3.074384229365137e-07 0.00021 3.0744842293651373e-07 0 3.0744842293651373e-07 0 3.0745842293651374e-07 0.00021 3.0746842293651375e-07 0 3.074822879731723e-07 0 3.074922879731723e-07 0.00021 3.075022879731723e-07 0 3.075022879731723e-07 0 3.075122879731723e-07 0.00021 3.0752228797317233e-07 0 3.0752228797317233e-07 0 3.0753228797317234e-07 0.00021 3.0754228797317235e-07 0 3.0754228797317235e-07 0 3.0755228797317236e-07 0.00021 3.0756228797317237e-07 0 3.0757423010217773e-07 0 3.0758423010217774e-07 0.00021 3.0759423010217775e-07 0 3.0759423010217775e-07 0 3.0760423010217776e-07 0.00021 3.076142301021778e-07 0 3.076142301021778e-07 0 3.076242301021778e-07 0.00021 3.076342301021778e-07 0 3.076930232478777e-07 0 3.077030232478777e-07 0.00021 3.0771302324787773e-07 0 3.0778371215062224e-07 0 3.0779371215062225e-07 0.00021 3.0780371215062227e-07 0 3.0783630694289005e-07 0 3.0784630694289007e-07 0.00021 3.078563069428901e-07 0 3.078563069428901e-07 0 3.078663069428901e-07 0.00021 3.078763069428901e-07 0 3.0790853743885666e-07 0 3.0791853743885667e-07 0.00021 3.079285374388567e-07 0 3.0794028457120944e-07 0 3.0795028457120945e-07 0.00021 3.0796028457120946e-07 0 3.0796649460285263e-07 0 3.0797649460285264e-07 0.00021 3.0798649460285265e-07 0 3.0798649460285265e-07 0 3.0799649460285266e-07 0.00021 3.080064946028527e-07 0 3.080979803707468e-07 0 3.081079803707468e-07 0.00021 3.081179803707468e-07 0 3.08150839030199e-07 0 3.08160839030199e-07 0.00021 3.08170839030199e-07 0 3.0819212245454994e-07 0 3.0820212245454995e-07 0.00021 3.0821212245454996e-07 0 3.083305655530521e-07 0 3.083405655530521e-07 0.00021 3.0835056555305213e-07 0 3.0835056555305213e-07 0 3.0836056555305214e-07 0.00021 3.0837056555305215e-07 0 3.0837609085571235e-07 0 3.0838609085571236e-07 0.00021 3.083960908557124e-07 0 3.083960908557124e-07 0 3.084060908557124e-07 0.00021 3.084160908557124e-07 0 3.0845284390302625e-07 0 3.0846284390302626e-07 0.00021 3.0847284390302627e-07 0 3.0847284390302627e-07 0 3.084828439030263e-07 0.00021 3.084928439030263e-07 0 3.084928439030263e-07 0 3.085028439030263e-07 0.00021 3.085128439030263e-07 0 3.085128439030263e-07 0 3.0852284390302633e-07 0.00021 3.0853284390302634e-07 0 3.0853284390302634e-07 0 3.0854284390302635e-07 0.00021 3.0855284390302636e-07 0 3.0855284390302636e-07 0 3.0856284390302637e-07 0.00021 3.085728439030264e-07 0 3.085728439030264e-07 0 3.085828439030264e-07 0.00021 3.085928439030264e-07 0 3.086023239227993e-07 0 3.086123239227993e-07 0.00021 3.0862232392279933e-07 0 3.086737174127136e-07 0 3.086837174127136e-07 0.00021 3.086937174127136e-07 0 3.086937174127136e-07 0 3.087037174127136e-07 0.00021 3.0871371741271363e-07 0 3.0871371741271363e-07 0 3.0872371741271364e-07 0.00021 3.0873371741271365e-07 0 3.0873371741271365e-07 0 3.0874371741271366e-07 0.00021 3.0875371741271367e-07 0 3.088564608297226e-07 0 3.088664608297226e-07 0.00021 3.0887646082972263e-07 0 3.0890269460348143e-07 0 3.0891269460348144e-07 0.00021 3.0892269460348146e-07 0 3.0892269460348146e-07 0 3.0893269460348147e-07 0.00021 3.089426946034815e-07 0 3.089426946034815e-07 0 3.089526946034815e-07 0.00021 3.089626946034815e-07 0 3.089626946034815e-07 0 3.089726946034815e-07 0.00021 3.089826946034815e-07 0 3.089826946034815e-07 0 3.0899269460348154e-07 0.00021 3.0900269460348155e-07 0 3.0900269460348155e-07 0 3.0901269460348156e-07 0.00021 3.0902269460348157e-07 0 3.0902269460348157e-07 0 3.090326946034816e-07 0.00021 3.090426946034816e-07 0 3.090426946034816e-07 0 3.090526946034816e-07 0.00021 3.090626946034816e-07 0 3.090722876803475e-07 0 3.090822876803475e-07 0.00021 3.090922876803475e-07 0 3.0910874541091876e-07 0 3.0911874541091877e-07 0.00021 3.091287454109188e-07 0 3.091287454109188e-07 0 3.091387454109188e-07 0.00021 3.091487454109188e-07 0 3.091487454109188e-07 0 3.091587454109188e-07 0.00021 3.091687454109188e-07 0 3.092018245535389e-07 0 3.092118245535389e-07 0.00021 3.092218245535389e-07 0 3.0926483658571076e-07 0 3.0927483658571077e-07 0.00021 3.092848365857108e-07 0 3.092848365857108e-07 0 3.092948365857108e-07 0.00021 3.093048365857108e-07 0 3.0932709366229524e-07 0 3.0933709366229525e-07 0.00021 3.0934709366229526e-07 0 3.0934709366229526e-07 0 3.093570936622953e-07 0.00021 3.093670936622953e-07 0 3.093670936622953e-07 0 3.093770936622953e-07 0.00021 3.093870936622953e-07 0 3.093870936622953e-07 0 3.093970936622953e-07 0.00021 3.0940709366229533e-07 0 3.0944331237723644e-07 0 3.0945331237723645e-07 0.00021 3.0946331237723646e-07 0 3.0946331237723646e-07 0 3.094733123772365e-07 0.00021 3.094833123772365e-07 0 3.094833123772365e-07 0 3.094933123772365e-07 0.00021 3.095033123772365e-07 0 3.095033123772365e-07 0 3.095133123772365e-07 0.00021 3.0952331237723653e-07 0 3.0952331237723653e-07 0 3.0953331237723654e-07 0.00021 3.0954331237723655e-07 0 3.0954331237723655e-07 0 3.0955331237723656e-07 0.00021 3.095633123772366e-07 0 3.095633123772366e-07 0 3.095733123772366e-07 0.00021 3.095833123772366e-07 0 3.095833123772366e-07 0 3.095933123772366e-07 0.00021 3.096033123772366e-07 0 3.096033123772366e-07 0 3.0961331237723663e-07 0.00021 3.0962331237723664e-07 0 3.0962331237723664e-07 0 3.0963331237723666e-07 0.00021 3.0964331237723667e-07 0 3.0964331237723667e-07 0 3.096533123772367e-07 0.00021 3.096633123772367e-07 0 3.096633123772367e-07 0 3.096733123772367e-07 0.00021 3.096833123772367e-07 0 3.096833123772367e-07 0 3.096933123772367e-07 0.00021 3.0970331237723673e-07 0 3.0972305098069326e-07 0 3.0973305098069327e-07 0.00021 3.097430509806933e-07 0 3.0975011766832374e-07 0 3.0976011766832376e-07 0.00021 3.0977011766832377e-07 0 3.0984118760455435e-07 0 3.0985118760455436e-07 0.00021 3.098611876045544e-07 0 3.098611876045544e-07 0 3.098711876045544e-07 0.00021 3.098811876045544e-07 0 3.0990229536488104e-07 0 3.0991229536488106e-07 0.00021 3.0992229536488107e-07 0 3.0992229536488107e-07 0 3.099322953648811e-07 0.00021 3.099422953648811e-07 0 3.099422953648811e-07 0 3.099522953648811e-07 0.00021 3.099622953648811e-07 0 3.099622953648811e-07 0 3.099722953648811e-07 0.00021 3.0998229536488113e-07 0 3.0998229536488113e-07 0 3.0999229536488115e-07 0.00021 3.1000229536488116e-07 0 3.1000229536488116e-07 0 3.1001229536488117e-07 0.00021 3.100222953648812e-07 0 3.100222953648812e-07 0 3.100322953648812e-07 0.00021 3.100422953648812e-07 0 3.100422953648812e-07 0 3.100522953648812e-07 0.00021 3.100622953648812e-07 0 3.100622953648812e-07 0 3.1007229536488124e-07 0.00021 3.1008229536488125e-07 0 3.1014302243701744e-07 0 3.1015302243701745e-07 0.00021 3.1016302243701746e-07 0 3.1016302243701746e-07 0 3.1017302243701747e-07 0.00021 3.101830224370175e-07 0 3.102052267492847e-07 0 3.1021522674928474e-07 0.00021 3.1022522674928475e-07 0 3.1026315733736686e-07 0 3.1027315733736687e-07 0.00021 3.102831573373669e-07 0 3.102831573373669e-07 0 3.102931573373669e-07 0.00021 3.103031573373669e-07 0 3.103735507795821e-07 0 3.103835507795821e-07 0.00021 3.103935507795821e-07 0 3.104385326815467e-07 0 3.104485326815467e-07 0.00021 3.104585326815467e-07 0 3.1047017006240127e-07 0 3.104801700624013e-07 0.00021 3.104901700624013e-07 0 3.104901700624013e-07 0 3.105001700624013e-07 0.00021 3.105101700624013e-07 0 3.105101700624013e-07 0 3.105201700624013e-07 0.00021 3.1053017006240134e-07 0 3.1053017006240134e-07 0 3.1054017006240135e-07 0.00021 3.1055017006240136e-07 0 3.1055017006240136e-07 0 3.1056017006240137e-07 0.00021 3.105701700624014e-07 0 3.105701700624014e-07 0 3.105801700624014e-07 0.00021 3.105901700624014e-07 0 3.105901700624014e-07 0 3.106001700624014e-07 0.00021 3.1061017006240143e-07 0 3.1061017006240143e-07 0 3.1062017006240144e-07 0.00021 3.1063017006240145e-07 0 3.1063017006240145e-07 0 3.1064017006240146e-07 0.00021 3.1065017006240147e-07 0 3.1065017006240147e-07 0 3.106601700624015e-07 0.00021 3.106701700624015e-07 0 3.106701700624015e-07 0 3.106801700624015e-07 0.00021 3.106901700624015e-07 0 3.106901700624015e-07 0 3.1070017006240153e-07 0.00021 3.1071017006240154e-07 0 3.1071017006240154e-07 0 3.1072017006240155e-07 0.00021 3.1073017006240156e-07 0 3.1073017006240156e-07 0 3.107401700624016e-07 0.00021 3.107501700624016e-07 0 3.1075550965723015e-07 0 3.1076550965723016e-07 0.00021 3.1077550965723017e-07 0 3.107834788367913e-07 0 3.107934788367913e-07 0.00021 3.1080347883679133e-07 0 3.1080347883679133e-07 0 3.1081347883679134e-07 0.00021 3.1082347883679136e-07 0 3.1082347883679136e-07 0 3.1083347883679137e-07 0.00021 3.108434788367914e-07 0 3.108434788367914e-07 0 3.108534788367914e-07 0.00021 3.108634788367914e-07 0 3.108634788367914e-07 0 3.108734788367914e-07 0.00021 3.108834788367914e-07 0 3.108834788367914e-07 0 3.1089347883679144e-07 0.00021 3.1090347883679145e-07 0 3.1090347883679145e-07 0 3.1091347883679146e-07 0.00021 3.1092347883679147e-07 0 3.109709205066129e-07 0 3.109809205066129e-07 0.00021 3.109909205066129e-07 0 3.109910884090483e-07 0 3.110010884090483e-07 0.00021 3.110110884090483e-07 0 3.110110884090483e-07 0 3.110210884090483e-07 0.00021 3.1103108840904833e-07 0 3.1107368624508805e-07 0 3.1108368624508806e-07 0.00021 3.110936862450881e-07 0 3.111693081650778e-07 0 3.111793081650778e-07 0.00021 3.1118930816507783e-07 0 3.112415032985582e-07 0 3.112515032985582e-07 0.00021 3.112615032985582e-07 0 3.112615032985582e-07 0 3.112715032985582e-07 0.00021 3.112815032985582e-07 0 3.112815032985582e-07 0 3.1129150329855823e-07 0.00021 3.1130150329855824e-07 0 3.1130150329855824e-07 0 3.1131150329855825e-07 0.00021 3.1132150329855827e-07 0 3.1132150329855827e-07 0 3.113315032985583e-07 0.00021 3.113415032985583e-07 0 3.113415032985583e-07 0 3.113515032985583e-07 0.00021 3.113615032985583e-07 0 3.113615032985583e-07 0 3.113715032985583e-07 0.00021 3.1138150329855833e-07 0 3.1138150329855833e-07 0 3.1139150329855835e-07 0.00021 3.1140150329855836e-07 0 3.1140150329855836e-07 0 3.1141150329855837e-07 0.00021 3.114215032985584e-07 0 3.114215032985584e-07 0 3.114315032985584e-07 0.00021 3.114415032985584e-07 0 3.114415032985584e-07 0 3.114515032985584e-07 0.00021 3.114615032985584e-07 0 3.114615032985584e-07 0 3.1147150329855844e-07 0.00021 3.1148150329855845e-07 0 3.1148150329855845e-07 0 3.1149150329855846e-07 0.00021 3.1150150329855847e-07 0 3.1150150329855847e-07 0 3.115115032985585e-07 0.00021 3.115215032985585e-07 0 3.115215032985585e-07 0 3.115315032985585e-07 0.00021 3.115415032985585e-07 0 3.115415032985585e-07 0 3.1155150329855853e-07 0.00021 3.1156150329855854e-07 0 3.1156150329855854e-07 0 3.1157150329855855e-07 0.00021 3.1158150329855856e-07 0 3.1158150329855856e-07 0 3.1159150329855857e-07 0.00021 3.116015032985586e-07 0 3.116015032985586e-07 0 3.116115032985586e-07 0.00021 3.116215032985586e-07 0 3.116215032985586e-07 0 3.116315032985586e-07 0.00021 3.1164150329855863e-07 0 3.1164150329855863e-07 0 3.1165150329855864e-07 0.00021 3.1166150329855865e-07 0 3.1166150329855865e-07 0 3.1167150329855866e-07 0.00021 3.116815032985587e-07 0 3.117045845395244e-07 0 3.117145845395244e-07 0.00021 3.117245845395244e-07 0 3.1176693053716635e-07 0 3.1177693053716636e-07 0.00021 3.117869305371664e-07 0 3.1178946229438823e-07 0 3.1179946229438824e-07 0.00021 3.1180946229438825e-07 0 3.118614180549063e-07 0 3.118714180549063e-07 0.00021 3.1188141805490634e-07 0 3.1190135641785335e-07 0 3.1191135641785336e-07 0.00021 3.1192135641785337e-07 0 3.1192135641785337e-07 0 3.119313564178534e-07 0.00021 3.119413564178534e-07 0 3.119413564178534e-07 0 3.119513564178534e-07 0.00021 3.119613564178534e-07 0 3.120090250089867e-07 0 3.120190250089867e-07 0.00021 3.1202902500898673e-07 0 3.120357366615281e-07 0 3.120457366615281e-07 0.00021 3.120557366615281e-07 0 3.120557366615281e-07 0 3.1206573666152813e-07 0.00021 3.1207573666152814e-07 0 3.1207573666152814e-07 0 3.1208573666152815e-07 0.00021 3.1209573666152817e-07 0 3.1209573666152817e-07 0 3.121057366615282e-07 0.00021 3.121157366615282e-07 0 3.121157366615282e-07 0 3.121257366615282e-07 0.00021 3.121357366615282e-07 0 3.121357366615282e-07 0 3.121457366615282e-07 0.00021 3.1215573666152823e-07 0 3.1215573666152823e-07 0 3.1216573666152824e-07 0.00021 3.1217573666152826e-07 0 3.1217573666152826e-07 0 3.1218573666152827e-07 0.00021 3.121957366615283e-07 0 3.121957366615283e-07 0 3.122057366615283e-07 0.00021 3.122157366615283e-07 0 3.122167793100492e-07 0 3.122267793100492e-07 0.00021 3.122367793100492e-07 0 3.122578694069712e-07 0 3.122678694069712e-07 0.00021 3.122778694069712e-07 0 3.122963051129931e-07 0 3.123063051129931e-07 0.00021 3.123163051129931e-07 0 3.123163051129931e-07 0 3.123263051129931e-07 0.00021 3.1233630511299313e-07 0 3.1233630511299313e-07 0 3.1234630511299314e-07 0.00021 3.1235630511299315e-07 0 3.1235630511299315e-07 0 3.1236630511299316e-07 0.00021 3.123763051129932e-07 0 3.123804065193291e-07 0 3.1239040651932913e-07 0.00021 3.1240040651932914e-07 0 3.1252540789117916e-07 0 3.1253540789117917e-07 0.00021 3.125454078911792e-07 0 3.126327216698473e-07 0 3.126427216698473e-07 0.00021 3.126527216698473e-07 0 3.126527216698473e-07 0 3.1266272166984733e-07 0.00021 3.1267272166984734e-07 0 3.1271707501165045e-07 0 3.1272707501165046e-07 0.00021 3.1273707501165047e-07 0 3.1273707501165047e-07 0 3.127470750116505e-07 0.00021 3.127570750116505e-07 0 3.127570750116505e-07 0 3.127670750116505e-07 0.00021 3.127770750116505e-07 0 3.127770750116505e-07 0 3.1278707501165053e-07 0.00021 3.1279707501165054e-07 0 3.1279707501165054e-07 0 3.1280707501165055e-07 0.00021 3.1281707501165056e-07 0 3.1281707501165056e-07 0 3.128270750116506e-07 0.00021 3.128370750116506e-07 0 3.128370750116506e-07 0 3.128470750116506e-07 0.00021 3.128570750116506e-07 0 3.128570750116506e-07 0 3.128670750116506e-07 0.00021 3.1287707501165063e-07 0 3.1287707501165063e-07 0 3.1288707501165064e-07 0.00021 3.1289707501165065e-07 0 3.1289707501165065e-07 0 3.1290707501165066e-07 0.00021 3.129170750116507e-07 0 3.129170750116507e-07 0 3.129270750116507e-07 0.00021 3.129370750116507e-07 0 3.129370750116507e-07 0 3.129470750116507e-07 0.00021 3.129570750116507e-07 0 3.129570750116507e-07 0 3.1296707501165073e-07 0.00021 3.1297707501165074e-07 0 3.1297707501165074e-07 0 3.1298707501165076e-07 0.00021 3.1299707501165077e-07 0 3.1299707501165077e-07 0 3.130070750116508e-07 0.00021 3.130170750116508e-07 0 3.1303989737398707e-07 0 3.130498973739871e-07 0.00021 3.130598973739871e-07 0 3.1307835764386497e-07 0 3.13088357643865e-07 0.00021 3.13098357643865e-07 0 3.131238043497629e-07 0 3.131338043497629e-07 0.00021 3.131438043497629e-07 0 3.1314895915025565e-07 0 3.1315895915025567e-07 0.00021 3.131689591502557e-07 0 3.1318334611840765e-07 0 3.1319334611840766e-07 0.00021 3.132033461184077e-07 0 3.132195728198191e-07 0 3.132295728198191e-07 0.00021 3.132395728198191e-07 0 3.133220362348891e-07 0 3.133320362348891e-07 0.00021 3.133420362348891e-07 0 3.133993618514337e-07 0 3.134093618514337e-07 0.00021 3.1341936185143373e-07 0 3.1345511824298175e-07 0 3.1346511824298176e-07 0.00021 3.134751182429818e-07 0 3.1354743983760285e-07 0 3.1355743983760286e-07 0.00021 3.1356743983760287e-07 0 3.1356743983760287e-07 0 3.135774398376029e-07 0.00021 3.135874398376029e-07 0 3.135874398376029e-07 0 3.135974398376029e-07 0.00021 3.136074398376029e-07 0 3.136074398376029e-07 0 3.1361743983760293e-07 0.00021 3.1362743983760294e-07 0 3.1362743983760294e-07 0 3.1363743983760295e-07 0.00021 3.1364743983760296e-07 0 3.1364743983760296e-07 0 3.13657439837603e-07 0.00021 3.13667439837603e-07 0 3.13667439837603e-07 0 3.13677439837603e-07 0.00021 3.13687439837603e-07 0 3.13687439837603e-07 0 3.13697439837603e-07 0.00021 3.1370743983760303e-07 0 3.1370743983760303e-07 0 3.1371743983760304e-07 0.00021 3.1372743983760305e-07 0 3.137746478653639e-07 0 3.137846478653639e-07 0.00021 3.1379464786536393e-07 0 3.1380362782096757e-07 0 3.138136278209676e-07 0.00021 3.138236278209676e-07 0 3.1383059610871593e-07 0 3.1384059610871594e-07 0.00021 3.1385059610871595e-07 0 3.1385059610871595e-07 0 3.1386059610871596e-07 0.00021 3.1387059610871597e-07 0 3.138936513208899e-07 0 3.139036513208899e-07 0.00021 3.139136513208899e-07 0 3.139437297382984e-07 0 3.1395372973829843e-07 0.00021 3.1396372973829844e-07 0 3.1396372973829844e-07 0 3.1397372973829845e-07 0.00021 3.1398372973829846e-07 0 3.1401996362671145e-07 0 3.1402996362671146e-07 0.00021 3.1403996362671147e-07 0 3.1403996362671147e-07 0 3.140499636267115e-07 0.00021 3.140599636267115e-07 0 3.140599636267115e-07 0 3.140699636267115e-07 0.00021 3.140799636267115e-07 0 3.140799636267115e-07 0 3.140899636267115e-07 0.00021 3.1409996362671154e-07 0 3.1414558374496935e-07 0 3.1415558374496936e-07 0.00021 3.1416558374496937e-07 0 3.1418221862702993e-07 0 3.1419221862702994e-07 0.00021 3.1420221862702995e-07 0 3.142257215639178e-07 0 3.142357215639178e-07 0.00021 3.1424572156391784e-07 0 3.1424572156391784e-07 0 3.1425572156391785e-07 0.00021 3.1426572156391786e-07 0 3.1427930995821387e-07 0 3.142893099582139e-07 0.00021 3.142993099582139e-07 0 3.142993099582139e-07 0 3.143093099582139e-07 0.00021 3.143193099582139e-07 0 3.143231360015135e-07 0 3.143331360015135e-07 0.00021 3.1434313600151353e-07 0 3.1439507894514403e-07 0 3.1440507894514404e-07 0.00021 3.1441507894514405e-07 0 3.1443558884466553e-07 0 3.1444558884466554e-07 0.00021 3.1445558884466555e-07 0 3.1445558884466555e-07 0 3.1446558884466556e-07 0.00021 3.144755888446656e-07 0 3.144755888446656e-07 0 3.144855888446656e-07 0.00021 3.144955888446656e-07 0 3.145007055068095e-07 0 3.145107055068095e-07 0.00021 3.145207055068095e-07 0 3.145552021107721e-07 0 3.145652021107721e-07 0.00021 3.145752021107721e-07 0 3.145838241283231e-07 0 3.145938241283231e-07 0.00021 3.1460382412832314e-07 0 3.1460382412832314e-07 0 3.1461382412832315e-07 0.00021 3.1462382412832316e-07 0 3.1462382412832316e-07 0 3.1463382412832317e-07 0.00021 3.146438241283232e-07 0 3.146438241283232e-07 0 3.146538241283232e-07 0.00021 3.146638241283232e-07 0 3.146638241283232e-07 0 3.146738241283232e-07 0.00021 3.146838241283232e-07 0 3.1479915113555574e-07 0 3.1480915113555575e-07 0.00021 3.1481915113555576e-07 0 3.1484582865175e-07 0 3.1485582865175e-07 0.00021 3.1486582865175e-07 0 3.1488360916782596e-07 0 3.1489360916782597e-07 0.00021 3.14903609167826e-07 0 3.14903609167826e-07 0 3.14913609167826e-07 0.00021 3.14923609167826e-07 0 3.1493391839503335e-07 0 3.1494391839503336e-07 0.00021 3.1495391839503337e-07 0 3.1495391839503337e-07 0 3.149639183950334e-07 0.00021 3.149739183950334e-07 0 3.149739183950334e-07 0 3.149839183950334e-07 0.00021 3.149939183950334e-07 0 3.149939183950334e-07 0 3.1500391839503343e-07 0.00021 3.1501391839503344e-07 0 3.1502920290000067e-07 0 3.150392029000007e-07 0.00021 3.150492029000007e-07 0 3.150721052054647e-07 0 3.1508210520546473e-07 0.00021 3.1509210520546474e-07 0 3.151475519200038e-07 0 3.151575519200038e-07 0.00021 3.151675519200038e-07 0 3.151675519200038e-07 0 3.1517755192000383e-07 0.00021 3.1518755192000385e-07 0 3.1518755192000385e-07 0 3.1519755192000386e-07 0.00021 3.1520755192000387e-07 0 3.1520755192000387e-07 0 3.152175519200039e-07 0.00021 3.152275519200039e-07 0 3.152275519200039e-07 0 3.152375519200039e-07 0.00021 3.152475519200039e-07 0 3.152475519200039e-07 0 3.152575519200039e-07 0.00021 3.1526755192000394e-07 0 3.1526755192000394e-07 0 3.1527755192000395e-07 0.00021 3.1528755192000396e-07 0 3.1528755192000396e-07 0 3.1529755192000397e-07 0.00021 3.15307551920004e-07 0 3.15307551920004e-07 0 3.15317551920004e-07 0.00021 3.15327551920004e-07 0 3.15327551920004e-07 0 3.15337551920004e-07 0.00021 3.1534755192000403e-07 0 3.1534755192000403e-07 0 3.1535755192000404e-07 0.00021 3.1536755192000405e-07 0 3.1536755192000405e-07 0 3.1537755192000406e-07 0.00021 3.1538755192000407e-07 0 3.1538755192000407e-07 0 3.153975519200041e-07 0.00021 3.154075519200041e-07 0 3.154075519200041e-07 0 3.154175519200041e-07 0.00021 3.154275519200041e-07 0 3.154275519200041e-07 0 3.1543755192000413e-07 0.00021 3.1544755192000414e-07 0 3.154949454945189e-07 0 3.1550494549451894e-07 0.00021 3.1551494549451895e-07 0 3.1551494549451895e-07 0 3.1552494549451896e-07 0.00021 3.1553494549451897e-07 0 3.155662522876495e-07 0 3.155762522876495e-07 0.00021 3.155862522876495e-07 0 3.1563799488330244e-07 0 3.1564799488330245e-07 0.00021 3.1565799488330246e-07 0 3.1565799488330246e-07 0 3.1566799488330247e-07 0.00021 3.156779948833025e-07 0 3.156800031719001e-07 0 3.156900031719001e-07 0.00021 3.157000031719001e-07 0 3.157973426134728e-07 0 3.1580734261347284e-07 0.00021 3.1581734261347285e-07 0 3.1581780828411515e-07 0 3.1582780828411516e-07 0.00021 3.1583780828411517e-07 0 3.1584651330131785e-07 0 3.1585651330131786e-07 0.00021 3.158665133013179e-07 0 3.158670419206635e-07 0 3.158770419206635e-07 0.00021 3.1588704192066353e-07 0 3.1588704192066353e-07 0 3.1589704192066354e-07 0.00021 3.1590704192066355e-07 0 3.1590704192066355e-07 0 3.1591704192066356e-07 0.00021 3.1592704192066357e-07 0 3.1592704192066357e-07 0 3.159370419206636e-07 0.00021 3.159470419206636e-07 0 3.159817552992477e-07 0 3.159917552992477e-07 0.00021 3.160017552992477e-07 0 3.160202699793727e-07 0 3.160302699793727e-07 0.00021 3.160402699793727e-07 0 3.160402699793727e-07 0 3.1605026997937274e-07 0.00021 3.1606026997937275e-07 0 3.1606026997937275e-07 0 3.1607026997937276e-07 0.00021 3.1608026997937277e-07 0 3.1608026997937277e-07 0 3.160902699793728e-07 0.00021 3.161002699793728e-07 0 3.161002699793728e-07 0 3.161102699793728e-07 0.00021 3.161202699793728e-07 0 3.161541845066415e-07 0 3.161641845066415e-07 0.00021 3.161741845066415e-07 0 3.161741845066415e-07 0 3.1618418450664153e-07 0.00021 3.1619418450664155e-07 0 3.162483032067545e-07 0 3.1625830320675453e-07 0.00021 3.1626830320675455e-07 0 3.1626830320675455e-07 0 3.1627830320675456e-07 0.00021 3.1628830320675457e-07 0 3.1628830320675457e-07 0 3.162983032067546e-07 0.00021 3.163083032067546e-07 0 3.163083032067546e-07 0 3.163183032067546e-07 0.00021 3.163283032067546e-07 0 3.163283032067546e-07 0 3.163383032067546e-07 0.00021 3.1634830320675464e-07 0 3.163488011754002e-07 0 3.163588011754002e-07 0.00021 3.163688011754002e-07 0 3.163688011754002e-07 0 3.163788011754002e-07 0.00021 3.1638880117540023e-07 0 3.1638880117540023e-07 0 3.1639880117540024e-07 0.00021 3.1640880117540025e-07 0 3.1640880117540025e-07 0 3.1641880117540026e-07 0.00021 3.164288011754003e-07 0 3.164288011754003e-07 0 3.164388011754003e-07 0.00021 3.164488011754003e-07 0 3.1652644949816456e-07 0 3.1653644949816457e-07 0.00021 3.165464494981646e-07 0 3.165545987017675e-07 0 3.165645987017675e-07 0.00021 3.165745987017675e-07 0 3.1659489471272007e-07 0 3.166048947127201e-07 0.00021 3.166148947127201e-07 0 3.166299916670465e-07 0 3.166399916670465e-07 0.00021 3.1664999166704653e-07 0 3.166640974624414e-07 0 3.166740974624414e-07 0.00021 3.1668409746244144e-07 0 3.1672164995395857e-07 0 3.167316499539586e-07 0.00021 3.167416499539586e-07 0 3.1681304976519584e-07 0 3.1682304976519585e-07 0.00021 3.1683304976519586e-07 0 3.1683304976519586e-07 0 3.1684304976519587e-07 0.00021 3.168530497651959e-07 0 3.1686248719230397e-07 0 3.16872487192304e-07 0.00021 3.16882487192304e-07 0 3.16882487192304e-07 0 3.16892487192304e-07 0.00021 3.16902487192304e-07 0 3.169222523920055e-07 0 3.169322523920055e-07 0.00021 3.169422523920055e-07 0 3.1694876251460904e-07 0 3.1695876251460905e-07 0.00021 3.1696876251460906e-07 0 3.170065481463285e-07 0 3.1701654814632853e-07 0.00021 3.1702654814632854e-07 0 3.1703807817997804e-07 0 3.1704807817997805e-07 0.00021 3.1705807817997806e-07 0 3.1708142283560547e-07 0 3.170914228356055e-07 0.00021 3.171014228356055e-07 0 3.1714657392357493e-07 0 3.1715657392357495e-07 0.00021 3.1716657392357496e-07 0 3.1724006867807945e-07 0 3.1725006867807946e-07 0.00021 3.1726006867807947e-07 0 3.1726006867807947e-07 0 3.172700686780795e-07 0.00021 3.172800686780795e-07 0 3.1735386438968953e-07 0 3.1736386438968954e-07 0.00021 3.1737386438968955e-07 0 3.174354544520938e-07 0 3.1744545445209383e-07 0.00021 3.1745545445209384e-07 0 3.1745545445209384e-07 0 3.1746545445209385e-07 0.00021 3.1747545445209386e-07 0 3.1747545445209386e-07 0 3.174854544520939e-07 0.00021 3.174954544520939e-07 0 3.175095588566295e-07 0 3.175195588566295e-07 0.00021 3.175295588566295e-07 0 3.175295588566295e-07 0 3.175395588566295e-07 0.00021 3.1754955885662953e-07 0 3.1754955885662953e-07 0 3.1755955885662954e-07 0.00021 3.1756955885662955e-07 0 3.1756955885662955e-07 0 3.1757955885662957e-07 0.00021 3.175895588566296e-07 0 3.175895588566296e-07 0 3.175995588566296e-07 0.00021 3.176095588566296e-07 0 3.1761308091130533e-07 0 3.1762308091130534e-07 0.00021 3.1763308091130535e-07 0 3.176553520503962e-07 0 3.176653520503962e-07 0.00021 3.1767535205039623e-07 0 3.1767535205039623e-07 0 3.1768535205039625e-07 0.00021 3.1769535205039626e-07 0 3.1772931450569437e-07 0 3.177393145056944e-07 0.00021 3.177493145056944e-07 0 3.177493145056944e-07 0 3.177593145056944e-07 0.00021 3.177693145056944e-07 0 3.177693145056944e-07 0 3.177793145056944e-07 0.00021 3.1778931450569443e-07 0 3.1778931450569443e-07 0 3.1779931450569445e-07 0.00021 3.1780931450569446e-07 0 3.1780931450569446e-07 0 3.1781931450569447e-07 0.00021 3.178293145056945e-07 0 3.178293145056945e-07 0 3.178393145056945e-07 0.00021 3.178493145056945e-07 0 3.178996711645452e-07 0 3.179096711645452e-07 0.00021 3.179196711645452e-07 0 3.179196711645452e-07 0 3.179296711645452e-07 0.00021 3.1793967116454523e-07 0 3.1793967116454523e-07 0 3.1794967116454524e-07 0.00021 3.1795967116454525e-07 0 3.180197177919691e-07 0 3.180297177919691e-07 0.00021 3.180397177919691e-07 0 3.180397177919691e-07 0 3.1804971779196913e-07 0.00021 3.1805971779196914e-07 0 3.180644068686176e-07 0 3.180744068686176e-07 0.00021 3.180844068686176e-07 0 3.180915713190771e-07 0 3.181015713190771e-07 0.00021 3.181115713190771e-07 0 3.181598436243771e-07 0 3.181698436243771e-07 0.00021 3.181798436243771e-07 0 3.181821685738437e-07 0 3.181921685738437e-07 0.00021 3.182021685738437e-07 0 3.182021685738437e-07 0 3.182121685738437e-07 0.00021 3.1822216857384373e-07 0 3.1824841822324e-07 0 3.1825841822324e-07 0.00021 3.1826841822324e-07 0 3.1826841822324e-07 0 3.1827841822324003e-07 0.00021 3.1828841822324004e-07 0 3.1828841822324004e-07 0 3.1829841822324005e-07 0.00021 3.1830841822324006e-07 0 3.183756929444748e-07 0 3.183856929444748e-07 0.00021 3.183956929444748e-07 0 3.1839941496528154e-07 0 3.1840941496528155e-07 0.00021 3.1841941496528156e-07 0 3.184374854705346e-07 0 3.184474854705346e-07 0.00021 3.1845748547053463e-07 0 3.1845748547053463e-07 0 3.1846748547053464e-07 0.00021 3.1847748547053465e-07 0 3.1847748547053465e-07 0 3.1848748547053466e-07 0.00021 3.1849748547053467e-07 0 3.1849748547053467e-07 0 3.185074854705347e-07 0.00021 3.185174854705347e-07 0 3.185174854705347e-07 0 3.185274854705347e-07 0.00021 3.185374854705347e-07 0 3.185374854705347e-07 0 3.1854748547053473e-07 0.00021 3.1855748547053474e-07 0 3.1855748547053474e-07 0 3.1856748547053475e-07 0.00021 3.1857748547053476e-07 0 3.1859534706843435e-07 0 3.1860534706843436e-07 0.00021 3.1861534706843437e-07 0 3.1861534706843437e-07 0 3.186253470684344e-07 0.00021 3.186353470684344e-07 0 3.186353470684344e-07 0 3.186453470684344e-07 0.00021 3.186553470684344e-07 0 3.186553470684344e-07 0 3.1866534706843443e-07 0.00021 3.1867534706843444e-07 0 3.1867534706843444e-07 0 3.1868534706843445e-07 0.00021 3.1869534706843446e-07 0 3.1869534706843446e-07 0 3.187053470684345e-07 0.00021 3.187153470684345e-07 0 3.187199341548364e-07 0 3.187299341548364e-07 0.00021 3.1873993415483644e-07 0 3.1874853098562483e-07 0 3.1875853098562484e-07 0.00021 3.1876853098562485e-07 0 3.188317278452886e-07 0 3.188417278452886e-07 0.00021 3.1885172784528863e-07 0 3.1887491524979826e-07 0 3.1888491524979827e-07 0.00021 3.188949152497983e-07 0 3.189110594553541e-07 0 3.189210594553541e-07 0.00021 3.189310594553541e-07 0 3.189520761574471e-07 0 3.189620761574471e-07 0.00021 3.1897207615744714e-07 0 3.1897207615744714e-07 0 3.1898207615744715e-07 0.00021 3.1899207615744716e-07 0 3.1899207615744716e-07 0 3.1900207615744717e-07 0.00021 3.190120761574472e-07 0 3.1907054961298646e-07 0 3.1908054961298647e-07 0.00021 3.190905496129865e-07 0 3.191306730802075e-07 0 3.191406730802075e-07 0.00021 3.191506730802075e-07 0 3.191506730802075e-07 0 3.191606730802075e-07 0.00021 3.1917067308020753e-07 0 3.192055781237034e-07 0 3.192155781237034e-07 0.00021 3.192255781237034e-07 0 3.192288071037933e-07 0 3.192388071037933e-07 0.00021 3.192488071037933e-07 0 3.192488071037933e-07 0 3.1925880710379333e-07 0.00021 3.1926880710379334e-07 0 3.1926880710379334e-07 0 3.1927880710379335e-07 0.00021 3.1928880710379336e-07 0 3.1928880710379336e-07 0 3.1929880710379337e-07 0.00021 3.193088071037934e-07 0 3.193088071037934e-07 0 3.193188071037934e-07 0.00021 3.193288071037934e-07 0 3.193288071037934e-07 0 3.193388071037934e-07 0.00021 3.1934880710379343e-07 0 3.1934880710379343e-07 0 3.1935880710379344e-07 0.00021 3.1936880710379345e-07 0 3.193807769537867e-07 0 3.193907769537867e-07 0.00021 3.194007769537867e-07 0 3.194007769537867e-07 0 3.194107769537867e-07 0.00021 3.1942077695378673e-07 0 3.1942077695378673e-07 0 3.1943077695378674e-07 0.00021 3.1944077695378675e-07 0 3.194940321851981e-07 0 3.195040321851981e-07 0.00021 3.1951403218519814e-07 0 3.1951403218519814e-07 0 3.1952403218519815e-07 0.00021 3.1953403218519816e-07 0 3.1953903516666094e-07 0 3.1954903516666095e-07 0.00021 3.1955903516666096e-07 0 3.1955903516666096e-07 0 3.19569035166661e-07 0.00021 3.19579035166661e-07 0 3.19579035166661e-07 0 3.19589035166661e-07 0.00021 3.19599035166661e-07 0 3.19599035166661e-07 0 3.19609035166661e-07 0.00021 3.1961903516666103e-07 0 3.1961903516666103e-07 0 3.1962903516666104e-07 0.00021 3.1963903516666105e-07 0 3.1963903516666105e-07 0 3.1964903516666106e-07 0.00021 3.196590351666611e-07 0 3.196590351666611e-07 0 3.196690351666611e-07 0.00021 3.196790351666611e-07 0 3.196790351666611e-07 0 3.196890351666611e-07 0.00021 3.196990351666611e-07 0 3.196990351666611e-07 0 3.1970903516666113e-07 0.00021 3.1971903516666114e-07 0 3.1984551151989e-07 0 3.1985551151989e-07 0.00021 3.1986551151989e-07 0 3.1986551151989e-07 0 3.1987551151989003e-07 0.00021 3.1988551151989004e-07 0 3.198873909564071e-07 0 3.198973909564071e-07 0.00021 3.199073909564071e-07 0 3.2005270049467615e-07 0 3.2006270049467616e-07 0.00021 3.2007270049467617e-07 0 3.2007270049467617e-07 0 3.200827004946762e-07 0.00021 3.200927004946762e-07 0 3.201383456884204e-07 0 3.201483456884204e-07 0.00021 3.201583456884204e-07 0 3.201704032124869e-07 0 3.2018040321248693e-07 0.00021 3.2019040321248694e-07 0 3.2019040321248694e-07 0 3.2020040321248695e-07 0.00021 3.2021040321248696e-07 0 3.202641456538992e-07 0 3.202741456538992e-07 0.00021 3.202841456538992e-07 0 3.2029882000680023e-07 0 3.2030882000680024e-07 0.00021 3.2031882000680025e-07 0 3.203222325164605e-07 0 3.203322325164605e-07 0.00021 3.203422325164605e-07 0 3.203723772102961e-07 0 3.203823772102961e-07 0.00021 3.203923772102961e-07 0 3.2042037301932223e-07 0 3.2043037301932225e-07 0.00021 3.2044037301932226e-07 0 3.2045411841978915e-07 0 3.2046411841978917e-07 0.00021 3.204741184197892e-07 0 3.204741184197892e-07 0 3.204841184197892e-07 0.00021 3.204941184197892e-07 0 3.205784835010635e-07 0 3.205884835010635e-07 0.00021 3.205984835010635e-07 0 3.205984835010635e-07 0 3.206084835010635e-07 0.00021 3.2061848350106353e-07 0 3.206709631212778e-07 0 3.206809631212778e-07 0.00021 3.206909631212778e-07 0 3.206909631212778e-07 0 3.207009631212778e-07 0.00021 3.207109631212778e-07 0 3.207109631212778e-07 0 3.2072096312127784e-07 0.00021 3.2073096312127785e-07 0 3.2078653812130856e-07 0 3.2079653812130857e-07 0.00021 3.208065381213086e-07 0 3.208065381213086e-07 0 3.208165381213086e-07 0.00021 3.208265381213086e-07 0 3.208265381213086e-07 0 3.208365381213086e-07 0.00021 3.208465381213086e-07 0 3.208465381213086e-07 0 3.2085653812130863e-07 0.00021 3.2086653812130865e-07 0 3.208837998482289e-07 0 3.2089379984822893e-07 0.00021 3.2090379984822894e-07 0 3.2090379984822894e-07 0 3.2091379984822895e-07 0.00021 3.2092379984822897e-07 0 3.2092379984822897e-07 0 3.20933799848229e-07 0.00021 3.20943799848229e-07 0 3.2095823864932926e-07 0 3.2096823864932927e-07 0.00021 3.209782386493293e-07 0 3.2099295237974565e-07 0 3.2100295237974567e-07 0.00021 3.210129523797457e-07 0 3.210835556072293e-07 0 3.210935556072293e-07 0.00021 3.211035556072293e-07 0 3.211069992831798e-07 0 3.211169992831798e-07 0.00021 3.2112699928317983e-07 0 3.211606957195553e-07 0 3.211706957195553e-07 0.00021 3.2118069571955534e-07 0 3.2118069571955534e-07 0 3.2119069571955535e-07 0.00021 3.2120069571955536e-07 0 3.21228160640582e-07 0 3.21238160640582e-07 0.00021 3.21248160640582e-07 0 3.21248160640582e-07 0 3.21258160640582e-07 0.00021 3.21268160640582e-07 0 3.21268160640582e-07 0 3.2127816064058203e-07 0.00021 3.2128816064058204e-07 0 3.213340492556609e-07 0 3.213440492556609e-07 0.00021 3.2135404925566093e-07 0 3.2135404925566093e-07 0 3.2136404925566094e-07 0.00021 3.2137404925566096e-07 0 3.214116227271515e-07 0 3.214216227271515e-07 0.00021 3.214316227271515e-07 0 3.214316227271515e-07 0 3.2144162272715153e-07 0.00021 3.2145162272715154e-07 0 3.2145162272715154e-07 0 3.2146162272715156e-07 0.00021 3.2147162272715157e-07 0 3.2147162272715157e-07 0 3.214816227271516e-07 0.00021 3.214916227271516e-07 0 3.2152229433296144e-07 0 3.2153229433296146e-07 0.00021 3.2154229433296147e-07 0 3.215765128689272e-07 0 3.215865128689272e-07 0.00021 3.2159651286892723e-07 0 3.2172428150244546e-07 0 3.2173428150244547e-07 0.00021 3.217442815024455e-07 0 3.217442815024455e-07 0 3.217542815024455e-07 0.00021 3.217642815024455e-07 0 3.217782044359176e-07 0 3.217882044359176e-07 0.00021 3.217982044359176e-07 0 3.217982044359176e-07 0 3.218082044359176e-07 0.00021 3.218182044359176e-07 0 3.218619694982012e-07 0 3.2187196949820123e-07 0.00021 3.2188196949820124e-07 0 3.2188196949820124e-07 0 3.2189196949820125e-07 0.00021 3.2190196949820126e-07 0 3.2190196949820126e-07 0 3.2191196949820127e-07 0.00021 3.219219694982013e-07 0 3.219219694982013e-07 0 3.219319694982013e-07 0.00021 3.219419694982013e-07 0 3.219419694982013e-07 0 3.219519694982013e-07 0.00021 3.2196196949820133e-07 0 3.2196196949820133e-07 0 3.2197196949820134e-07 0.00021 3.2198196949820135e-07 0 3.2198196949820135e-07 0 3.2199196949820136e-07 0.00021 3.220019694982014e-07 0 3.220019694982014e-07 0 3.220119694982014e-07 0.00021 3.220219694982014e-07 0 3.220219694982014e-07 0 3.220319694982014e-07 0.00021 3.220419694982014e-07 0 3.220419694982014e-07 0 3.2205196949820143e-07 0.00021 3.2206196949820144e-07 0 3.2206196949820144e-07 0 3.2207196949820145e-07 0.00021 3.2208196949820146e-07 0 3.2208196949820146e-07 0 3.220919694982015e-07 0.00021 3.221019694982015e-07 0 3.221019694982015e-07 0 3.221119694982015e-07 0.00021 3.221219694982015e-07 0 3.221358381089961e-07 0 3.221458381089961e-07 0.00021 3.221558381089961e-07 0 3.2216910074570123e-07 0 3.2217910074570124e-07 0.00021 3.2218910074570125e-07 0 3.2218910074570125e-07 0 3.2219910074570126e-07 0.00021 3.2220910074570127e-07 0 3.222212444005385e-07 0 3.222312444005385e-07 0.00021 3.222412444005385e-07 0 3.222412444005385e-07 0 3.222512444005385e-07 0.00021 3.222612444005385e-07 0 3.223034799391509e-07 0 3.223134799391509e-07 0.00021 3.223234799391509e-07 0 3.223234799391509e-07 0 3.223334799391509e-07 0.00021 3.2234347993915094e-07 0 3.2234347993915094e-07 0 3.2235347993915095e-07 0.00021 3.2236347993915096e-07 0 3.223772638774773e-07 0 3.223872638774773e-07 0.00021 3.223972638774773e-07 0 3.224241712014322e-07 0 3.224341712014322e-07 0.00021 3.2244417120143223e-07 0 3.2244417120143223e-07 0 3.2245417120143224e-07 0.00021 3.2246417120143225e-07 0 3.2249260757807246e-07 0 3.225026075780725e-07 0.00021 3.225126075780725e-07 0 3.225126075780725e-07 0 3.225226075780725e-07 0.00021 3.225326075780725e-07 0 3.225326075780725e-07 0 3.225426075780725e-07 0.00021 3.2255260757807253e-07 0 3.2255260757807253e-07 0 3.2256260757807254e-07 0.00021 3.2257260757807255e-07 0 3.22648164037272e-07 0 3.22658164037272e-07 0.00021 3.22668164037272e-07 0 3.227164044274472e-07 0 3.227264044274472e-07 0.00021 3.227364044274472e-07 0 3.227364044274472e-07 0 3.227464044274472e-07 0.00021 3.2275640442744723e-07 0 3.2275640442744723e-07 0 3.2276640442744724e-07 0.00021 3.2277640442744725e-07 0 3.2277640442744725e-07 0 3.2278640442744726e-07 0.00021 3.2279640442744727e-07 0 3.2279640442744727e-07 0 3.228064044274473e-07 0.00021 3.228164044274473e-07 0 3.228602796808281e-07 0 3.2287027968082813e-07 0.00021 3.2288027968082814e-07 0 3.2288027968082814e-07 0 3.2289027968082815e-07 0.00021 3.2290027968082816e-07 0 3.2290027968082816e-07 0 3.2291027968082817e-07 0.00021 3.229202796808282e-07 0 3.229202796808282e-07 0 3.229302796808282e-07 0.00021 3.229402796808282e-07 0 3.229402796808282e-07 0 3.229502796808282e-07 0.00021 3.2296027968082823e-07 0 3.2296027968082823e-07 0 3.2297027968082824e-07 0.00021 3.2298027968082825e-07 0 3.2298502310106994e-07 0 3.2299502310106995e-07 0.00021 3.2300502310106996e-07 0 3.2306130385797343e-07 0 3.2307130385797345e-07 0.00021 3.2308130385797346e-07 0 3.231029120393978e-07 0 3.231129120393978e-07 0.00021 3.231229120393978e-07 0 3.231354625523491e-07 0 3.231454625523491e-07 0.00021 3.231554625523491e-07 0 3.232127006548498e-07 0 3.232227006548498e-07 0.00021 3.232327006548498e-07 0 3.2335459904073614e-07 0 3.2336459904073616e-07 0.00021 3.2337459904073617e-07 0 3.2337594693734936e-07 0 3.2338594693734937e-07 0.00021 3.233959469373494e-07 0 3.2346080916723806e-07 0 3.2347080916723807e-07 0.00021 3.234808091672381e-07 0 3.2350039279756553e-07 0 3.2351039279756554e-07 0.00021 3.2352039279756556e-07 0 3.2352039279756556e-07 0 3.2353039279756557e-07 0.00021 3.235403927975656e-07 0 3.235403927975656e-07 0 3.235503927975656e-07 0.00021 3.235603927975656e-07 0 3.235603927975656e-07 0 3.235703927975656e-07 0.00021 3.235803927975656e-07 0 3.235803927975656e-07 0 3.2359039279756563e-07 0.00021 3.2360039279756565e-07 0 3.2360039279756565e-07 0 3.2361039279756566e-07 0.00021 3.2362039279756567e-07 0 3.2362039279756567e-07 0 3.236303927975657e-07 0.00021 3.236403927975657e-07 0 3.2373895609072563e-07 0 3.2374895609072564e-07 0.00021 3.2375895609072565e-07 0 3.2375895609072565e-07 0 3.2376895609072566e-07 0.00021 3.237789560907257e-07 0 3.2379577487296724e-07 0 3.2380577487296725e-07 0.00021 3.2381577487296726e-07 0 3.23876746331389e-07 0 3.23886746331389e-07 0.00021 3.23896746331389e-07 0 3.239366989365371e-07 0 3.239466989365371e-07 0.00021 3.239566989365371e-07 0 3.2396280724778415e-07 0 3.2397280724778416e-07 0.00021 3.239828072477842e-07 0 3.239838238058773e-07 0 3.239938238058773e-07 0.00021 3.240038238058773e-07 0 3.240038238058773e-07 0 3.240138238058773e-07 0.00021 3.240238238058773e-07 0 3.240238238058773e-07 0 3.2403382380587733e-07 0.00021 3.2404382380587734e-07 0 3.2404382380587734e-07 0 3.2405382380587735e-07 0.00021 3.2406382380587737e-07 0 3.241224575340379e-07 0 3.241324575340379e-07 0.00021 3.241424575340379e-07 0 3.24166192606069e-07 0 3.24176192606069e-07 0.00021 3.24186192606069e-07 0 3.24186192606069e-07 0 3.24196192606069e-07 0.00021 3.2420619260606903e-07 0 3.2420619260606903e-07 0 3.2421619260606905e-07 0.00021 3.2422619260606906e-07 0 3.2422619260606906e-07 0 3.2423619260606907e-07 0.00021 3.242461926060691e-07 0 3.242461926060691e-07 0 3.242561926060691e-07 0.00021 3.242661926060691e-07 0 3.243135367170126e-07 0 3.243235367170126e-07 0.00021 3.243335367170126e-07 0 3.244107273597648e-07 0 3.2442072735976484e-07 0.00021 3.2443072735976485e-07 0 3.2443072735976485e-07 0 3.2444072735976486e-07 0.00021 3.2445072735976487e-07 0 3.244884084965475e-07 0 3.244984084965475e-07 0.00021 3.2450840849654753e-07 0 3.2450840849654753e-07 0 3.2451840849654754e-07 0.00021 3.2452840849654755e-07 0 3.2452840849654755e-07 0 3.2453840849654756e-07 0.00021 3.245484084965476e-07 0 3.245484084965476e-07 0 3.245584084965476e-07 0.00021 3.245684084965476e-07 0 3.245684084965476e-07 0 3.245784084965476e-07 0.00021 3.245884084965476e-07 0 3.2460190278506587e-07 0 3.246119027850659e-07 0.00021 3.246219027850659e-07 0 3.246373841196538e-07 0 3.246473841196538e-07 0.00021 3.246573841196538e-07 0 3.2468749288205833e-07 0 3.2469749288205834e-07 0.00021 3.2470749288205835e-07 0 3.2470749288205835e-07 0 3.2471749288205836e-07 0.00021 3.2472749288205837e-07 0 3.2472749288205837e-07 0 3.247374928820584e-07 0.00021 3.247474928820584e-07 0 3.247474928820584e-07 0 3.247574928820584e-07 0.00021 3.247674928820584e-07 0 3.247674928820584e-07 0 3.2477749288205843e-07 0.00021 3.2478749288205844e-07 0 3.2478749288205844e-07 0 3.2479749288205845e-07 0.00021 3.2480749288205846e-07 0 3.2480749288205846e-07 0 3.248174928820585e-07 0.00021 3.248274928820585e-07 0 3.248274928820585e-07 0 3.248374928820585e-07 0.00021 3.248474928820585e-07 0 3.248474928820585e-07 0 3.248574928820585e-07 0.00021 3.2486749288205853e-07 0 3.24873180636363e-07 0 3.24883180636363e-07 0.00021 3.2489318063636303e-07 0 3.2489318063636303e-07 0 3.2490318063636304e-07 0.00021 3.2491318063636305e-07 0 3.2491318063636305e-07 0 3.2492318063636306e-07 0.00021 3.249331806363631e-07 0 3.249675833892992e-07 0 3.249775833892992e-07 0.00021 3.249875833892992e-07 0 3.249875833892992e-07 0 3.2499758338929923e-07 0.00021 3.2500758338929924e-07 0 3.2500758338929924e-07 0 3.2501758338929926e-07 0.00021 3.2502758338929927e-07 0 3.250397485436318e-07 0 3.2504974854363183e-07 0.00021 3.2505974854363185e-07 0 3.2512869036375185e-07 0 3.2513869036375186e-07 0.00021 3.251486903637519e-07 0 3.251486903637519e-07 0 3.251586903637519e-07 0.00021 3.251686903637519e-07 0 3.251686903637519e-07 0 3.251786903637519e-07 0.00021 3.251886903637519e-07 0 3.2520494435298405e-07 0 3.2521494435298407e-07 0.00021 3.252249443529841e-07 0 3.252369617567551e-07 0 3.2524696175675513e-07 0.00021 3.2525696175675515e-07 0 3.2526449292968704e-07 0 3.2527449292968705e-07 0.00021 3.2528449292968706e-07 0 3.2530073200689447e-07 0 3.253107320068945e-07 0.00021 3.253207320068945e-07 0 3.253422151894719e-07 0 3.253522151894719e-07 0.00021 3.2536221518947194e-07 0 3.2536823907642765e-07 0 3.2537823907642766e-07 0.00021 3.2538823907642767e-07 0 3.2538823907642767e-07 0 3.253982390764277e-07 0.00021 3.254082390764277e-07 0 3.254082390764277e-07 0 3.254182390764277e-07 0.00021 3.254282390764277e-07 0 3.254282390764277e-07 0 3.2543823907642773e-07 0.00021 3.2544823907642774e-07 0 3.2544823907642774e-07 0 3.2545823907642775e-07 0.00021 3.2546823907642776e-07 0 3.2546823907642776e-07 0 3.254782390764278e-07 0.00021 3.254882390764278e-07 0 3.254882390764278e-07 0 3.254982390764278e-07 0.00021 3.255082390764278e-07 0 3.255082390764278e-07 0 3.255182390764278e-07 0.00021 3.2552823907642783e-07 0 3.2553267074325106e-07 0 3.2554267074325107e-07 0.00021 3.255526707432511e-07 0 3.2559236560619474e-07 0 3.2560236560619475e-07 0.00021 3.2561236560619476e-07 0 3.2561236560619476e-07 0 3.256223656061948e-07 0.00021 3.256323656061948e-07 0 3.25746914605533e-07 0 3.25756914605533e-07 0.00021 3.25766914605533e-07 0 3.25766914605533e-07 0 3.25776914605533e-07 0.00021 3.2578691460553304e-07 0 3.2578691460553304e-07 0 3.2579691460553305e-07 0.00021 3.2580691460553306e-07 0 3.2580691460553306e-07 0 3.2581691460553307e-07 0.00021 3.258269146055331e-07 0 3.258269146055331e-07 0 3.258369146055331e-07 0.00021 3.258469146055331e-07 0 3.258469146055331e-07 0 3.258569146055331e-07 0.00021 3.2586691460553313e-07 0 3.2587996333531417e-07 0 3.258899633353142e-07 0.00021 3.258999633353142e-07 0 3.259029621385367e-07 0 3.259129621385367e-07 0.00021 3.2592296213853673e-07 0 3.2592296213853673e-07 0 3.2593296213853674e-07 0.00021 3.2594296213853676e-07 0 3.2594296213853676e-07 0 3.2595296213853677e-07 0.00021 3.259629621385368e-07 0 3.259629621385368e-07 0 3.259729621385368e-07 0.00021 3.259829621385368e-07 0 3.259829621385368e-07 0 3.259929621385368e-07 0.00021 3.260029621385368e-07 0 3.260626111073974e-07 0 3.2607261110739743e-07 0.00021 3.2608261110739744e-07 0 3.2608261110739744e-07 0 3.2609261110739745e-07 0.00021 3.2610261110739746e-07 0 3.2610261110739746e-07 0 3.2611261110739747e-07 0.00021 3.261226111073975e-07 0 3.261226111073975e-07 0 3.261326111073975e-07 0.00021 3.261426111073975e-07 0 3.261426111073975e-07 0 3.261526111073975e-07 0.00021 3.2616261110739753e-07 0 3.2617913421416864e-07 0 3.2618913421416865e-07 0.00021 3.2619913421416866e-07 0 3.262085544463467e-07 0 3.262185544463467e-07 0.00021 3.2622855444634674e-07 0 3.262730128266462e-07 0 3.262830128266462e-07 0.00021 3.262930128266462e-07 0 3.262930128266462e-07 0 3.263030128266462e-07 0.00021 3.263130128266462e-07 0 3.263385705153042e-07 0 3.263485705153042e-07 0.00021 3.263585705153042e-07 0 3.2636562812746983e-07 0 3.2637562812746984e-07 0.00021 3.2638562812746985e-07 0 3.2638562812746985e-07 0 3.2639562812746986e-07 0.00021 3.264056281274699e-07 0 3.264491096904945e-07 0 3.264591096904945e-07 0.00021 3.264691096904945e-07 0 3.265097461143877e-07 0 3.265197461143877e-07 0.00021 3.265297461143877e-07 0 3.2659304259387135e-07 0 3.2660304259387137e-07 0.00021 3.266130425938714e-07 0 3.266130425938714e-07 0 3.266230425938714e-07 0.00021 3.266330425938714e-07 0 3.266477960866206e-07 0 3.266577960866206e-07 0.00021 3.266677960866206e-07 0 3.266677960866206e-07 0 3.266777960866206e-07 0.00021 3.2668779608662063e-07 0 3.2668779608662063e-07 0 3.2669779608662064e-07 0.00021 3.2670779608662065e-07 0 3.2673582925428515e-07 0 3.2674582925428516e-07 0.00021 3.2675582925428517e-07 0 3.2675582925428517e-07 0 3.267658292542852e-07 0.00021 3.267758292542852e-07 0 3.267758292542852e-07 0 3.267858292542852e-07 0.00021 3.267958292542852e-07 0 3.267958292542852e-07 0 3.2680582925428523e-07 0.00021 3.2681582925428524e-07 0 3.2681582925428524e-07 0 3.2682582925428525e-07 0.00021 3.2683582925428526e-07 0 3.2683582925428526e-07 0 3.268458292542853e-07 0.00021 3.268558292542853e-07 0 3.268558292542853e-07 0 3.268658292542853e-07 0.00021 3.268758292542853e-07 0 3.268758292542853e-07 0 3.268858292542853e-07 0.00021 3.2689582925428533e-07 0 3.2689582925428533e-07 0 3.2690582925428534e-07 0.00021 3.2691582925428535e-07 0 3.2691582925428535e-07 0 3.2692582925428537e-07 0.00021 3.269358292542854e-07 0 3.269358292542854e-07 0 3.269458292542854e-07 0.00021 3.269558292542854e-07 0 3.269558292542854e-07 0 3.269658292542854e-07 0.00021 3.269758292542854e-07 0 3.269766584280248e-07 0 3.269866584280248e-07 0.00021 3.269966584280248e-07 0 3.269966584280248e-07 0 3.270066584280248e-07 0.00021 3.2701665842802483e-07 0 3.2701665842802483e-07 0 3.2702665842802484e-07 0.00021 3.2703665842802486e-07 0 3.2703665842802486e-07 0 3.2704665842802487e-07 0.00021 3.270566584280249e-07 0 3.270566584280249e-07 0 3.270666584280249e-07 0.00021 3.270766584280249e-07 0 3.270766584280249e-07 0 3.270866584280249e-07 0.00021 3.270966584280249e-07 0 3.2718695406287205e-07 0 3.2719695406287206e-07 0.00021 3.2720695406287207e-07 0 3.2720695406287207e-07 0 3.272169540628721e-07 0.00021 3.272269540628721e-07 0 3.2724657248143963e-07 0 3.2725657248143964e-07 0.00021 3.2726657248143965e-07 0 3.2726657248143965e-07 0 3.2727657248143967e-07 0.00021 3.272865724814397e-07 0 3.272865724814397e-07 0 3.272965724814397e-07 0.00021 3.273065724814397e-07 0 3.27306989016302e-07 0 3.2731698901630203e-07 0.00021 3.2732698901630204e-07 0 3.2737070461506547e-07 0 3.273807046150655e-07 0.00021 3.273907046150655e-07 0 3.273907046150655e-07 0 3.274007046150655e-07 0.00021 3.274107046150655e-07 0 3.274107046150655e-07 0 3.274207046150655e-07 0.00021 3.2743070461506554e-07 0 3.2743070461506554e-07 0 3.2744070461506555e-07 0.00021 3.2745070461506556e-07 0 3.274571839875904e-07 0 3.274671839875904e-07 0.00021 3.274771839875904e-07 0 3.275472914484426e-07 0 3.275572914484426e-07 0.00021 3.275672914484426e-07 0 3.2760611046718126e-07 0 3.276161104671813e-07 0.00021 3.276261104671813e-07 0 3.276313332365625e-07 0 3.276413332365625e-07 0.00021 3.276513332365625e-07 0 3.276513332365625e-07 0 3.276613332365625e-07 0.00021 3.276713332365625e-07 0 3.27736737496663e-07 0 3.27746737496663e-07 0.00021 3.27756737496663e-07 0 3.278575146970434e-07 0 3.278675146970434e-07 0.00021 3.278775146970434e-07 0 3.278775146970434e-07 0 3.278875146970434e-07 0.00021 3.278975146970434e-07 0 3.278975146970434e-07 0 3.2790751469704343e-07 0.00021 3.2791751469704345e-07 0 3.2791751469704345e-07 0 3.2792751469704346e-07 0.00021 3.2793751469704347e-07 0 3.2793751469704347e-07 0 3.279475146970435e-07 0.00021 3.279575146970435e-07 0 3.279575146970435e-07 0 3.279675146970435e-07 0.00021 3.279775146970435e-07 0 3.2798714865918247e-07 0 3.279971486591825e-07 0.00021 3.280071486591825e-07 0 3.280385068803515e-07 0 3.2804850688035153e-07 0.00021 3.2805850688035154e-07 0 3.2808763486611333e-07 0 3.2809763486611334e-07 0.00021 3.2810763486611336e-07 0 3.281195063166738e-07 0 3.281295063166738e-07 0.00021 3.2813950631667384e-07 0 3.2813950631667384e-07 0 3.2814950631667385e-07 0.00021 3.2815950631667386e-07 0 3.2829253901609377e-07 0 3.283025390160938e-07 0.00021 3.283125390160938e-07 0 3.283662424295471e-07 0 3.283762424295471e-07 0.00021 3.283862424295471e-07 0 3.283904758399621e-07 0 3.284004758399621e-07 0.00021 3.284104758399621e-07 0 3.284417506087718e-07 0 3.284517506087718e-07 0.00021 3.284617506087718e-07 0 3.284617506087718e-07 0 3.284717506087718e-07 0.00021 3.284817506087718e-07 0 3.2849950405470807e-07 0 3.285095040547081e-07 0.00021 3.285195040547081e-07 0 3.285195040547081e-07 0 3.285295040547081e-07 0.00021 3.285395040547081e-07 0 3.285395040547081e-07 0 3.285495040547081e-07 0.00021 3.2855950405470814e-07 0 3.2855950405470814e-07 0 3.2856950405470815e-07 0.00021 3.2857950405470816e-07 0 3.2858255749720866e-07 0 3.285925574972087e-07 0.00021 3.286025574972087e-07 0 3.286025574972087e-07 0 3.286125574972087e-07 0.00021 3.286225574972087e-07 0 3.286238254292305e-07 0 3.286338254292305e-07 0.00021 3.286438254292305e-07 0 3.286462852547642e-07 0 3.286562852547642e-07 0.00021 3.2866628525476423e-07 0 3.2872163027817036e-07 0 3.287316302781704e-07 0.00021 3.287416302781704e-07 0 3.2876771454611784e-07 0 3.2877771454611785e-07 0.00021 3.2878771454611786e-07 0 3.2878771454611786e-07 0 3.287977145461179e-07 0.00021 3.288077145461179e-07 0 3.2882514220815614e-07 0 3.2883514220815615e-07 0.00021 3.2884514220815617e-07 0 3.288931996496248e-07 0 3.289031996496248e-07 0.00021 3.2891319964962483e-07 0 3.2892263782481977e-07 0 3.289326378248198e-07 0.00021 3.289426378248198e-07 0 3.289774649355008e-07 0 3.289874649355008e-07 0.00021 3.2899746493550083e-07 0 3.2899746493550083e-07 0 3.2900746493550085e-07 0.00021 3.2901746493550086e-07 0 3.2907905033554403e-07 0 3.2908905033554404e-07 0.00021 3.2909905033554405e-07 0 3.2909905033554405e-07 0 3.2910905033554406e-07 0.00021 3.291190503355441e-07 0 3.29160626964664e-07 0 3.2917062696466404e-07 0.00021 3.2918062696466405e-07 0 3.2924150947075346e-07 0 3.2925150947075347e-07 0.00021 3.292615094707535e-07 0 3.292615094707535e-07 0 3.292715094707535e-07 0.00021 3.292815094707535e-07 0 3.292815094707535e-07 0 3.292915094707535e-07 0.00021 3.2930150947075353e-07 0 3.2930150947075353e-07 0 3.2931150947075354e-07 0.00021 3.2932150947075355e-07 0 3.2934635118782433e-07 0 3.2935635118782435e-07 0.00021 3.2936635118782436e-07 0 3.2936635118782436e-07 0 3.2937635118782437e-07 0.00021 3.293863511878244e-07 0 3.293863511878244e-07 0 3.293963511878244e-07 0.00021 3.294063511878244e-07 0 3.294063511878244e-07 0 3.294163511878244e-07 0.00021 3.294263511878244e-07 0 3.294263511878244e-07 0 3.2943635118782444e-07 0.00021 3.2944635118782445e-07 0 3.2944635118782445e-07 0 3.2945635118782446e-07 0.00021 3.2946635118782447e-07 0 3.2953259920891657e-07 0 3.295425992089166e-07 0.00021 3.295525992089166e-07 0 3.295611339697524e-07 0 3.295711339697524e-07 0.00021 3.295811339697524e-07 0 3.295811339697524e-07 0 3.295911339697524e-07 0.00021 3.296011339697524e-07 0 3.296011339697524e-07 0 3.2961113396975244e-07 0.00021 3.2962113396975245e-07 0 3.2962113396975245e-07 0 3.2963113396975246e-07 0.00021 3.2964113396975247e-07 0 3.2964113396975247e-07 0 3.296511339697525e-07 0.00021 3.296611339697525e-07 0 3.29688213245184e-07 0 3.2969821324518403e-07 0.00021 3.2970821324518404e-07 0 3.2970821324518404e-07 0 3.2971821324518406e-07 0.00021 3.2972821324518407e-07 0 3.2973573062361007e-07 0 3.297457306236101e-07 0.00021 3.297557306236101e-07 0 3.2995839309773883e-07 0 3.2996839309773884e-07 0.00021 3.2997839309773886e-07 0 3.3002366777858326e-07 0 3.300336677785833e-07 0.00021 3.300436677785833e-07 0 3.3009030894677607e-07 0 3.301003089467761e-07 0.00021 3.301103089467761e-07 0 3.301103089467761e-07 0 3.301203089467761e-07 0.00021 3.301303089467761e-07 0 3.3016323388181224e-07 0 3.3017323388181225e-07 0.00021 3.3018323388181226e-07 0 3.302075446212752e-07 0 3.302175446212752e-07 0.00021 3.302275446212752e-07 0 3.3025691955746117e-07 0 3.302669195574612e-07 0.00021 3.302769195574612e-07 0 3.302926653666037e-07 0 3.303026653666037e-07 0.00021 3.303126653666037e-07 0 3.303130712398277e-07 0 3.303230712398277e-07 0.00021 3.3033307123982773e-07 0 3.303378083694361e-07 0 3.303478083694361e-07 0.00021 3.303578083694361e-07 0 3.3039743847612306e-07 0 3.3040743847612307e-07 0.00021 3.304174384761231e-07 0 3.3042146151186314e-07 0 3.3043146151186316e-07 0.00021 3.3044146151186317e-07 0 3.304587738978366e-07 0 3.304687738978366e-07 0.00021 3.3047877389783663e-07 0 3.3051179850045096e-07 0 3.30521798500451e-07 0.00021 3.30531798500451e-07 0 3.305437240240113e-07 0 3.3055372402401133e-07 0.00021 3.3056372402401135e-07 0 3.3056372402401135e-07 0 3.3057372402401136e-07 0.00021 3.3058372402401137e-07 0 3.3058372402401137e-07 0 3.305937240240114e-07 0.00021 3.306037240240114e-07 0 3.306037240240114e-07 0 3.306137240240114e-07 0.00021 3.306237240240114e-07 0 3.306237240240114e-07 0 3.306337240240114e-07 0.00021 3.3064372402401144e-07 0 3.306469424709608e-07 0 3.306569424709608e-07 0.00021 3.306669424709608e-07 0 3.307032116521997e-07 0 3.3071321165219973e-07 0.00021 3.3072321165219974e-07 0 3.3072321165219974e-07 0 3.3073321165219975e-07 0.00021 3.3074321165219976e-07 0 3.3074321165219976e-07 0 3.307532116521998e-07 0.00021 3.307632116521998e-07 0 3.307632116521998e-07 0 3.307732116521998e-07 0.00021 3.307832116521998e-07 0 3.307832116521998e-07 0 3.307932116521998e-07 0.00021 3.3080321165219983e-07 0 3.3080321165219983e-07 0 3.3081321165219984e-07 0.00021 3.3082321165219985e-07 0 3.3082321165219985e-07 0 3.3083321165219986e-07 0.00021 3.308432116521999e-07 0 3.308432116521999e-07 0 3.308532116521999e-07 0.00021 3.308632116521999e-07 0 3.308632116521999e-07 0 3.308732116521999e-07 0.00021 3.308832116521999e-07 0 3.308832116521999e-07 0 3.3089321165219993e-07 0.00021 3.3090321165219994e-07 0 3.3090321165219994e-07 0 3.3091321165219996e-07 0.00021 3.3092321165219997e-07 0 3.3092321165219997e-07 0 3.309332116522e-07 0.00021 3.309432116522e-07 0 3.309432116522e-07 0 3.309532116522e-07 0.00021 3.309632116522e-07 0 3.309632116522e-07 0 3.309732116522e-07 0.00021 3.3098321165220003e-07 0 3.3098321165220003e-07 0 3.3099321165220005e-07 0.00021 3.3100321165220006e-07 0 3.3100321165220006e-07 0 3.3101321165220007e-07 0.00021 3.310232116522001e-07 0 3.31023801495231e-07 0 3.31033801495231e-07 0.00021 3.31043801495231e-07 0 3.310439908247405e-07 0 3.3105399082474053e-07 0.00021 3.3106399082474054e-07 0 3.3106561343600823e-07 0 3.3107561343600824e-07 0.00021 3.3108561343600825e-07 0 3.3108561343600825e-07 0 3.3109561343600827e-07 0.00021 3.311056134360083e-07 0 3.311056134360083e-07 0 3.311156134360083e-07 0.00021 3.311256134360083e-07 0 3.311256134360083e-07 0 3.311356134360083e-07 0.00021 3.311456134360083e-07 0 3.3116982994051567e-07 0 3.311798299405157e-07 0.00021 3.311898299405157e-07 0 3.312070648540229e-07 0 3.312170648540229e-07 0.00021 3.312270648540229e-07 0 3.312664766859905e-07 0 3.312764766859905e-07 0.00021 3.312864766859905e-07 0 3.3138646724664467e-07 0 3.313964672466447e-07 0.00021 3.314064672466447e-07 0 3.314064672466447e-07 0 3.314164672466447e-07 0.00021 3.314264672466447e-07 0 3.314264672466447e-07 0 3.314364672466447e-07 0.00021 3.3144646724664473e-07 0 3.3144646724664473e-07 0 3.3145646724664474e-07 0.00021 3.3146646724664476e-07 0 3.3146646724664476e-07 0 3.3147646724664477e-07 0.00021 3.314864672466448e-07 0 3.314975118573105e-07 0 3.3150751185731053e-07 0.00021 3.3151751185731054e-07 0 3.315217189120279e-07 0 3.315317189120279e-07 0.00021 3.315417189120279e-07 0 3.3160765265691153e-07 0 3.3161765265691154e-07 0.00021 3.3162765265691155e-07 0 3.317980192832839e-07 0 3.318080192832839e-07 0.00021 3.318180192832839e-07 0 3.318180192832839e-07 0 3.318280192832839e-07 0.00021 3.318380192832839e-07 0 3.3193480940620736e-07 0 3.319448094062074e-07 0.00021 3.319548094062074e-07 0 3.319548094062074e-07 0 3.319648094062074e-07 0.00021 3.319748094062074e-07 0 3.31987456639087e-07 0 3.31997456639087e-07 0.00021 3.32007456639087e-07 0 3.3204355396088415e-07 0 3.3205355396088416e-07 0.00021 3.320635539608842e-07 0 3.321273983921415e-07 0 3.321373983921415e-07 0.00021 3.3214739839214153e-07 0 3.32174530420607e-07 0 3.32184530420607e-07 0.00021 3.32194530420607e-07 0 3.3220775056364026e-07 0 3.3221775056364027e-07 0.00021 3.322277505636403e-07 0 3.322286420763914e-07 0 3.322386420763914e-07 0.00021 3.3224864207639144e-07 0 3.3224864207639144e-07 0 3.3225864207639145e-07 0.00021 3.3226864207639146e-07 0 3.3226864207639146e-07 0 3.3227864207639147e-07 0.00021 3.322886420763915e-07 0 3.323067317394304e-07 0 3.3231673173943044e-07 0.00021 3.3232673173943045e-07 0 3.3232673173943045e-07 0 3.3233673173943046e-07 0.00021 3.3234673173943047e-07 0 3.3234673173943047e-07 0 3.323567317394305e-07 0.00021 3.323667317394305e-07 0 3.323667317394305e-07 0 3.323767317394305e-07 0.00021 3.323867317394305e-07 0 3.323867317394305e-07 0 3.323967317394305e-07 0.00021 3.3240673173943054e-07 0 3.3248575632251737e-07 0 3.324957563225174e-07 0.00021 3.325057563225174e-07 0 3.325057563225174e-07 0 3.325157563225174e-07 0.00021 3.325257563225174e-07 0 3.325257563225174e-07 0 3.325357563225174e-07 0.00021 3.3254575632251744e-07 0 3.3261105801669146e-07 0 3.3262105801669147e-07 0.00021 3.326310580166915e-07 0 3.3276496404469166e-07 0 3.3277496404469167e-07 0.00021 3.327849640446917e-07 0 3.327851192918182e-07 0 3.327951192918182e-07 0.00021 3.328051192918182e-07 0 3.3282983608642323e-07 0 3.3283983608642324e-07 0.00021 3.3284983608642325e-07 0 3.3286054184917317e-07 0 3.328705418491732e-07 0.00021 3.328805418491732e-07 0 3.328805418491732e-07 0 3.328905418491732e-07 0.00021 3.329005418491732e-07 0 3.329005418491732e-07 0 3.329105418491732e-07 0.00021 3.3292054184917324e-07 0 3.3292054184917324e-07 0 3.3293054184917325e-07 0.00021 3.3294054184917326e-07 0 3.329679371872551e-07 0 3.329779371872551e-07 0.00021 3.329879371872551e-07 0 3.329879371872551e-07 0 3.329979371872551e-07 0.00021 3.3300793718725513e-07 0 3.3300793718725513e-07 0 3.3301793718725514e-07 0.00021 3.3302793718725515e-07 0 3.330612813868088e-07 0 3.330712813868088e-07 0.00021 3.330812813868088e-07 0 3.330939772542131e-07 0 3.3310397725421313e-07 0.00021 3.3311397725421314e-07 0 3.3311397725421314e-07 0 3.3312397725421315e-07 0.00021 3.3313397725421316e-07 0 3.3315519100608887e-07 0 3.331651910060889e-07 0.00021 3.331751910060889e-07 0 3.331751910060889e-07 0 3.331851910060889e-07 0.00021 3.331951910060889e-07 0 3.3321878586553035e-07 0 3.3322878586553036e-07 0.00021 3.3323878586553037e-07 0 3.3323878586553037e-07 0 3.332487858655304e-07 0.00021 3.332587858655304e-07 0 3.332587858655304e-07 0 3.332687858655304e-07 0.00021 3.332787858655304e-07 0 3.3328664680688824e-07 0 3.3329664680688825e-07 0.00021 3.3330664680688827e-07 0 3.3344287278841566e-07 0 3.334528727884157e-07 0.00021 3.334628727884157e-07 0 3.3348538354325664e-07 0 3.3349538354325665e-07 0.00021 3.3350538354325666e-07 0 3.3350538354325666e-07 0 3.3351538354325667e-07 0.00021 3.335253835432567e-07 0 3.335253835432567e-07 0 3.335353835432567e-07 0.00021 3.335453835432567e-07 0 3.335759530159161e-07 0 3.335859530159161e-07 0.00021 3.335959530159161e-07 0 3.3361021415570585e-07 0 3.3362021415570586e-07 0.00021 3.3363021415570587e-07 0 3.336598288723028e-07 0 3.336698288723028e-07 0.00021 3.336798288723028e-07 0 3.336814373572581e-07 0 3.336914373572581e-07 0.00021 3.337014373572581e-07 0 3.337350278115244e-07 0 3.337450278115244e-07 0.00021 3.3375502781152443e-07 0 3.338244148868613e-07 0 3.338344148868613e-07 0.00021 3.3384441488686134e-07 0 3.3384441488686134e-07 0 3.3385441488686135e-07 0.00021 3.3386441488686136e-07 0 3.3386441488686136e-07 0 3.3387441488686137e-07 0.00021 3.338844148868614e-07 0 3.3388523610939575e-07 0 3.3389523610939576e-07 0.00021 3.3390523610939577e-07 0 3.3393690471565827e-07 0 3.339469047156583e-07 0.00021 3.339569047156583e-07 0 3.339569047156583e-07 0 3.339669047156583e-07 0.00021 3.339769047156583e-07 0 3.339769047156583e-07 0 3.3398690471565833e-07 0.00021 3.3399690471565834e-07 0 3.3399690471565834e-07 0 3.3400690471565835e-07 0.00021 3.3401690471565836e-07 0 3.340341299469156e-07 0 3.340441299469156e-07 0.00021 3.340541299469156e-07 0 3.340541299469156e-07 0 3.340641299469156e-07 0.00021 3.340741299469156e-07 0 3.340741299469156e-07 0 3.3408412994691564e-07 0.00021 3.3409412994691565e-07 0 3.3409412994691565e-07 0 3.3410412994691566e-07 0.00021 3.3411412994691567e-07 0 3.341679681364423e-07 0 3.341779681364423e-07 0.00021 3.3418796813644233e-07 0 3.342414081192439e-07 0 3.342514081192439e-07 0.00021 3.342614081192439e-07 0 3.342614081192439e-07 0 3.3427140811924394e-07 0.00021 3.3428140811924395e-07 0 3.3428140811924395e-07 0 3.3429140811924396e-07 0.00021 3.3430140811924397e-07 0 3.3430140811924397e-07 0 3.34311408119244e-07 0.00021 3.34321408119244e-07 0 3.34321408119244e-07 0 3.34331408119244e-07 0.00021 3.34341408119244e-07 0 3.344594848403863e-07 0 3.344694848403863e-07 0.00021 3.3447948484038633e-07 0 3.3447948484038633e-07 0 3.3448948484038634e-07 0.00021 3.3449948484038635e-07 0 3.3449985792275266e-07 0 3.3450985792275267e-07 0.00021 3.345198579227527e-07 0 3.34526129401298e-07 0 3.34536129401298e-07 0.00021 3.3454612940129803e-07 0 3.3454612940129803e-07 0 3.3455612940129804e-07 0.00021 3.3456612940129806e-07 0 3.3456612940129806e-07 0 3.3457612940129807e-07 0.00021 3.345861294012981e-07 0 3.3460428505851126e-07 0 3.3461428505851127e-07 0.00021 3.346242850585113e-07 0 3.346242850585113e-07 0 3.346342850585113e-07 0.00021 3.346442850585113e-07 0 3.346442850585113e-07 0 3.346542850585113e-07 0.00021 3.3466428505851133e-07 0 3.3466428505851133e-07 0 3.3467428505851134e-07 0.00021 3.3468428505851135e-07 0 3.347469056850971e-07 0 3.347569056850971e-07 0.00021 3.347669056850971e-07 0 3.347669056850971e-07 0 3.347769056850971e-07 0.00021 3.3478690568509713e-07 0 3.3478690568509713e-07 0 3.3479690568509714e-07 0.00021 3.3480690568509715e-07 0 3.3480690568509715e-07 0 3.3481690568509716e-07 0.00021 3.3482690568509717e-07 0 3.3482690568509717e-07 0 3.348369056850972e-07 0.00021 3.348469056850972e-07 0 3.348469056850972e-07 0 3.348569056850972e-07 0.00021 3.348669056850972e-07 0 3.348669056850972e-07 0 3.3487690568509723e-07 0.00021 3.3488690568509724e-07 0 3.3488690568509724e-07 0 3.3489690568509725e-07 0.00021 3.3490690568509726e-07 0 3.3490690568509726e-07 0 3.349169056850973e-07 0.00021 3.349269056850973e-07 0 3.349269056850973e-07 0 3.349369056850973e-07 0.00021 3.349469056850973e-07 0 3.349469056850973e-07 0 3.349569056850973e-07 0.00021 3.3496690568509733e-07 0 3.3496690568509733e-07 0 3.3497690568509734e-07 0.00021 3.3498690568509735e-07 0 3.3498690568509735e-07 0 3.3499690568509737e-07 0.00021 3.350069056850974e-07 0 3.350069056850974e-07 0 3.350169056850974e-07 0.00021 3.350269056850974e-07 0 3.350269056850974e-07 0 3.350369056850974e-07 0.00021 3.350469056850974e-07 0 3.350469056850974e-07 0 3.3505690568509743e-07 0.00021 3.3506690568509744e-07 0 3.3506690568509744e-07 0 3.3507690568509746e-07 0.00021 3.3508690568509747e-07 0 3.3508690568509747e-07 0 3.350969056850975e-07 0.00021 3.351069056850975e-07 0 3.351069056850975e-07 0 3.351169056850975e-07 0.00021 3.351269056850975e-07 0 3.351269056850975e-07 0 3.351369056850975e-07 0.00021 3.3514690568509754e-07 0 3.3514690568509754e-07 0 3.3515690568509755e-07 0.00021 3.3516690568509756e-07 0 3.3516690568509756e-07 0 3.3517690568509757e-07 0.00021 3.351869056850976e-07 0 3.351869056850976e-07 0 3.351969056850976e-07 0.00021 3.352069056850976e-07 0 3.352069056850976e-07 0 3.352169056850976e-07 0.00021 3.352269056850976e-07 0 3.3524326979422264e-07 0 3.3525326979422265e-07 0.00021 3.3526326979422267e-07 0 3.3526326979422267e-07 0 3.352732697942227e-07 0.00021 3.352832697942227e-07 0 3.3530815451171953e-07 0 3.3531815451171954e-07 0.00021 3.3532815451171955e-07 0 3.353455701250584e-07 0 3.353555701250584e-07 0.00021 3.353655701250584e-07 0 3.3537613812810785e-07 0 3.3538613812810786e-07 0.00021 3.353961381281079e-07 0 3.353961381281079e-07 0 3.354061381281079e-07 0.00021 3.354161381281079e-07 0 3.354161381281079e-07 0 3.354261381281079e-07 0.00021 3.354361381281079e-07 0 3.3546258281546436e-07 0 3.3547258281546437e-07 0.00021 3.354825828154644e-07 0 3.354981379655308e-07 0 3.3550813796553083e-07 0.00021 3.3551813796553084e-07 0 3.355758897687901e-07 0 3.355858897687901e-07 0.00021 3.355958897687901e-07 0 3.3563615482086257e-07 0 3.356461548208626e-07 0.00021 3.356561548208626e-07 0 3.356561548208626e-07 0 3.356661548208626e-07 0.00021 3.356761548208626e-07 0 3.356761548208626e-07 0 3.3568615482086263e-07 0.00021 3.3569615482086264e-07 0 3.3569615482086264e-07 0 3.3570615482086265e-07 0.00021 3.3571615482086266e-07 0 3.3571615482086266e-07 0 3.357261548208627e-07 0.00021 3.357361548208627e-07 0 3.357361548208627e-07 0 3.357461548208627e-07 0.00021 3.357561548208627e-07 0 3.357685632566194e-07 0 3.357785632566194e-07 0.00021 3.357885632566194e-07 0 3.35829543745447e-07 0 3.35839543745447e-07 0.00021 3.3584954374544703e-07 0 3.3584954374544703e-07 0 3.3585954374544704e-07 0.00021 3.3586954374544705e-07 0 3.3588001083399806e-07 0 3.3589001083399807e-07 0.00021 3.359000108339981e-07 0 3.359000108339981e-07 0 3.359100108339981e-07 0.00021 3.359200108339981e-07 0 3.359398935906053e-07 0 3.359498935906053e-07 0.00021 3.359598935906053e-07 0 3.360063299456192e-07 0 3.360163299456192e-07 0.00021 3.360263299456192e-07 0 3.361380220226389e-07 0 3.361480220226389e-07 0.00021 3.361580220226389e-07 0 3.361588542835437e-07 0 3.361688542835437e-07 0.00021 3.361788542835437e-07 0 3.3618414293004527e-07 0 3.361941429300453e-07 0.00021 3.362041429300453e-07 0 3.362335489714448e-07 0 3.3624354897144483e-07 0.00021 3.3625354897144484e-07 0 3.3625354897144484e-07 0 3.3626354897144486e-07 0.00021 3.3627354897144487e-07 0 3.363279060218777e-07 0 3.3633790602187773e-07 0.00021 3.3634790602187774e-07 0 3.3636609490699103e-07 0 3.3637609490699104e-07 0.00021 3.3638609490699105e-07 0 3.3638609490699105e-07 0 3.3639609490699106e-07 0.00021 3.3640609490699107e-07 0 3.3640609490699107e-07 0 3.364160949069911e-07 0.00021 3.364260949069911e-07 0 3.3648863833511567e-07 0 3.364986383351157e-07 0.00021 3.365086383351157e-07 0 3.3652468566443874e-07 0 3.3653468566443875e-07 0.00021 3.3654468566443877e-07 0 3.365599460841715e-07 0 3.3656994608417153e-07 0.00021 3.3657994608417155e-07 0 3.365811560509999e-07 0 3.365911560509999e-07 0.00021 3.366011560509999e-07 0 3.366011560509999e-07 0 3.366111560509999e-07 0.00021 3.366211560509999e-07 0 3.3665551471261123e-07 0 3.3666551471261124e-07 0.00021 3.3667551471261125e-07 0 3.3667551471261125e-07 0 3.3668551471261127e-07 0.00021 3.366955147126113e-07 0 3.366955421298051e-07 0 3.3670554212980513e-07 0.00021 3.3671554212980514e-07 0 3.367503838975363e-07 0 3.367603838975363e-07 0.00021 3.367703838975363e-07 0 3.367703838975363e-07 0 3.367803838975363e-07 0.00021 3.3679038389753633e-07 0 3.3679038389753633e-07 0 3.3680038389753635e-07 0.00021 3.3681038389753636e-07 0 3.3681038389753636e-07 0 3.3682038389753637e-07 0.00021 3.368303838975364e-07 0 3.368652426756065e-07 0 3.3687524267560654e-07 0.00021 3.3688524267560655e-07 0 3.369095108498977e-07 0 3.369195108498977e-07 0.00021 3.3692951084989773e-07 0 3.3693169865500624e-07 0 3.3694169865500625e-07 0.00021 3.3695169865500627e-07 0 3.3695169865500627e-07 0 3.369616986550063e-07 0.00021 3.369716986550063e-07 0 3.369716986550063e-07 0 3.369816986550063e-07 0.00021 3.369916986550063e-07 0 3.370604916842746e-07 0 3.3707049168427463e-07 0.00021 3.3708049168427465e-07 0 3.371005962009615e-07 0 3.371105962009615e-07 0.00021 3.371205962009615e-07 0 3.3712195151709977e-07 0 3.371319515170998e-07 0.00021 3.371419515170998e-07 0 3.371419515170998e-07 0 3.371519515170998e-07 0.00021 3.371619515170998e-07 0 3.371619515170998e-07 0 3.3717195151709983e-07 0.00021 3.3718195151709984e-07 0 3.3718195151709984e-07 0 3.3719195151709985e-07 0.00021 3.3720195151709986e-07 0 3.3720195151709986e-07 0 3.3721195151709987e-07 0.00021 3.372219515170999e-07 0 3.373185893819361e-07 0 3.3732858938193614e-07 0.00021 3.3733858938193615e-07 0 3.3734980190769507e-07 0 3.373598019076951e-07 0.00021 3.373698019076951e-07 0 3.373698019076951e-07 0 3.373798019076951e-07 0.00021 3.373898019076951e-07 0 3.373898019076951e-07 0 3.3739980190769513e-07 0.00021 3.3740980190769514e-07 0 3.3740980190769514e-07 0 3.3741980190769515e-07 0.00021 3.3742980190769516e-07 0 3.3745928989784896e-07 0 3.37469289897849e-07 0.00021 3.37479289897849e-07 0 3.37479289897849e-07 0 3.37489289897849e-07 0.00021 3.37499289897849e-07 0 3.37499289897849e-07 0 3.37509289897849e-07 0.00021 3.3751928989784903e-07 0 3.3751928989784903e-07 0 3.3752928989784904e-07 0.00021 3.3753928989784905e-07 0 3.3753928989784905e-07 0 3.3754928989784906e-07 0.00021 3.375592898978491e-07 0 3.375592898978491e-07 0 3.375692898978491e-07 0.00021 3.375792898978491e-07 0 3.375792898978491e-07 0 3.375892898978491e-07 0.00021 3.375992898978491e-07 0 3.375992898978491e-07 0 3.3760928989784913e-07 0.00021 3.3761928989784914e-07 0 3.3761928989784914e-07 0 3.3762928989784916e-07 0.00021 3.3763928989784917e-07 0 3.3763928989784917e-07 0 3.376492898978492e-07 0.00021 3.376592898978492e-07 0 3.376592898978492e-07 0 3.376692898978492e-07 0.00021 3.376792898978492e-07 0 3.377124814165172e-07 0 3.377224814165172e-07 0.00021 3.377324814165172e-07 0 3.377324814165172e-07 0 3.3774248141651723e-07 0.00021 3.3775248141651725e-07 0 3.3775248141651725e-07 0 3.3776248141651726e-07 0.00021 3.3777248141651727e-07 0 3.3777248141651727e-07 0 3.377824814165173e-07 0.00021 3.377924814165173e-07 0 3.3781515824948265e-07 0 3.3782515824948266e-07 0.00021 3.378351582494827e-07 0 3.378351582494827e-07 0 3.378451582494827e-07 0.00021 3.378551582494827e-07 0 3.378551582494827e-07 0 3.378651582494827e-07 0.00021 3.378751582494827e-07 0 3.378751582494827e-07 0 3.3788515824948273e-07 0.00021 3.3789515824948274e-07 0 3.379206343532689e-07 0 3.379306343532689e-07 0.00021 3.379406343532689e-07 0 3.379571548319898e-07 0 3.379671548319898e-07 0.00021 3.379771548319898e-07 0 3.379771548319898e-07 0 3.379871548319898e-07 0.00021 3.3799715483198984e-07 0 3.3802953093794034e-07 0 3.3803953093794035e-07 0.00021 3.3804953093794036e-07 0 3.3806870146056104e-07 0 3.3807870146056106e-07 0.00021 3.3808870146056107e-07 0 3.3811640660418325e-07 0 3.3812640660418326e-07 0.00021 3.381364066041833e-07 0 3.3814014188674685e-07 0 3.3815014188674686e-07 0.00021 3.3816014188674687e-07 0 3.3820126505042433e-07 0 3.3821126505042434e-07 0.00021 3.3822126505042435e-07 0 3.382371722731527e-07 0 3.3824717227315273e-07 0.00021 3.3825717227315274e-07 0 3.3829740069323e-07 0 3.3830740069323004e-07 0.00021 3.3831740069323005e-07 0 3.3833844597683214e-07 0 3.3834844597683215e-07 0.00021 3.3835844597683216e-07 0 3.3846091260049035e-07 0 3.3847091260049036e-07 0.00021 3.3848091260049037e-07 0 3.3848091260049037e-07 0 3.384909126004904e-07 0.00021 3.385009126004904e-07 0 3.3851349187390395e-07 0 3.3852349187390396e-07 0.00021 3.3853349187390397e-07 0 3.385595345393748e-07 0 3.385695345393748e-07 0.00021 3.385795345393748e-07 0 3.385795345393748e-07 0 3.385895345393748e-07 0.00021 3.3859953453937484e-07 0 3.3859953453937484e-07 0 3.3860953453937485e-07 0.00021 3.3861953453937486e-07 0 3.3861953453937486e-07 0 3.3862953453937487e-07 0.00021 3.386395345393749e-07 0 3.3868621259307484e-07 0 3.3869621259307485e-07 0.00021 3.3870621259307486e-07 0 3.3870621259307486e-07 0 3.3871621259307487e-07 0.00021 3.387262125930749e-07 0 3.387853118573516e-07 0 3.3879531185735164e-07 0.00021 3.3880531185735165e-07 0 3.38805576585736e-07 0 3.38815576585736e-07 0.00021 3.38825576585736e-07 0 3.388416657062057e-07 0 3.388516657062057e-07 0.00021 3.3886166570620574e-07 0 3.3887775766727126e-07 0 3.388877576672713e-07 0.00021 3.388977576672713e-07 0 3.388977576672713e-07 0 3.389077576672713e-07 0.00021 3.389177576672713e-07 0 3.3893669395906387e-07 0 3.389466939590639e-07 0.00021 3.389566939590639e-07 0 3.3897849255243697e-07 0 3.38988492552437e-07 0.00021 3.38998492552437e-07 0 3.38998492552437e-07 0 3.39008492552437e-07 0.00021 3.39018492552437e-07 0 3.3903921224770557e-07 0 3.390492122477056e-07 0.00021 3.390592122477056e-07 0 3.390592122477056e-07 0 3.390692122477056e-07 0.00021 3.390792122477056e-07 0 3.3908664448793736e-07 0 3.3909664448793737e-07 0.00021 3.391066444879374e-07 0 3.391066444879374e-07 0 3.391166444879374e-07 0.00021 3.391266444879374e-07 0 3.391266444879374e-07 0 3.391366444879374e-07 0.00021 3.391466444879374e-07 0 3.391466444879374e-07 0 3.3915664448793744e-07 0.00021 3.3916664448793745e-07 0 3.3916664448793745e-07 0 3.3917664448793746e-07 0.00021 3.3918664448793747e-07 0 3.3918664448793747e-07 0 3.391966444879375e-07 0.00021 3.392066444879375e-07 0 3.392066444879375e-07 0 3.392166444879375e-07 0.00021 3.392266444879375e-07 0 3.392266444879375e-07 0 3.392366444879375e-07 0.00021 3.3924664448793754e-07 0 3.3924664448793754e-07 0 3.3925664448793755e-07 0.00021 3.3926664448793756e-07 0 3.3926664448793756e-07 0 3.3927664448793757e-07 0.00021 3.392866444879376e-07 0 3.392866444879376e-07 0 3.392966444879376e-07 0.00021 3.393066444879376e-07 0 3.3932018997008306e-07 0 3.3933018997008307e-07 0.00021 3.393401899700831e-07 0 3.3936097208833105e-07 0 3.3937097208833106e-07 0.00021 3.393809720883311e-07 0 3.394528187010136e-07 0 3.3946281870101363e-07 0.00021 3.3947281870101364e-07 0 3.3947281870101364e-07 0 3.3948281870101365e-07 0.00021 3.3949281870101366e-07 0 3.3949281870101366e-07 0 3.3950281870101367e-07 0.00021 3.395128187010137e-07 0 3.395128187010137e-07 0 3.395228187010137e-07 0.00021 3.395328187010137e-07 0 3.395328187010137e-07 0 3.395428187010137e-07 0.00021 3.3955281870101373e-07 0 3.3955281870101373e-07 0 3.3956281870101374e-07 0.00021 3.3957281870101375e-07 0 3.3957694250735256e-07 0 3.395869425073526e-07 0.00021 3.395969425073526e-07 0 3.395969425073526e-07 0 3.396069425073526e-07 0.00021 3.396169425073526e-07 0 3.3964394299066877e-07 0 3.396539429906688e-07 0.00021 3.396639429906688e-07 0 3.396639429906688e-07 0 3.396739429906688e-07 0.00021 3.396839429906688e-07 0 3.3972631212575904e-07 0 3.3973631212575905e-07 0.00021 3.3974631212575906e-07 0 3.3974631212575906e-07 0 3.3975631212575907e-07 0.00021 3.397663121257591e-07 0 3.397663121257591e-07 0 3.397763121257591e-07 0.00021 3.397863121257591e-07 0 3.3982159251057107e-07 0 3.398315925105711e-07 0.00021 3.398415925105711e-07 0 3.398415925105711e-07 0 3.398515925105711e-07 0.00021 3.398615925105711e-07 0 3.398615925105711e-07 0 3.398715925105711e-07 0.00021 3.3988159251057113e-07 0 3.3990333158845537e-07 0 3.399133315884554e-07 0.00021 3.399233315884554e-07 0 3.399383024095712e-07 0 3.399483024095712e-07 0.00021 3.399583024095712e-07 0 3.399583024095712e-07 0 3.399683024095712e-07 0.00021 3.3997830240957123e-07 0 3.399801806749447e-07 0 3.3999018067494474e-07 0.00021 3.4000018067494475e-07 0 3.4000018067494475e-07 0 3.4001018067494476e-07 0.00021 3.4002018067494477e-07 0 3.400327539928573e-07 0 3.400427539928573e-07 0.00021 3.400527539928573e-07 0 3.400527539928573e-07 0 3.400627539928573e-07 0.00021 3.4007275399285733e-07 0 3.400748837552257e-07 0 3.4008488375522574e-07 0.00021 3.4009488375522575e-07 0 3.4009488375522575e-07 0 3.4010488375522576e-07 0.00021 3.4011488375522577e-07 0 3.4011488375522577e-07 0 3.401248837552258e-07 0.00021 3.401348837552258e-07 0 3.401813341801512e-07 0 3.401913341801512e-07 0.00021 3.402013341801512e-07 0 3.402236227560847e-07 0 3.402336227560847e-07 0.00021 3.4024362275608473e-07 0 3.4025700983407573e-07 0 3.4026700983407574e-07 0.00021 3.4027700983407576e-07 0 3.4028073234870153e-07 0 3.4029073234870154e-07 0.00021 3.4030073234870155e-07 0 3.403372026803532e-07 0 3.4034720268035324e-07 0.00021 3.4035720268035325e-07 0 3.4035720268035325e-07 0 3.4036720268035326e-07 0.00021 3.4037720268035327e-07 0 3.4041030694843165e-07 0 3.4042030694843166e-07 0.00021 3.4043030694843167e-07 0 3.404394070947314e-07 0 3.404494070947314e-07 0.00021 3.404594070947314e-07 0 3.40490986561884e-07 0 3.40500986561884e-07 0.00021 3.40510986561884e-07 0 3.40510986561884e-07 0 3.4052098656188403e-07 0.00021 3.4053098656188404e-07 0 3.4056250677213984e-07 0 3.4057250677213985e-07 0.00021 3.4058250677213986e-07 0 3.4058250677213986e-07 0 3.405925067721399e-07 0.00021 3.406025067721399e-07 0 3.406025067721399e-07 0 3.406125067721399e-07 0.00021 3.406225067721399e-07 0 3.406225067721399e-07 0 3.406325067721399e-07 0.00021 3.4064250677213993e-07 0 3.4064250677213993e-07 0 3.4065250677213994e-07 0.00021 3.4066250677213995e-07 0 3.4066250677213995e-07 0 3.4067250677213997e-07 0.00021 3.4068250677214e-07 0 3.40689354903398e-07 0 3.40699354903398e-07 0.00021 3.4070935490339804e-07 0 3.4070935490339804e-07 0 3.4071935490339805e-07 0.00021 3.4072935490339806e-07 0 3.4072935490339806e-07 0 3.4073935490339807e-07 0.00021 3.407493549033981e-07 0 3.407493549033981e-07 0 3.407593549033981e-07 0.00021 3.407693549033981e-07 0 3.407693549033981e-07 0 3.407793549033981e-07 0.00021 3.4078935490339813e-07 0 3.4078935490339813e-07 0 3.4079935490339814e-07 0.00021 3.4080935490339815e-07 0 3.4080935490339815e-07 0 3.4081935490339816e-07 0.00021 3.408293549033982e-07 0 3.408293549033982e-07 0 3.408393549033982e-07 0.00021 3.408493549033982e-07 0 3.409640345999894e-07 0 3.409740345999894e-07 0.00021 3.4098403459998943e-07 0 3.409965067101557e-07 0 3.410065067101557e-07 0.00021 3.410165067101557e-07 0 3.410245837404316e-07 0 3.410345837404316e-07 0.00021 3.410445837404316e-07 0 3.4109688365655104e-07 0 3.4110688365655105e-07 0.00021 3.4111688365655106e-07 0 3.411189679152069e-07 0 3.411289679152069e-07 0.00021 3.4113896791520693e-07 0 3.411478392180516e-07 0 3.411578392180516e-07 0.00021 3.411678392180516e-07 0 3.4117402660350316e-07 0 3.411840266035032e-07 0.00021 3.411940266035032e-07 0 3.411940266035032e-07 0 3.412040266035032e-07 0.00021 3.412140266035032e-07 0 3.412140266035032e-07 0 3.412240266035032e-07 0.00021 3.4123402660350323e-07 0 3.4123402660350323e-07 0 3.4124402660350324e-07 0.00021 3.4125402660350325e-07 0 3.4133010371927614e-07 0 3.4134010371927615e-07 0.00021 3.4135010371927616e-07 0 3.414752523613535e-07 0 3.414852523613535e-07 0.00021 3.4149525236135354e-07 0 3.414975488763004e-07 0 3.415075488763004e-07 0.00021 3.4151754887630043e-07 0 3.4151754887630043e-07 0 3.4152754887630044e-07 0.00021 3.4153754887630045e-07 0 3.415822094438388e-07 0 3.415922094438388e-07 0.00021 3.416022094438388e-07 0 3.4162787065176366e-07 0 3.4163787065176367e-07 0.00021 3.416478706517637e-07 0 3.41668383196576e-07 0 3.41678383196576e-07 0.00021 3.41688383196576e-07 0 3.41688383196576e-07 0 3.41698383196576e-07 0.00021 3.4170838319657604e-07 0 3.4170838319657604e-07 0 3.4171838319657605e-07 0.00021 3.4172838319657606e-07 0 3.4172838319657606e-07 0 3.4173838319657607e-07 0.00021 3.417483831965761e-07 0 3.417506264616923e-07 0 3.417606264616923e-07 0.00021 3.417706264616923e-07 0 3.4178876296820784e-07 0 3.4179876296820785e-07 0.00021 3.4180876296820786e-07 0 3.4181092618550793e-07 0 3.4182092618550794e-07 0.00021 3.4183092618550795e-07 0 3.4183092618550795e-07 0 3.4184092618550796e-07 0.00021 3.41850926185508e-07 0 3.418891573053736e-07 0 3.418991573053736e-07 0.00021 3.419091573053736e-07 0 3.419378476578341e-07 0 3.419478476578341e-07 0.00021 3.419578476578341e-07 0 3.4198186827711646e-07 0 3.4199186827711647e-07 0.00021 3.420018682771165e-07 0 3.4213509379578317e-07 0 3.421450937957832e-07 0.00021 3.421550937957832e-07 0 3.421759089983546e-07 0 3.421859089983546e-07 0.00021 3.421959089983546e-07 0 3.422260179069069e-07 0 3.4223601790690693e-07 0.00021 3.4224601790690694e-07 0 3.422890455941551e-07 0 3.422990455941551e-07 0.00021 3.423090455941551e-07 0 3.423090455941551e-07 0 3.423190455941551e-07 0.00021 3.423290455941551e-07 0 3.423290455941551e-07 0 3.4233904559415514e-07 0.00021 3.4234904559415515e-07 0 3.42424612324784e-07 0 3.42434612324784e-07 0.00021 3.42444612324784e-07 0 3.4244565115235783e-07 0 3.4245565115235784e-07 0.00021 3.4246565115235785e-07 0 3.4246565115235785e-07 0 3.4247565115235786e-07 0.00021 3.4248565115235787e-07 0 3.4248565115235787e-07 0 3.424956511523579e-07 0.00021 3.425056511523579e-07 0 3.426192734113899e-07 0 3.4262927341138993e-07 0.00021 3.4263927341138994e-07 0 3.4265734756372323e-07 0 3.4266734756372324e-07 0.00021 3.4267734756372325e-07 0 3.426976121509312e-07 0 3.427076121509312e-07 0.00021 3.427176121509312e-07 0 3.427976012678711e-07 0 3.428076012678711e-07 0.00021 3.4281760126787113e-07 0 3.4281760126787113e-07 0 3.4282760126787114e-07 0.00021 3.4283760126787115e-07 0 3.428679093017039e-07 0 3.428779093017039e-07 0.00021 3.4288790930170393e-07 0 3.4288790930170393e-07 0 3.4289790930170394e-07 0.00021 3.4290790930170395e-07 0 3.4290790930170395e-07 0 3.4291790930170397e-07 0.00021 3.42927909301704e-07 0 3.4294836488991095e-07 0 3.4295836488991096e-07 0.00021 3.42968364889911e-07 0 3.4300770349057907e-07 0 3.430177034905791e-07 0.00021 3.430277034905791e-07 0 3.430277034905791e-07 0 3.430377034905791e-07 0.00021 3.430477034905791e-07 0 3.430477034905791e-07 0 3.430577034905791e-07 0.00021 3.4306770349057914e-07 0 3.4306770349057914e-07 0 3.4307770349057915e-07 0.00021 3.4308770349057916e-07 0 3.4308770349057916e-07 0 3.4309770349057917e-07 0.00021 3.431077034905792e-07 0 3.431077034905792e-07 0 3.431177034905792e-07 0.00021 3.431277034905792e-07 0 3.431277034905792e-07 0 3.431377034905792e-07 0.00021 3.4314770349057923e-07 0 3.4314770349057923e-07 0 3.4315770349057924e-07 0.00021 3.4316770349057925e-07 0 3.4316770349057925e-07 0 3.4317770349057926e-07 0.00021 3.4318770349057927e-07 0 3.4319764519648886e-07 0 3.432076451964889e-07 0.00021 3.432176451964889e-07 0 3.432176451964889e-07 0 3.432276451964889e-07 0.00021 3.432376451964889e-07 0 3.4329333606947934e-07 0 3.4330333606947935e-07 0.00021 3.4331333606947936e-07 0 3.4331333606947936e-07 0 3.4332333606947937e-07 0.00021 3.433333360694794e-07 0 3.433333360694794e-07 0 3.433433360694794e-07 0.00021 3.433533360694794e-07 0 3.433533360694794e-07 0 3.433633360694794e-07 0.00021 3.4337333606947943e-07 0 3.4337333606947943e-07 0 3.4338333606947944e-07 0.00021 3.4339333606947945e-07 0 3.4339333606947945e-07 0 3.4340333606947946e-07 0.00021 3.4341333606947947e-07 0 3.4341333606947947e-07 0 3.434233360694795e-07 0.00021 3.434333360694795e-07 0 3.434333360694795e-07 0 3.434433360694795e-07 0.00021 3.434533360694795e-07 0 3.434533360694795e-07 0 3.4346333606947953e-07 0.00021 3.4347333606947954e-07 0 3.4347333606947954e-07 0 3.4348333606947955e-07 0.00021 3.4349333606947956e-07 0 3.4349333606947956e-07 0 3.435033360694796e-07 0.00021 3.435133360694796e-07 0 3.435133360694796e-07 0 3.435233360694796e-07 0.00021 3.435333360694796e-07 0 3.4368923041193953e-07 0 3.4369923041193954e-07 0.00021 3.4370923041193956e-07 0 3.4371213916162784e-07 0 3.4372213916162785e-07 0.00021 3.4373213916162786e-07 0 3.4373213916162786e-07 0 3.4374213916162787e-07 0.00021 3.437521391616279e-07 0 3.437521391616279e-07 0 3.437621391616279e-07 0.00021 3.437721391616279e-07 0 3.437721391616279e-07 0 3.437821391616279e-07 0.00021 3.4379213916162793e-07 0 3.4379213916162793e-07 0 3.4380213916162794e-07 0.00021 3.4381213916162795e-07 0 3.4381213916162795e-07 0 3.4382213916162796e-07 0.00021 3.43832139161628e-07 0 3.43832139161628e-07 0 3.43842139161628e-07 0.00021 3.43852139161628e-07 0 3.43852139161628e-07 0 3.43862139161628e-07 0.00021 3.43872139161628e-07 0 3.43872139161628e-07 0 3.4388213916162803e-07 0.00021 3.4389213916162804e-07 0 3.4391898308127576e-07 0 3.439289830812758e-07 0.00021 3.439389830812758e-07 0 3.439435959109661e-07 0 3.439535959109661e-07 0.00021 3.4396359591096613e-07 0 3.4396359591096613e-07 0 3.4397359591096614e-07 0.00021 3.4398359591096615e-07 0 3.440034301648796e-07 0 3.440134301648796e-07 0.00021 3.440234301648796e-07 0 3.440234301648796e-07 0 3.440334301648796e-07 0.00021 3.440434301648796e-07 0 3.440736737958453e-07 0 3.440836737958453e-07 0.00021 3.440936737958453e-07 0 3.4409752278130915e-07 0 3.4410752278130916e-07 0.00021 3.4411752278130917e-07 0 3.4412650695667504e-07 0 3.4413650695667505e-07 0.00021 3.4414650695667506e-07 0 3.4414650695667506e-07 0 3.4415650695667507e-07 0.00021 3.441665069566751e-07 0 3.441665069566751e-07 0 3.441765069566751e-07 0.00021 3.441865069566751e-07 0 3.441865069566751e-07 0 3.441965069566751e-07 0.00021 3.4420650695667513e-07 0 3.4420650695667513e-07 0 3.4421650695667514e-07 0.00021 3.4422650695667515e-07 0 3.4422650695667515e-07 0 3.4423650695667516e-07 0.00021 3.442465069566752e-07 0 3.442465069566752e-07 0 3.442565069566752e-07 0.00021 3.442665069566752e-07 0 3.444044087773847e-07 0 3.444144087773847e-07 0.00021 3.444244087773847e-07 0 3.444244087773847e-07 0 3.4443440877738473e-07 0.00021 3.4444440877738474e-07 0 3.4444440877738474e-07 0 3.4445440877738476e-07 0.00021 3.4446440877738477e-07 0 3.446657927918694e-07 0 3.446757927918694e-07 0.00021 3.4468579279186943e-07 0 3.4468579279186943e-07 0 3.4469579279186944e-07 0.00021 3.4470579279186945e-07 0 3.4470579279186945e-07 0 3.4471579279186946e-07 0.00021 3.447257927918695e-07 0 3.448118447788368e-07 0 3.448218447788368e-07 0.00021 3.448318447788368e-07 0 3.448318447788368e-07 0 3.448418447788368e-07 0.00021 3.4485184477883683e-07 0 3.448628905448428e-07 0 3.448728905448428e-07 0.00021 3.4488289054484283e-07 0 3.4488289054484283e-07 0 3.4489289054484284e-07 0.00021 3.4490289054484285e-07 0 3.4490289054484285e-07 0 3.4491289054484286e-07 0.00021 3.449228905448429e-07 0 3.44970949158195e-07 0 3.44980949158195e-07 0.00021 3.44990949158195e-07 0 3.44990949158195e-07 0 3.4500094915819503e-07 0.00021 3.4501094915819504e-07 0 3.4501094915819504e-07 0 3.4502094915819505e-07 0.00021 3.4503094915819506e-07 0 3.4503094915819506e-07 0 3.450409491581951e-07 0.00021 3.450509491581951e-07 0 3.4508501855824115e-07 0 3.4509501855824116e-07 0.00021 3.4510501855824117e-07 0 3.4510501855824117e-07 0 3.451150185582412e-07 0.00021 3.451250185582412e-07 0 3.451250185582412e-07 0 3.451350185582412e-07 0.00021 3.451450185582412e-07 0 3.451450185582412e-07 0 3.4515501855824123e-07 0.00021 3.4516501855824124e-07 0 3.4516501855824124e-07 0 3.4517501855824125e-07 0.00021 3.4518501855824126e-07 0 3.4518501855824126e-07 0 3.4519501855824127e-07 0.00021 3.452050185582413e-07 0 3.4522365588360025e-07 0 3.4523365588360026e-07 0.00021 3.4524365588360027e-07 0 3.4524365588360027e-07 0 3.452536558836003e-07 0.00021 3.452636558836003e-07 0 3.452636558836003e-07 0 3.452736558836003e-07 0.00021 3.452836558836003e-07 0 3.452836558836003e-07 0 3.452936558836003e-07 0.00021 3.4530365588360034e-07 0 3.4530365588360034e-07 0 3.4531365588360035e-07 0.00021 3.4532365588360036e-07 0 3.4532365588360036e-07 0 3.4533365588360037e-07 0.00021 3.453436558836004e-07 0 3.4536322495615563e-07 0 3.4537322495615564e-07 0.00021 3.4538322495615565e-07 0 3.45393329860392e-07 0 3.45403329860392e-07 0.00021 3.45413329860392e-07 0 3.45413329860392e-07 0 3.45423329860392e-07 0.00021 3.4543332986039203e-07 0 3.4543332986039203e-07 0 3.4544332986039204e-07 0.00021 3.4545332986039205e-07 0 3.4545332986039205e-07 0 3.4546332986039206e-07 0.00021 3.454733298603921e-07 0 3.4554187691473977e-07 0 3.455518769147398e-07 0.00021 3.455618769147398e-07 0 3.455618769147398e-07 0 3.455718769147398e-07 0.00021 3.455818769147398e-07 0 3.455818769147398e-07 0 3.4559187691473983e-07 0.00021 3.4560187691473984e-07 0 3.4560187691473984e-07 0 3.4561187691473985e-07 0.00021 3.4562187691473986e-07 0 3.4562187691473986e-07 0 3.4563187691473987e-07 0.00021 3.456418769147399e-07 0 3.456418769147399e-07 0 3.456518769147399e-07 0.00021 3.456618769147399e-07 0 3.456618769147399e-07 0 3.456718769147399e-07 0.00021 3.4568187691473993e-07 0 3.4569512733198306e-07 0 3.4570512733198307e-07 0.00021 3.457151273319831e-07 0 3.4577792078028716e-07 0 3.457879207802872e-07 0.00021 3.457979207802872e-07 0 3.458377380850462e-07 0 3.4584773808504623e-07 0.00021 3.4585773808504624e-07 0 3.4592947900700003e-07 0 3.4593947900700004e-07 0.00021 3.4594947900700005e-07 0 3.4594947900700005e-07 0 3.4595947900700006e-07 0.00021 3.459694790070001e-07 0 3.4600779222853785e-07 0 3.4601779222853786e-07 0.00021 3.4602779222853787e-07 0 3.4606968750886516e-07 0 3.4607968750886517e-07 0.00021 3.460896875088652e-07 0 3.460896875088652e-07 0 3.460996875088652e-07 0.00021 3.461096875088652e-07 0 3.461096875088652e-07 0 3.461196875088652e-07 0.00021 3.4612968750886523e-07 0 3.4622534526424326e-07 0 3.4623534526424327e-07 0.00021 3.462453452642433e-07 0 3.462453452642433e-07 0 3.462553452642433e-07 0.00021 3.462653452642433e-07 0 3.462653452642433e-07 0 3.462753452642433e-07 0.00021 3.462853452642433e-07 0 3.462853452642433e-07 0 3.4629534526424334e-07 0.00021 3.4630534526424335e-07 0 3.4630534526424335e-07 0 3.4631534526424336e-07 0.00021 3.4632534526424337e-07 0 3.463405338552085e-07 0 3.463505338552085e-07 0.00021 3.463605338552085e-07 0 3.4639223134822436e-07 0 3.464022313482244e-07 0.00021 3.464122313482244e-07 0 3.464122313482244e-07 0 3.464222313482244e-07 0.00021 3.464322313482244e-07 0 3.464322313482244e-07 0 3.464422313482244e-07 0.00021 3.4645223134822443e-07 0 3.4645223134822443e-07 0 3.4646223134822444e-07 0.00021 3.4647223134822445e-07 0 3.4647223134822445e-07 0 3.4648223134822447e-07 0.00021 3.464922313482245e-07 0 3.4655932127385345e-07 0 3.4656932127385347e-07 0.00021 3.465793212738535e-07 0 3.4662793473553233e-07 0 3.4663793473553234e-07 0.00021 3.4664793473553236e-07 0 3.466611883743257e-07 0 3.466711883743257e-07 0.00021 3.466811883743257e-07 0 3.466811883743257e-07 0 3.4669118837432573e-07 0.00021 3.4670118837432575e-07 0 3.4670118837432575e-07 0 3.4671118837432576e-07 0.00021 3.4672118837432577e-07 0 3.4672118837432577e-07 0 3.467311883743258e-07 0.00021 3.467411883743258e-07 0 3.467541981672447e-07 0 3.467641981672447e-07 0.00021 3.467741981672447e-07 0 3.467741981672447e-07 0 3.467841981672447e-07 0.00021 3.4679419816724473e-07 0 3.4679419816724473e-07 0 3.4680419816724474e-07 0.00021 3.4681419816724475e-07 0 3.4682631818486534e-07 0 3.4683631818486535e-07 0.00021 3.4684631818486536e-07 0 3.4684631818486536e-07 0 3.4685631818486537e-07 0.00021 3.468663181848654e-07 0 3.468800694913046e-07 0 3.468900694913046e-07 0.00021 3.4690006949130463e-07 0 3.469024208017214e-07 0 3.469124208017214e-07 0.00021 3.469224208017214e-07 0 3.469588603473006e-07 0 3.469688603473006e-07 0.00021 3.469788603473006e-07 0 3.469830504956229e-07 0 3.469930504956229e-07 0.00021 3.4700305049562293e-07 0 3.4700305049562293e-07 0 3.4701305049562294e-07 0.00021 3.4702305049562295e-07 0 3.4702305049562295e-07 0 3.4703305049562296e-07 0.00021 3.47043050495623e-07 0 3.47043050495623e-07 0 3.47053050495623e-07 0.00021 3.47063050495623e-07 0 3.47063050495623e-07 0 3.47073050495623e-07 0.00021 3.47083050495623e-07 0 3.47083050495623e-07 0 3.4709305049562303e-07 0.00021 3.4710305049562304e-07 0 3.471418296376664e-07 0 3.471518296376664e-07 0.00021 3.471618296376664e-07 0 3.471781092601429e-07 0 3.471881092601429e-07 0.00021 3.4719810926014294e-07 0 3.472159135383223e-07 0 3.4722591353832233e-07 0.00021 3.4723591353832234e-07 0 3.4723591353832234e-07 0 3.4724591353832235e-07 0.00021 3.4725591353832236e-07 0 3.4725591353832236e-07 0 3.472659135383224e-07 0.00021 3.472759135383224e-07 0 3.472759135383224e-07 0 3.472859135383224e-07 0.00021 3.472959135383224e-07 0 3.472959135383224e-07 0 3.473059135383224e-07 0.00021 3.4731591353832243e-07 0 3.4731591353832243e-07 0 3.4732591353832244e-07 0.00021 3.4733591353832246e-07 0 3.4733591353832246e-07 0 3.4734591353832247e-07 0.00021 3.473559135383225e-07 0 3.473559135383225e-07 0 3.473659135383225e-07 0.00021 3.473759135383225e-07 0 3.4738967861314374e-07 0 3.4739967861314375e-07 0.00021 3.4740967861314376e-07 0 3.4745297099073445e-07 0 3.4746297099073446e-07 0.00021 3.4747297099073447e-07 0 3.474965502038727e-07 0 3.4750655020387273e-07 0.00021 3.4751655020387274e-07 0 3.4751655020387274e-07 0 3.4752655020387275e-07 0.00021 3.4753655020387276e-07 0 3.4753655020387276e-07 0 3.475465502038728e-07 0.00021 3.475565502038728e-07 0 3.475565502038728e-07 0 3.475665502038728e-07 0.00021 3.475765502038728e-07 0 3.475765502038728e-07 0 3.475865502038728e-07 0.00021 3.4759655020387283e-07 0 3.4759655020387283e-07 0 3.4760655020387284e-07 0.00021 3.4761655020387285e-07 0 3.4766639023134473e-07 0 3.4767639023134474e-07 0.00021 3.4768639023134475e-07 0 3.4769644922322755e-07 0 3.4770644922322756e-07 0.00021 3.4771644922322757e-07 0 3.47752622694149e-07 0 3.47762622694149e-07 0.00021 3.4777262269414904e-07 0 3.4781194508238444e-07 0 3.4782194508238445e-07 0.00021 3.4783194508238446e-07 0 3.478527420602545e-07 0 3.478627420602545e-07 0.00021 3.4787274206025453e-07 0 3.4787274206025453e-07 0 3.4788274206025455e-07 0.00021 3.4789274206025456e-07 0 3.4789274206025456e-07 0 3.4790274206025457e-07 0.00021 3.479127420602546e-07 0 3.479127420602546e-07 0 3.479227420602546e-07 0.00021 3.479327420602546e-07 0 3.4807737072795046e-07 0 3.4808737072795047e-07 0.00021 3.480973707279505e-07 0 3.481938250911722e-07 0 3.482038250911722e-07 0.00021 3.482138250911722e-07 0 3.482138250911722e-07 0 3.4822382509117223e-07 0.00021 3.4823382509117224e-07 0 3.4823382509117224e-07 0 3.4824382509117225e-07 0.00021 3.4825382509117226e-07 0 3.4825382509117226e-07 0 3.4826382509117227e-07 0.00021 3.482738250911723e-07 0 3.482738250911723e-07 0 3.482838250911723e-07 0.00021 3.482938250911723e-07 0 3.48375771189998e-07 0 3.4838577118999804e-07 0.00021 3.4839577118999805e-07 0 3.4839577118999805e-07 0 3.4840577118999806e-07 0.00021 3.4841577118999807e-07 0 3.484382087821707e-07 0 3.484482087821707e-07 0.00021 3.484582087821707e-07 0 3.484582087821707e-07 0 3.484682087821707e-07 0.00021 3.4847820878217073e-07 0 3.4847820878217073e-07 0 3.4848820878217074e-07 0.00021 3.4849820878217075e-07 0 3.4852545914069154e-07 0 3.4853545914069155e-07 0.00021 3.4854545914069156e-07 0 3.485494182262648e-07 0 3.485594182262648e-07 0.00021 3.485694182262648e-07 0 3.487074709120074e-07 0 3.487174709120074e-07 0.00021 3.487274709120074e-07 0 3.488198630648639e-07 0 3.488298630648639e-07 0.00021 3.488398630648639e-07 0 3.488398630648639e-07 0 3.488498630648639e-07 0.00021 3.488598630648639e-07 0 3.488598630648639e-07 0 3.4886986306486394e-07 0.00021 3.4887986306486395e-07 0 3.4887986306486395e-07 0 3.4888986306486396e-07 0.00021 3.4889986306486397e-07 0 3.4889986306486397e-07 0 3.48909863064864e-07 0.00021 3.48919863064864e-07 0 3.4894569881012277e-07 0 3.489556988101228e-07 0.00021 3.489656988101228e-07 0 3.4898055757514877e-07 0 3.489905575751488e-07 0.00021 3.490005575751488e-07 0 3.490326526539902e-07 0 3.490426526539902e-07 0.00021 3.490526526539902e-07 0 3.4927720121802064e-07 0 3.4928720121802065e-07 0.00021 3.4929720121802066e-07 0 3.4929720121802066e-07 0 3.493072012180207e-07 0.00021 3.493172012180207e-07 0 3.493172012180207e-07 0 3.493272012180207e-07 0.00021 3.493372012180207e-07 0 3.493809427673883e-07 0 3.493909427673883e-07 0.00021 3.494009427673883e-07 0 3.494009427673883e-07 0 3.494109427673883e-07 0.00021 3.4942094276738834e-07 0 3.4946323313261125e-07 0 3.4947323313261126e-07 0.00021 3.4948323313261127e-07 0 3.495344561398335e-07 0 3.495444561398335e-07 0.00021 3.495544561398335e-07 0 3.495635135596464e-07 0 3.4957351355964643e-07 0.00021 3.4958351355964644e-07 0 3.496019583583426e-07 0 3.496119583583426e-07 0.00021 3.496219583583426e-07 0 3.496219583583426e-07 0 3.4963195835834263e-07 0.00021 3.4964195835834264e-07 0 3.4964195835834264e-07 0 3.4965195835834265e-07 0.00021 3.4966195835834267e-07 0 3.4969096105301293e-07 0 3.4970096105301294e-07 0.00021 3.4971096105301295e-07 0 3.4972501063131933e-07 0 3.4973501063131934e-07 0.00021 3.4974501063131935e-07 0 3.4974501063131935e-07 0 3.4975501063131937e-07 0.00021 3.497650106313194e-07 0 3.497650106313194e-07 0 3.497750106313194e-07 0.00021 3.497850106313194e-07 0 3.497850106313194e-07 0 3.497950106313194e-07 0.00021 3.498050106313194e-07 0 3.498050106313194e-07 0 3.4981501063131943e-07 0.00021 3.4982501063131944e-07 0 3.4982501063131944e-07 0 3.4983501063131946e-07 0.00021 3.4984501063131947e-07 0 3.4984501063131947e-07 0 3.498550106313195e-07 0.00021 3.498650106313195e-07 0 3.498650106313195e-07 0 3.498750106313195e-07 0.00021 3.498850106313195e-07 0 3.498850106313195e-07 0 3.498950106313195e-07 0.00021 3.4990501063131954e-07 0 3.4990501063131954e-07 0 3.4991501063131955e-07 0.00021 3.4992501063131956e-07 0 3.4992501063131956e-07 0 3.4993501063131957e-07 0.00021 3.499450106313196e-07 0 3.499450106313196e-07 0 3.499550106313196e-07 0.00021 3.499650106313196e-07 0 3.499650106313196e-07 0 3.499750106313196e-07 0.00021 3.499850106313196e-07 0 3.499850106313196e-07 0 3.4999501063131964e-07 0.00021 3.5000501063131965e-07 0 3.5000501063131965e-07 0 3.5001501063131966e-07 0.00021 3.5002501063131967e-07 0 3.5002501063131967e-07 0 3.500350106313197e-07 0.00021 3.500450106313197e-07 0 3.500450106313197e-07 0 3.500550106313197e-07 0.00021 3.500650106313197e-07 0 3.500650106313197e-07 0 3.5007501063131973e-07 0.00021 3.5008501063131974e-07 0 3.5008501063131974e-07 0 3.5009501063131975e-07 0.00021 3.5010501063131976e-07 0 3.5010501063131976e-07 0 3.5011501063131977e-07 0.00021 3.501250106313198e-07 0 3.501250106313198e-07 0 3.501350106313198e-07 0.00021 3.501450106313198e-07 0 3.501450106313198e-07 0 3.501550106313198e-07 0.00021 3.5016501063131983e-07 0 3.5016501063131983e-07 0 3.5017501063131984e-07 0.00021 3.5018501063131985e-07 0 3.5018501063131985e-07 0 3.5019501063131986e-07 0.00021 3.502050106313199e-07 0 3.502050106313199e-07 0 3.502150106313199e-07 0.00021 3.502250106313199e-07 0 3.502250106313199e-07 0 3.502350106313199e-07 0.00021 3.502450106313199e-07 0 3.502450106313199e-07 0 3.5025501063131993e-07 0.00021 3.5026501063131994e-07 0 3.5026501063131994e-07 0 3.5027501063131995e-07 0.00021 3.5028501063131997e-07 0 3.5028501063131997e-07 0 3.5029501063132e-07 0.00021 3.5030501063132e-07 0 3.5030501063132e-07 0 3.5031501063132e-07 0.00021 3.5032501063132e-07 0 3.5032501063132e-07 0 3.5033501063132e-07 0.00021 3.5034501063132003e-07 0 3.5040726700658215e-07 0 3.5041726700658216e-07 0.00021 3.5042726700658217e-07 0 3.5043765237147235e-07 0 3.5044765237147236e-07 0.00021 3.5045765237147237e-07 0 3.5045765237147237e-07 0 3.504676523714724e-07 0.00021 3.504776523714724e-07 0 3.505080612944299e-07 0 3.505180612944299e-07 0.00021 3.5052806129442993e-07 0 3.505759352500139e-07 0 3.505859352500139e-07 0.00021 3.505959352500139e-07 0 3.505959352500139e-07 0 3.506059352500139e-07 0.00021 3.506159352500139e-07 0 3.506159352500139e-07 0 3.5062593525001393e-07 0.00021 3.5063593525001394e-07 0 3.5063593525001394e-07 0 3.5064593525001395e-07 0.00021 3.5065593525001397e-07 0 3.506618737363606e-07 0 3.506718737363606e-07 0.00021 3.506818737363606e-07 0 3.507293660491311e-07 0 3.507393660491311e-07 0.00021 3.507493660491311e-07 0 3.507493660491311e-07 0 3.507593660491311e-07 0.00021 3.5076936604913113e-07 0 3.5076936604913113e-07 0 3.5077936604913114e-07 0.00021 3.5078936604913115e-07 0 3.5078936604913115e-07 0 3.5079936604913116e-07 0.00021 3.5080936604913117e-07 0 3.5080936604913117e-07 0 3.508193660491312e-07 0.00021 3.508293660491312e-07 0 3.508293660491312e-07 0 3.508393660491312e-07 0.00021 3.508493660491312e-07 0 3.508493660491312e-07 0 3.5085936604913123e-07 0.00021 3.5086936604913124e-07 0 3.5086936604913124e-07 0 3.5087936604913125e-07 0.00021 3.5088936604913126e-07 0 3.5088936604913126e-07 0 3.508993660491313e-07 0.00021 3.509093660491313e-07 0 3.509093660491313e-07 0 3.509193660491313e-07 0.00021 3.509293660491313e-07 0 3.509293660491313e-07 0 3.509393660491313e-07 0.00021 3.5094936604913133e-07 0 3.5094936604913133e-07 0 3.5095936604913134e-07 0.00021 3.5096936604913135e-07 0 3.5096936604913135e-07 0 3.5097936604913137e-07 0.00021 3.509893660491314e-07 0 3.509893660491314e-07 0 3.509993660491314e-07 0.00021 3.510093660491314e-07 0 3.510093660491314e-07 0 3.510193660491314e-07 0.00021 3.510293660491314e-07 0 3.510293660491314e-07 0 3.5103936604913143e-07 0.00021 3.5104936604913144e-07 0 3.5107057547352583e-07 0 3.5108057547352584e-07 0.00021 3.5109057547352585e-07 0 3.5109057547352585e-07 0 3.5110057547352586e-07 0.00021 3.511105754735259e-07 0 3.511105754735259e-07 0 3.511205754735259e-07 0.00021 3.511305754735259e-07 0 3.511305754735259e-07 0 3.511405754735259e-07 0.00021 3.511505754735259e-07 0 3.511604686459343e-07 0 3.511704686459343e-07 0.00021 3.511804686459343e-07 0 3.5119173498143855e-07 0 3.5120173498143856e-07 0.00021 3.5121173498143857e-07 0 3.5121441437019427e-07 0 3.512244143701943e-07 0.00021 3.512344143701943e-07 0 3.5128768072533064e-07 0 3.5129768072533065e-07 0.00021 3.5130768072533066e-07 0 3.5130768072533066e-07 0 3.5131768072533067e-07 0.00021 3.513276807253307e-07 0 3.513276807253307e-07 0 3.513376807253307e-07 0.00021 3.513476807253307e-07 0 3.5136573768350545e-07 0 3.5137573768350546e-07 0.00021 3.513857376835055e-07 0 3.5143584205691387e-07 0 3.514458420569139e-07 0.00021 3.514558420569139e-07 0 3.5146468054071283e-07 0 3.5147468054071285e-07 0.00021 3.5148468054071286e-07 0 3.515013467161457e-07 0 3.515113467161457e-07 0.00021 3.5152134671614574e-07 0 3.515634545385341e-07 0 3.515734545385341e-07 0.00021 3.5158345453853414e-07 0 3.5158345453853414e-07 0 3.5159345453853415e-07 0.00021 3.5160345453853416e-07 0 3.5166654453024626e-07 0 3.5167654453024627e-07 0.00021 3.516865445302463e-07 0 3.517504757915354e-07 0 3.517604757915354e-07 0.00021 3.517704757915354e-07 0 3.517704757915354e-07 0 3.517804757915354e-07 0.00021 3.5179047579153543e-07 0 3.5180692166143233e-07 0 3.5181692166143234e-07 0.00021 3.5182692166143235e-07 0 3.518317171598542e-07 0 3.518417171598542e-07 0.00021 3.5185171715985423e-07 0 3.5187671207281835e-07 0 3.5188671207281836e-07 0.00021 3.5189671207281837e-07 0 3.520147358750574e-07 0 3.520247358750574e-07 0.00021 3.5203473587505744e-07 0 3.5203473587505744e-07 0 3.5204473587505745e-07 0.00021 3.5205473587505746e-07 0 3.520578461664017e-07 0 3.520678461664017e-07 0.00021 3.520778461664017e-07 0 3.521298089249512e-07 0 3.521398089249512e-07 0.00021 3.521498089249512e-07 0 3.52213783559189e-07 0 3.52223783559189e-07 0.00021 3.52233783559189e-07 0 3.523280606653376e-07 0 3.523380606653376e-07 0.00021 3.523480606653376e-07 0 3.523480606653376e-07 0 3.523580606653376e-07 0.00021 3.5236806066533763e-07 0 3.524517192762805e-07 0 3.524617192762805e-07 0.00021 3.524717192762805e-07 0 3.524717192762805e-07 0 3.5248171927628053e-07 0.00021 3.5249171927628054e-07 0 3.524951283902637e-07 0 3.525051283902637e-07 0.00021 3.525151283902637e-07 0 3.5260854410730467e-07 0 3.526185441073047e-07 0.00021 3.526285441073047e-07 0 3.526285441073047e-07 0 3.526385441073047e-07 0.00021 3.526485441073047e-07 0 3.526485441073047e-07 0 3.526585441073047e-07 0.00021 3.5266854410730473e-07 0 3.526770472346971e-07 0 3.526870472346971e-07 0.00021 3.526970472346971e-07 0 3.527059886939815e-07 0 3.527159886939815e-07 0.00021 3.527259886939815e-07 0 3.527440371878092e-07 0 3.527540371878092e-07 0.00021 3.527640371878092e-07 0 3.527640371878092e-07 0 3.527740371878092e-07 0.00021 3.527840371878092e-07 0 3.527840371878092e-07 0 3.5279403718780923e-07 0.00021 3.5280403718780924e-07 0 3.5280403718780924e-07 0 3.5281403718780925e-07 0.00021 3.5282403718780927e-07 0 3.5282403718780927e-07 0 3.528340371878093e-07 0.00021 3.528440371878093e-07 0 3.528657674870077e-07 0 3.528757674870077e-07 0.00021 3.528857674870077e-07 0 3.529029938399189e-07 0 3.5291299383991894e-07 0.00021 3.5292299383991895e-07 0 3.5292299383991895e-07 0 3.5293299383991896e-07 0.00021 3.5294299383991897e-07 0 3.5294299383991897e-07 0 3.52952993839919e-07 0.00021 3.52962993839919e-07 0 3.52962993839919e-07 0 3.52972993839919e-07 0.00021 3.52982993839919e-07 0 3.52982993839919e-07 0 3.52992993839919e-07 0.00021 3.5300299383991904e-07 0 3.5300299383991904e-07 0 3.5301299383991905e-07 0.00021 3.5302299383991906e-07 0 3.5302299383991906e-07 0 3.5303299383991907e-07 0.00021 3.530429938399191e-07 0 3.530429938399191e-07 0 3.530529938399191e-07 0.00021 3.530629938399191e-07 0 3.530629938399191e-07 0 3.530729938399191e-07 0.00021 3.5308299383991913e-07 0 3.5308299383991913e-07 0 3.5309299383991914e-07 0.00021 3.5310299383991915e-07 0 3.5310299383991915e-07 0 3.5311299383991916e-07 0.00021 3.5312299383991917e-07 0 3.5312299383991917e-07 0 3.531329938399192e-07 0.00021 3.531429938399192e-07 0 3.531429938399192e-07 0 3.531529938399192e-07 0.00021 3.531629938399192e-07 0 3.531629938399192e-07 0 3.5317299383991923e-07 0.00021 3.5318299383991924e-07 0 3.5318299383991924e-07 0 3.5319299383991925e-07 0.00021 3.5320299383991926e-07 0 3.5320299383991926e-07 0 3.532129938399193e-07 0.00021 3.532229938399193e-07 0 3.532229938399193e-07 0 3.532329938399193e-07 0.00021 3.532429938399193e-07 0 3.532429938399193e-07 0 3.532529938399193e-07 0.00021 3.5326299383991933e-07 0 3.5326886870335923e-07 0 3.5327886870335924e-07 0.00021 3.5328886870335925e-07 0 3.5328886870335925e-07 0 3.5329886870335926e-07 0.00021 3.5330886870335927e-07 0 3.5330886870335927e-07 0 3.533188687033593e-07 0.00021 3.533288687033593e-07 0 3.533360762092231e-07 0 3.533460762092231e-07 0.00021 3.533560762092231e-07 0 3.533560762092231e-07 0 3.533660762092231e-07 0.00021 3.5337607620922313e-07 0 3.5337607620922313e-07 0 3.5338607620922314e-07 0.00021 3.5339607620922315e-07 0 3.5339607620922315e-07 0 3.5340607620922317e-07 0.00021 3.534160762092232e-07 0 3.534160762092232e-07 0 3.534260762092232e-07 0.00021 3.534360762092232e-07 0 3.534360762092232e-07 0 3.534460762092232e-07 0.00021 3.534560762092232e-07 0 3.5348447006712935e-07 0 3.5349447006712936e-07 0.00021 3.5350447006712937e-07 0 3.5351661043995224e-07 0 3.5352661043995225e-07 0.00021 3.5353661043995226e-07 0 3.5353661043995226e-07 0 3.5354661043995227e-07 0.00021 3.535566104399523e-07 0 3.535566104399523e-07 0 3.535666104399523e-07 0.00021 3.535766104399523e-07 0 3.5365257307406526e-07 0 3.5366257307406527e-07 0.00021 3.536725730740653e-07 0 3.536725730740653e-07 0 3.536825730740653e-07 0.00021 3.536925730740653e-07 0 3.536925730740653e-07 0 3.537025730740653e-07 0.00021 3.5371257307406533e-07 0 3.5371257307406533e-07 0 3.5372257307406534e-07 0.00021 3.5373257307406535e-07 0 3.5373257307406535e-07 0 3.5374257307406536e-07 0.00021 3.5375257307406537e-07 0 3.5375257307406537e-07 0 3.537625730740654e-07 0.00021 3.537725730740654e-07 0 3.537725730740654e-07 0 3.537825730740654e-07 0.00021 3.537925730740654e-07 0 3.537925730740654e-07 0 3.5380257307406543e-07 0.00021 3.5381257307406544e-07 0 3.5381257307406544e-07 0 3.5382257307406545e-07 0.00021 3.5383257307406546e-07 0 3.538459957994944e-07 0 3.538559957994944e-07 0.00021 3.538659957994944e-07 0 3.539059717660155e-07 0 3.539159717660155e-07 0.00021 3.539259717660155e-07 0 3.5405325487597926e-07 0 3.5406325487597927e-07 0.00021 3.540732548759793e-07 0 3.540819349463706e-07 0 3.5409193494637063e-07 0.00021 3.5410193494637064e-07 0 3.5424078757662887e-07 0 3.542507875766289e-07 0.00021 3.542607875766289e-07 0 3.5426263877928226e-07 0 3.5427263877928227e-07 0.00021 3.542826387792823e-07 0 3.542826387792823e-07 0 3.542926387792823e-07 0.00021 3.543026387792823e-07 0 3.544201009359389e-07 0 3.544301009359389e-07 0.00021 3.5444010093593894e-07 0 3.544478890358815e-07 0 3.544578890358815e-07 0.00021 3.544678890358815e-07 0 3.544678890358815e-07 0 3.5447788903588153e-07 0.00021 3.5448788903588155e-07 0 3.545149459688281e-07 0 3.545249459688281e-07 0.00021 3.545349459688281e-07 0 3.545349459688281e-07 0 3.545449459688281e-07 0.00021 3.5455494596882813e-07 0 3.545661645196132e-07 0 3.545761645196132e-07 0.00021 3.545861645196132e-07 0 3.546133613759877e-07 0 3.546233613759877e-07 0.00021 3.546333613759877e-07 0 3.546333613759877e-07 0 3.5464336137598773e-07 0.00021 3.5465336137598774e-07 0 3.5465336137598774e-07 0 3.5466336137598775e-07 0.00021 3.5467336137598776e-07 0 3.547296605478652e-07 0 3.547396605478652e-07 0.00021 3.547496605478652e-07 0 3.547568316024387e-07 0 3.547668316024387e-07 0.00021 3.5477683160243873e-07 0 3.548027086853021e-07 0 3.5481270868530213e-07 0.00021 3.5482270868530214e-07 0 3.5482270868530214e-07 0 3.5483270868530216e-07 0.00021 3.5484270868530217e-07 0 3.5484270868530217e-07 0 3.548527086853022e-07 0.00021 3.548627086853022e-07 0 3.548627086853022e-07 0 3.548727086853022e-07 0.00021 3.548827086853022e-07 0 3.548827086853022e-07 0 3.548927086853022e-07 0.00021 3.5490270868530223e-07 0 3.5495643972017737e-07 0 3.549664397201774e-07 0.00021 3.549764397201774e-07 0 3.549764397201774e-07 0 3.549864397201774e-07 0.00021 3.549964397201774e-07 0 3.5509267541017645e-07 0 3.5510267541017646e-07 0.00021 3.5511267541017647e-07 0 3.5511267541017647e-07 0 3.551226754101765e-07 0.00021 3.551326754101765e-07 0 3.551510647494955e-07 0 3.551610647494955e-07 0.00021 3.5517106474949553e-07 0 3.5517106474949553e-07 0 3.5518106474949554e-07 0.00021 3.5519106474949556e-07 0 3.5519692132661665e-07 0 3.5520692132661666e-07 0.00021 3.552169213266167e-07 0 3.552169213266167e-07 0 3.552269213266167e-07 0.00021 3.552369213266167e-07 0 3.552568625019442e-07 0 3.5526686250194424e-07 0.00021 3.5527686250194425e-07 0 3.5527686250194425e-07 0 3.5528686250194426e-07 0.00021 3.5529686250194427e-07 0 3.5531516642813394e-07 0 3.5532516642813395e-07 0.00021 3.5533516642813396e-07 0 3.5537584524831926e-07 0 3.5538584524831927e-07 0.00021 3.553958452483193e-07 0 3.553958452483193e-07 0 3.554058452483193e-07 0.00021 3.554158452483193e-07 0 3.554252304741444e-07 0 3.554352304741444e-07 0.00021 3.554452304741444e-07 0 3.554452304741444e-07 0 3.554552304741444e-07 0.00021 3.5546523047414443e-07 0 3.5546523047414443e-07 0 3.5547523047414444e-07 0.00021 3.5548523047414445e-07 0 3.5548523047414445e-07 0 3.5549523047414446e-07 0.00021 3.5550523047414447e-07 0 3.5550523047414447e-07 0 3.555152304741445e-07 0.00021 3.555252304741445e-07 0 3.555252304741445e-07 0 3.555352304741445e-07 0.00021 3.555452304741445e-07 0 3.555452304741445e-07 0 3.5555523047414453e-07 0.00021 3.5556523047414454e-07 0 3.5556523047414454e-07 0 3.5557523047414455e-07 0.00021 3.5558523047414456e-07 0 3.5558523047414456e-07 0 3.555952304741446e-07 0.00021 3.556052304741446e-07 0 3.5560798208481164e-07 0 3.5561798208481165e-07 0.00021 3.5562798208481166e-07 0 3.5562798208481166e-07 0 3.556379820848117e-07 0.00021 3.556479820848117e-07 0 3.556479820848117e-07 0 3.556579820848117e-07 0.00021 3.556679820848117e-07 0 3.556679820848117e-07 0 3.556779820848117e-07 0.00021 3.5568798208481173e-07 0 3.5568798208481173e-07 0 3.5569798208481174e-07 0.00021 3.5570798208481175e-07 0 3.5570798208481175e-07 0 3.5571798208481176e-07 0.00021 3.557279820848118e-07 0 3.557279820848118e-07 0 3.557379820848118e-07 0.00021 3.557479820848118e-07 0 3.557479820848118e-07 0 3.557579820848118e-07 0.00021 3.557679820848118e-07 0 3.557679820848118e-07 0 3.5577798208481183e-07 0.00021 3.5578798208481184e-07 0 3.5578798208481184e-07 0 3.5579798208481186e-07 0.00021 3.5580798208481187e-07 0 3.5580798208481187e-07 0 3.558179820848119e-07 0.00021 3.558279820848119e-07 0 3.558279820848119e-07 0 3.558379820848119e-07 0.00021 3.558479820848119e-07 0 3.558479820848119e-07 0 3.558579820848119e-07 0.00021 3.5586798208481193e-07 0 3.5586798208481193e-07 0 3.5587798208481195e-07 0.00021 3.5588798208481196e-07 0 3.5588798208481196e-07 0 3.5589798208481197e-07 0.00021 3.55907982084812e-07 0 3.55907982084812e-07 0 3.55917982084812e-07 0.00021 3.55927982084812e-07 0 3.55927982084812e-07 0 3.55937982084812e-07 0.00021 3.55947982084812e-07 0 3.55947982084812e-07 0 3.5595798208481204e-07 0.00021 3.5596798208481205e-07 0 3.5596798208481205e-07 0 3.5597798208481206e-07 0.00021 3.5598798208481207e-07 0 3.559901753128682e-07 0 3.560001753128682e-07 0.00021 3.560101753128682e-07 0 3.5605609714176526e-07 0 3.5606609714176527e-07 0.00021 3.560760971417653e-07 0 3.560815127727509e-07 0 3.560915127727509e-07 0.00021 3.561015127727509e-07 0 3.5620003700039414e-07 0 3.5621003700039415e-07 0.00021 3.5622003700039416e-07 0 3.5622003700039416e-07 0 3.5623003700039417e-07 0.00021 3.562400370003942e-07 0 3.5629765710373306e-07 0 3.5630765710373307e-07 0.00021 3.563176571037331e-07 0 3.5634458462576383e-07 0 3.5635458462576384e-07 0.00021 3.5636458462576386e-07 0 3.564037244159965e-07 0 3.564137244159965e-07 0.00021 3.5642372441599654e-07 0 3.5642372441599654e-07 0 3.5643372441599655e-07 0.00021 3.5644372441599656e-07 0 3.5644372441599656e-07 0 3.5645372441599657e-07 0.00021 3.564637244159966e-07 0 3.564637244159966e-07 0 3.564737244159966e-07 0.00021 3.564837244159966e-07 0 3.564837244159966e-07 0 3.564937244159966e-07 0.00021 3.565037244159966e-07 0 3.565037244159966e-07 0 3.5651372441599664e-07 0.00021 3.5652372441599665e-07 0 3.5667268360013774e-07 0 3.5668268360013775e-07 0.00021 3.5669268360013776e-07 0 3.567626856484611e-07 0 3.567726856484611e-07 0.00021 3.567826856484611e-07 0 3.56811888948479e-07 0 3.56821888948479e-07 0.00021 3.5683188894847903e-07 0 3.5683539153588277e-07 0 3.568453915358828e-07 0.00021 3.568553915358828e-07 0 3.568553915358828e-07 0 3.568653915358828e-07 0.00021 3.568753915358828e-07 0 3.568753915358828e-07 0 3.5688539153588283e-07 0.00021 3.5689539153588284e-07 0 3.570187114392945e-07 0 3.570287114392945e-07 0.00021 3.5703871143929454e-07 0 3.570766578999381e-07 0 3.570866578999381e-07 0.00021 3.5709665789993813e-07 0 3.5709665789993813e-07 0 3.5710665789993814e-07 0.00021 3.5711665789993816e-07 0 3.572180515798008e-07 0 3.5722805157980083e-07 0.00021 3.5723805157980084e-07 0 3.5723805157980084e-07 0 3.5724805157980085e-07 0.00021 3.5725805157980086e-07 0 3.5725805157980086e-07 0 3.572680515798009e-07 0.00021 3.572780515798009e-07 0 3.572780515798009e-07 0 3.572880515798009e-07 0.00021 3.572980515798009e-07 0 3.572980515798009e-07 0 3.573080515798009e-07 0.00021 3.5731805157980093e-07 0 3.5731805157980093e-07 0 3.5732805157980094e-07 0.00021 3.5733805157980095e-07 0 3.5733805157980095e-07 0 3.5734805157980097e-07 0.00021 3.57358051579801e-07 0 3.573635084361991e-07 0 3.573735084361991e-07 0.00021 3.573835084361991e-07 0 3.573835084361991e-07 0 3.573935084361991e-07 0.00021 3.5740350843619913e-07 0 3.5740350843619913e-07 0 3.5741350843619914e-07 0.00021 3.5742350843619915e-07 0 3.5742350843619915e-07 0 3.5743350843619916e-07 0.00021 3.574435084361992e-07 0 3.574435084361992e-07 0 3.574535084361992e-07 0.00021 3.574635084361992e-07 0 3.574891273822677e-07 0 3.574991273822677e-07 0.00021 3.575091273822677e-07 0 3.575091273822677e-07 0 3.575191273822677e-07 0.00021 3.575291273822677e-07 0 3.575291273822677e-07 0 3.5753912738226774e-07 0.00021 3.5754912738226775e-07 0 3.575505206756642e-07 0 3.575605206756642e-07 0.00021 3.5757052067566423e-07 0 3.575767901545006e-07 0 3.575867901545006e-07 0.00021 3.5759679015450064e-07 0 3.576042370863142e-07 0 3.576142370863142e-07 0.00021 3.576242370863142e-07 0 3.5764038882022456e-07 0 3.576503888202246e-07 0.00021 3.576603888202246e-07 0 3.5766173708741236e-07 0 3.5767173708741237e-07 0.00021 3.576817370874124e-07 0 3.5770033303968574e-07 0 3.5771033303968575e-07 0.00021 3.5772033303968576e-07 0 3.5772033303968576e-07 0 3.577303330396858e-07 0.00021 3.577403330396858e-07 0 3.577403330396858e-07 0 3.577503330396858e-07 0.00021 3.577603330396858e-07 0 3.577603330396858e-07 0 3.577703330396858e-07 0.00021 3.5778033303968583e-07 0 3.5778033303968583e-07 0 3.5779033303968584e-07 0.00021 3.5780033303968585e-07 0 3.5780033303968585e-07 0 3.5781033303968587e-07 0.00021 3.578203330396859e-07 0 3.578203330396859e-07 0 3.578303330396859e-07 0.00021 3.578403330396859e-07 0 3.578403330396859e-07 0 3.578503330396859e-07 0.00021 3.578603330396859e-07 0 3.578603330396859e-07 0 3.5787033303968593e-07 0.00021 3.5788033303968594e-07 0 3.5788033303968594e-07 0 3.5789033303968596e-07 0.00021 3.5790033303968597e-07 0 3.5790033303968597e-07 0 3.57910333039686e-07 0.00021 3.57920333039686e-07 0 3.57920333039686e-07 0 3.57930333039686e-07 0.00021 3.57940333039686e-07 0 3.57940333039686e-07 0 3.57950333039686e-07 0.00021 3.5796033303968604e-07 0 3.5796033303968604e-07 0 3.5797033303968605e-07 0.00021 3.5798033303968606e-07 0 3.579859298568317e-07 0 3.579959298568317e-07 0.00021 3.580059298568317e-07 0 3.5801019400583593e-07 0 3.5802019400583594e-07 0.00021 3.5803019400583595e-07 0 3.5803019400583595e-07 0 3.5804019400583596e-07 0.00021 3.5805019400583597e-07 0 3.580590923292719e-07 0 3.580690923292719e-07 0.00021 3.580790923292719e-07 0 3.580790923292719e-07 0 3.580890923292719e-07 0.00021 3.5809909232927193e-07 0 3.5809909232927193e-07 0 3.5810909232927195e-07 0.00021 3.5811909232927196e-07 0 3.5811909232927196e-07 0 3.5812909232927197e-07 0.00021 3.58139092329272e-07 0 3.58139092329272e-07 0 3.58149092329272e-07 0.00021 3.58159092329272e-07 0 3.58159092329272e-07 0 3.58169092329272e-07 0.00021 3.58179092329272e-07 0 3.58179092329272e-07 0 3.5818909232927204e-07 0.00021 3.5819909232927205e-07 0 3.5819909232927205e-07 0 3.5820909232927206e-07 0.00021 3.5821909232927207e-07 0 3.582746381831179e-07 0 3.5828463818311793e-07 0.00021 3.5829463818311794e-07 0 3.583017013646918e-07 0 3.583117013646918e-07 0.00021 3.583217013646918e-07 0 3.5834813837774953e-07 0 3.5835813837774955e-07 0.00021 3.5836813837774956e-07 0 3.5836813837774956e-07 0 3.5837813837774957e-07 0.00021 3.583881383777496e-07 0 3.583881383777496e-07 0 3.583981383777496e-07 0.00021 3.584081383777496e-07 0 3.584081383777496e-07 0 3.584181383777496e-07 0.00021 3.584281383777496e-07 0 3.584281383777496e-07 0 3.5843813837774964e-07 0.00021 3.5844813837774965e-07 0 3.5844813837774965e-07 0 3.5845813837774966e-07 0.00021 3.5846813837774967e-07 0 3.5846813837774967e-07 0 3.584781383777497e-07 0.00021 3.584881383777497e-07 0 3.584881383777497e-07 0 3.584981383777497e-07 0.00021 3.585081383777497e-07 0 3.585081383777497e-07 0 3.5851813837774973e-07 0.00021 3.5852813837774974e-07 0 3.5852813837774974e-07 0 3.5853813837774975e-07 0.00021 3.5854813837774976e-07 0 3.585508853437819e-07 0 3.585608853437819e-07 0.00021 3.585708853437819e-07 0 3.586290189386015e-07 0 3.586390189386015e-07 0.00021 3.5864901893860153e-07 0 3.5866429407023557e-07 0 3.586742940702356e-07 0.00021 3.586842940702356e-07 0 3.5874600065671963e-07 0 3.5875600065671964e-07 0.00021 3.5876600065671965e-07 0 3.5876600065671965e-07 0 3.5877600065671966e-07 0.00021 3.5878600065671967e-07 0 3.5878600065671967e-07 0 3.587960006567197e-07 0.00021 3.588060006567197e-07 0 3.5880661320002886e-07 0 3.5881661320002887e-07 0.00021 3.588266132000289e-07 0 3.58838686943141e-07 0 3.58848686943141e-07 0.00021 3.5885868694314103e-07 0 3.5885868694314103e-07 0 3.5886868694314105e-07 0.00021 3.5887868694314106e-07 0 3.588984826764292e-07 0 3.589084826764292e-07 0.00021 3.589184826764292e-07 0 3.589184826764292e-07 0 3.5892848267642923e-07 0.00021 3.5893848267642924e-07 0 3.589719850264314e-07 0 3.589819850264314e-07 0.00021 3.589919850264314e-07 0 3.590369089592942e-07 0 3.5904690895929423e-07 0.00021 3.5905690895929424e-07 0 3.5905690895929424e-07 0 3.5906690895929425e-07 0.00021 3.5907690895929426e-07 0 3.5907690895929426e-07 0 3.590869089592943e-07 0.00021 3.590969089592943e-07 0 3.591041332001133e-07 0 3.5911413320011334e-07 0.00021 3.5912413320011335e-07 0 3.5912413320011335e-07 0 3.5913413320011336e-07 0.00021 3.5914413320011337e-07 0 3.5914413320011337e-07 0 3.591541332001134e-07 0.00021 3.591641332001134e-07 0 3.591641332001134e-07 0 3.591741332001134e-07 0.00021 3.591841332001134e-07 0 3.591841332001134e-07 0 3.591941332001134e-07 0.00021 3.5920413320011344e-07 0 3.5920413320011344e-07 0 3.5921413320011345e-07 0.00021 3.5922413320011346e-07 0 3.592415622448589e-07 0 3.592515622448589e-07 0.00021 3.592615622448589e-07 0 3.5927802463931543e-07 0 3.5928802463931544e-07 0.00021 3.5929802463931545e-07 0 3.5929802463931545e-07 0 3.5930802463931547e-07 0.00021 3.593180246393155e-07 0 3.593180246393155e-07 0 3.593280246393155e-07 0.00021 3.593380246393155e-07 0 3.593380246393155e-07 0 3.593480246393155e-07 0.00021 3.593580246393155e-07 0 3.593580246393155e-07 0 3.5936802463931553e-07 0.00021 3.5937802463931555e-07 0 3.5937802463931555e-07 0 3.5938802463931556e-07 0.00021 3.5939802463931557e-07 0 3.5939802463931557e-07 0 3.594080246393156e-07 0.00021 3.594180246393156e-07 0 3.594574552677189e-07 0 3.594674552677189e-07 0.00021 3.594774552677189e-07 0 3.5949865979096155e-07 0 3.5950865979096156e-07 0.00021 3.595186597909616e-07 0 3.595186597909616e-07 0 3.595286597909616e-07 0.00021 3.595386597909616e-07 0 3.595386597909616e-07 0 3.595486597909616e-07 0.00021 3.595586597909616e-07 0 3.595692388158603e-07 0 3.595792388158603e-07 0.00021 3.5958923881586033e-07 0 3.5965122935466395e-07 0 3.5966122935466396e-07 0.00021 3.5967122935466397e-07 0 3.5973550349057105e-07 0 3.5974550349057106e-07 0.00021 3.597555034905711e-07 0 3.597555034905711e-07 0 3.597655034905711e-07 0.00021 3.597755034905711e-07 0 3.597755034905711e-07 0 3.597855034905711e-07 0.00021 3.597955034905711e-07 0 3.597955034905711e-07 0 3.5980550349057113e-07 0.00021 3.5981550349057114e-07 0 3.5988911574394294e-07 0 3.5989911574394296e-07 0.00021 3.5990911574394297e-07 0 3.599419487497805e-07 0 3.599519487497805e-07 0.00021 3.599619487497805e-07 0 3.599619487497805e-07 0 3.5997194874978053e-07 0.00021 3.5998194874978054e-07 0 3.6000062538529447e-07 0 3.600106253852945e-07 0.00021 3.600206253852945e-07 0 3.600206253852945e-07 0 3.600306253852945e-07 0.00021 3.600406253852945e-07 0 3.600406253852945e-07 0 3.600506253852945e-07 0.00021 3.6006062538529454e-07 0 3.6006062538529454e-07 0 3.6007062538529455e-07 0.00021 3.6008062538529456e-07 0 3.6008062538529456e-07 0 3.6009062538529457e-07 0.00021 3.601006253852946e-07 0 3.601006253852946e-07 0 3.601106253852946e-07 0.00021 3.601206253852946e-07 0 3.601206253852946e-07 0 3.601306253852946e-07 0.00021 3.601406253852946e-07 0 3.601921680750271e-07 0 3.602021680750271e-07 0.00021 3.602121680750271e-07 0 3.602338065785963e-07 0 3.602438065785963e-07 0.00021 3.602538065785963e-07 0 3.602702283148923e-07 0 3.602802283148923e-07 0.00021 3.602902283148923e-07 0 3.602902283148923e-07 0 3.6030022831489233e-07 0.00021 3.6031022831489234e-07 0 3.603319258760729e-07 0 3.603419258760729e-07 0.00021 3.603519258760729e-07 0 3.603519258760729e-07 0 3.603619258760729e-07 0.00021 3.6037192587607293e-07 0 3.6037192587607293e-07 0 3.6038192587607294e-07 0.00021 3.6039192587607295e-07 0 3.6039192587607295e-07 0 3.6040192587607296e-07 0.00021 3.6041192587607297e-07 0 3.6044118661870577e-07 0 3.604511866187058e-07 0.00021 3.604611866187058e-07 0 3.604611866187058e-07 0 3.604711866187058e-07 0.00021 3.604811866187058e-07 0 3.604811866187058e-07 0 3.6049118661870583e-07 0.00021 3.6050118661870584e-07 0 3.6053324189141887e-07 0 3.605432418914189e-07 0.00021 3.605532418914189e-07 0 3.605577451681554e-07 0 3.605677451681554e-07 0.00021 3.605777451681554e-07 0 3.605777451681554e-07 0 3.605877451681554e-07 0.00021 3.6059774516815543e-07 0 3.606073423651733e-07 0 3.606173423651733e-07 0.00021 3.6062734236517333e-07 0 3.606519162395019e-07 0 3.606619162395019e-07 0.00021 3.6067191623950193e-07 0 3.606958294092476e-07 0 3.6070582940924764e-07 0.00021 3.6071582940924765e-07 0 3.6071582940924765e-07 0 3.6072582940924766e-07 0.00021 3.6073582940924767e-07 0 3.6073582940924767e-07 0 3.607458294092477e-07 0.00021 3.607558294092477e-07 0 3.607558294092477e-07 0 3.607658294092477e-07 0.00021 3.607758294092477e-07 0 3.607758294092477e-07 0 3.6078582940924773e-07 0.00021 3.6079582940924774e-07 0 3.6080543543923923e-07 0 3.6081543543923924e-07 0.00021 3.6082543543923925e-07 0 3.6083804574587423e-07 0 3.6084804574587424e-07 0.00021 3.6085804574587426e-07 0 3.6085804574587426e-07 0 3.6086804574587427e-07 0.00021 3.608780457458743e-07 0 3.608780457458743e-07 0 3.608880457458743e-07 0.00021 3.608980457458743e-07 0 3.6090396569401914e-07 0 3.6091396569401915e-07 0.00021 3.6092396569401916e-07 0 3.6092396569401916e-07 0 3.6093396569401917e-07 0.00021 3.609439656940192e-07 0 3.609439656940192e-07 0 3.609539656940192e-07 0.00021 3.609639656940192e-07 0 3.609639656940192e-07 0 3.609739656940192e-07 0.00021 3.6098396569401923e-07 0 3.6098396569401923e-07 0 3.6099396569401924e-07 0.00021 3.6100396569401925e-07 0 3.6105112028871855e-07 0 3.6106112028871856e-07 0.00021 3.6107112028871857e-07 0 3.6107112028871857e-07 0 3.610811202887186e-07 0.00021 3.610911202887186e-07 0 3.6110365693765774e-07 0 3.6111365693765775e-07 0.00021 3.6112365693765776e-07 0 3.6112814775920644e-07 0 3.6113814775920645e-07 0.00021 3.6114814775920646e-07 0 3.611655501468757e-07 0 3.611755501468757e-07 0.00021 3.611855501468757e-07 0 3.612012698066699e-07 0 3.612112698066699e-07 0.00021 3.612212698066699e-07 0 3.612344338651789e-07 0 3.612444338651789e-07 0.00021 3.612544338651789e-07 0 3.612962939413691e-07 0 3.613062939413691e-07 0.00021 3.6131629394136913e-07 0 3.613406656728595e-07 0 3.613506656728595e-07 0.00021 3.613606656728595e-07 0 3.613606656728595e-07 0 3.613706656728595e-07 0.00021 3.613806656728595e-07 0 3.613806656728595e-07 0 3.6139066567285953e-07 0.00021 3.6140066567285954e-07 0 3.6140066567285954e-07 0 3.6141066567285956e-07 0.00021 3.6142066567285957e-07 0 3.6142066567285957e-07 0 3.614306656728596e-07 0.00021 3.614406656728596e-07 0 3.614406656728596e-07 0 3.614506656728596e-07 0.00021 3.614606656728596e-07 0 3.614606656728596e-07 0 3.614706656728596e-07 0.00021 3.6148066567285964e-07 0 3.6148066567285964e-07 0 3.6149066567285965e-07 0.00021 3.6150066567285966e-07 0 3.6150066567285966e-07 0 3.6151066567285967e-07 0.00021 3.615206656728597e-07 0 3.616039179012694e-07 0 3.616139179012694e-07 0.00021 3.616239179012694e-07 0 3.616239179012694e-07 0 3.6163391790126943e-07 0.00021 3.6164391790126944e-07 0 3.6164391790126944e-07 0 3.6165391790126945e-07 0.00021 3.6166391790126946e-07 0 3.6166391790126946e-07 0 3.616739179012695e-07 0.00021 3.616839179012695e-07 0 3.616839179012695e-07 0 3.616939179012695e-07 0.00021 3.617039179012695e-07 0 3.617392305931029e-07 0 3.6174923059310293e-07 0.00021 3.6175923059310294e-07 0 3.6175923059310294e-07 0 3.6176923059310295e-07 0.00021 3.6177923059310297e-07 0 3.6177923059310297e-07 0 3.61789230593103e-07 0.00021 3.61799230593103e-07 0 3.61799230593103e-07 0 3.61809230593103e-07 0.00021 3.61819230593103e-07 0 3.61819230593103e-07 0 3.61829230593103e-07 0.00021 3.6183923059310303e-07 0 3.6183923059310303e-07 0 3.6184923059310304e-07 0.00021 3.6185923059310306e-07 0 3.6185923059310306e-07 0 3.6186923059310307e-07 0.00021 3.618792305931031e-07 0 3.618792305931031e-07 0 3.618892305931031e-07 0.00021 3.618992305931031e-07 0 3.619149695595152e-07 0 3.619249695595152e-07 0.00021 3.619349695595152e-07 0 3.619349695595152e-07 0 3.6194496955951523e-07 0.00021 3.6195496955951524e-07 0 3.6195496955951524e-07 0 3.6196496955951526e-07 0.00021 3.6197496955951527e-07 0 3.6197496955951527e-07 0 3.619849695595153e-07 0.00021 3.619949695595153e-07 0 3.619955200456237e-07 0 3.6200552004562373e-07 0.00021 3.6201552004562375e-07 0 3.6206916853584433e-07 0 3.6207916853584434e-07 0.00021 3.6208916853584435e-07 0 3.6209153398070013e-07 0 3.6210153398070014e-07 0.00021 3.6211153398070015e-07 0 3.62111739070232e-07 0 3.62121739070232e-07 0.00021 3.6213173907023204e-07 0 3.6213557895950684e-07 0 3.6214557895950685e-07 0.00021 3.6215557895950686e-07 0 3.6215557895950686e-07 0 3.6216557895950687e-07 0.00021 3.621755789595069e-07 0 3.621755789595069e-07 0 3.621855789595069e-07 0.00021 3.621955789595069e-07 0 3.6219781655295673e-07 0 3.6220781655295674e-07 0.00021 3.6221781655295676e-07 0 3.6231734542088817e-07 0 3.623273454208882e-07 0.00021 3.623373454208882e-07 0 3.6235337146735626e-07 0 3.623633714673563e-07 0.00021 3.623733714673563e-07 0 3.623733714673563e-07 0 3.623833714673563e-07 0.00021 3.623933714673563e-07 0 3.623933714673563e-07 0 3.624033714673563e-07 0.00021 3.6241337146735633e-07 0 3.6241337146735633e-07 0 3.6242337146735634e-07 0.00021 3.6243337146735635e-07 0 3.6243337146735635e-07 0 3.6244337146735637e-07 0.00021 3.624533714673564e-07 0 3.624533714673564e-07 0 3.624633714673564e-07 0.00021 3.624733714673564e-07 0 3.6248422579024174e-07 0 3.6249422579024176e-07 0.00021 3.6250422579024177e-07 0 3.6250422579024177e-07 0 3.625142257902418e-07 0.00021 3.625242257902418e-07 0 3.625242257902418e-07 0 3.625342257902418e-07 0.00021 3.625442257902418e-07 0 3.6255405120146796e-07 0 3.6256405120146797e-07 0.00021 3.62574051201468e-07 0 3.62574051201468e-07 0 3.62584051201468e-07 0.00021 3.62594051201468e-07 0 3.62594051201468e-07 0 3.62604051201468e-07 0.00021 3.62614051201468e-07 0 3.62614051201468e-07 0 3.6262405120146804e-07 0.00021 3.6263405120146805e-07 0 3.6263405120146805e-07 0 3.6264405120146806e-07 0.00021 3.6265405120146807e-07 0 3.6265405120146807e-07 0 3.626640512014681e-07 0.00021 3.626740512014681e-07 0 3.6274608478248615e-07 0 3.6275608478248616e-07 0.00021 3.6276608478248617e-07 0 3.6276608478248617e-07 0 3.627760847824862e-07 0.00021 3.627860847824862e-07 0 3.627860847824862e-07 0 3.627960847824862e-07 0.00021 3.628060847824862e-07 0 3.6293548357337287e-07 0 3.629454835733729e-07 0.00021 3.629554835733729e-07 0 3.629554835733729e-07 0 3.629654835733729e-07 0.00021 3.629754835733729e-07 0 3.6300862096980406e-07 0 3.630186209698041e-07 0.00021 3.630286209698041e-07 0 3.630286209698041e-07 0 3.630386209698041e-07 0.00021 3.630486209698041e-07 0 3.630486209698041e-07 0 3.630586209698041e-07 0.00021 3.6306862096980413e-07 0 3.6307055856366225e-07 0 3.6308055856366226e-07 0.00021 3.6309055856366227e-07 0 3.6309055856366227e-07 0 3.631005585636623e-07 0.00021 3.631105585636623e-07 0 3.631105585636623e-07 0 3.631205585636623e-07 0.00021 3.631305585636623e-07 0 3.631305585636623e-07 0 3.6314055856366233e-07 0.00021 3.6315055856366234e-07 0 3.6315055856366234e-07 0 3.6316055856366235e-07 0.00021 3.6317055856366236e-07 0 3.6320883320517545e-07 0 3.6321883320517546e-07 0.00021 3.6322883320517547e-07 0 3.6322883320517547e-07 0 3.632388332051755e-07 0.00021 3.632488332051755e-07 0 3.633028863539706e-07 0 3.633128863539706e-07 0.00021 3.633228863539706e-07 0 3.633577668128347e-07 0 3.6336776681283473e-07 0.00021 3.6337776681283474e-07 0 3.6337776681283474e-07 0 3.6338776681283476e-07 0.00021 3.6339776681283477e-07 0 3.634217380039601e-07 0 3.634317380039601e-07 0.00021 3.634417380039601e-07 0 3.634417380039601e-07 0 3.6345173800396014e-07 0.00021 3.6346173800396015e-07 0 3.6346173800396015e-07 0 3.6347173800396016e-07 0.00021 3.6348173800396017e-07 0 3.635155338430084e-07 0 3.635255338430084e-07 0.00021 3.635355338430084e-07 0 3.635355338430084e-07 0 3.635455338430084e-07 0.00021 3.6355553384300843e-07 0 3.6355553384300843e-07 0 3.6356553384300844e-07 0.00021 3.6357553384300845e-07 0 3.6357553384300845e-07 0 3.6358553384300847e-07 0.00021 3.635955338430085e-07 0 3.635970505020512e-07 0 3.636070505020512e-07 0.00021 3.636170505020512e-07 0 3.636447365559539e-07 0 3.636547365559539e-07 0.00021 3.6366473655595393e-07 0 3.6366473655595393e-07 0 3.6367473655595394e-07 0.00021 3.6368473655595395e-07 0 3.6368473655595395e-07 0 3.6369473655595396e-07 0.00021 3.63704736555954e-07 0 3.63704736555954e-07 0 3.63714736555954e-07 0.00021 3.63724736555954e-07 0 3.63728306011783e-07 0 3.63738306011783e-07 0.00021 3.6374830601178303e-07 0 3.637618164245013e-07 0 3.637718164245013e-07 0.00021 3.637818164245013e-07 0 3.63789764227285e-07 0 3.63799764227285e-07 0.00021 3.63809764227285e-07 0 3.6381856088446646e-07 0 3.6382856088446647e-07 0.00021 3.638385608844665e-07 0 3.638385608844665e-07 0 3.638485608844665e-07 0.00021 3.638585608844665e-07 0 3.638585608844665e-07 0 3.638685608844665e-07 0.00021 3.6387856088446653e-07 0 3.6388887500313006e-07 0 3.6389887500313007e-07 0.00021 3.639088750031301e-07 0 3.639352157531429e-07 0 3.639452157531429e-07 0.00021 3.6395521575314294e-07 0 3.639680355496823e-07 0 3.639780355496823e-07 0.00021 3.6398803554968233e-07 0 3.6398803554968233e-07 0 3.6399803554968234e-07 0.00021 3.6400803554968236e-07 0 3.64026251095697e-07 0 3.64036251095697e-07 0.00021 3.6404625109569703e-07 0 3.64061574675993e-07 0 3.64071574675993e-07 0.00021 3.64081574675993e-07 0 3.6408831173097994e-07 0 3.6409831173097996e-07 0.00021 3.6410831173097997e-07 0 3.6412961938085705e-07 0 3.6413961938085706e-07 0.00021 3.6414961938085707e-07 0 3.6420244542625744e-07 0 3.6421244542625745e-07 0.00021 3.6422244542625746e-07 0 3.6422244542625746e-07 0 3.642324454262575e-07 0.00021 3.642424454262575e-07 0 3.642424454262575e-07 0 3.642524454262575e-07 0.00021 3.642624454262575e-07 0 3.643591057305967e-07 0 3.6436910573059674e-07 0.00021 3.6437910573059675e-07 0 3.644742759649482e-07 0 3.6448427596494823e-07 0.00021 3.6449427596494824e-07 0 3.6455616197781206e-07 0 3.6456616197781207e-07 0.00021 3.645761619778121e-07 0 3.645827627319234e-07 0 3.645927627319234e-07 0.00021 3.6460276273192343e-07 0 3.6460276273192343e-07 0 3.6461276273192344e-07 0.00021 3.6462276273192345e-07 0 3.6462276273192345e-07 0 3.6463276273192346e-07 0.00021 3.646427627319235e-07 0 3.646427627319235e-07 0 3.646527627319235e-07 0.00021 3.646627627319235e-07 0 3.646627627319235e-07 0 3.646727627319235e-07 0.00021 3.646827627319235e-07 0 3.646827627319235e-07 0 3.6469276273192353e-07 0.00021 3.6470276273192354e-07 0 3.6470276273192354e-07 0 3.6471276273192355e-07 0.00021 3.6472276273192357e-07 0 3.6472276273192357e-07 0 3.647327627319236e-07 0.00021 3.647427627319236e-07 0 3.647427627319236e-07 0 3.647527627319236e-07 0.00021 3.647627627319236e-07 0 3.647627627319236e-07 0 3.647727627319236e-07 0.00021 3.6478276273192363e-07 0 3.6478276273192363e-07 0 3.6479276273192364e-07 0.00021 3.6480276273192366e-07 0 3.6480276273192366e-07 0 3.6481276273192367e-07 0.00021 3.648227627319237e-07 0 3.648899115199467e-07 0 3.648999115199467e-07 0.00021 3.649099115199467e-07 0 3.649099115199467e-07 0 3.6491991151994674e-07 0.00021 3.6492991151994675e-07 0 3.6496533386931397e-07 0 3.64975333869314e-07 0.00021 3.64985333869314e-07 0 3.64985333869314e-07 0 3.64995333869314e-07 0.00021 3.65005333869314e-07 0 3.65005333869314e-07 0 3.65015333869314e-07 0.00021 3.6502533386931403e-07 0 3.6504513552331044e-07 0 3.6505513552331045e-07 0.00021 3.6506513552331046e-07 0 3.650666796371724e-07 0 3.650766796371724e-07 0.00021 3.650866796371724e-07 0 3.6512305697717135e-07 0 3.6513305697717136e-07 0.00021 3.651430569771714e-07 0 3.6520824604652314e-07 0 3.6521824604652315e-07 0.00021 3.6522824604652316e-07 0 3.6522824604652316e-07 0 3.652382460465232e-07 0.00021 3.652482460465232e-07 0 3.652482460465232e-07 0 3.652582460465232e-07 0.00021 3.652682460465232e-07 0 3.653009875894958e-07 0 3.653109875894958e-07 0.00021 3.6532098758949583e-07 0 3.6537278862920397e-07 0 3.65382788629204e-07 0.00021 3.65392788629204e-07 0 3.65417555512274e-07 0 3.65427555512274e-07 0.00021 3.6543755551227403e-07 0 3.654550559148042e-07 0 3.654650559148042e-07 0.00021 3.6547505591480423e-07 0 3.6547505591480423e-07 0 3.6548505591480425e-07 0.00021 3.6549505591480426e-07 0 3.655956846840609e-07 0 3.656056846840609e-07 0.00021 3.656156846840609e-07 0 3.656805280615743e-07 0 3.656905280615743e-07 0.00021 3.6570052806157433e-07 0 3.6575250811549807e-07 0 3.657625081154981e-07 0.00021 3.657725081154981e-07 0 3.657725081154981e-07 0 3.657825081154981e-07 0.00021 3.657925081154981e-07 0 3.658113727440184e-07 0 3.658213727440184e-07 0.00021 3.6583137274401843e-07 0 3.6584653871753754e-07 0 3.6585653871753755e-07 0.00021 3.6586653871753757e-07 0 3.6587217998685966e-07 0 3.6588217998685967e-07 0.00021 3.658921799868597e-07 0 3.660699178967098e-07 0 3.660799178967098e-07 0.00021 3.660899178967098e-07 0 3.660899178967098e-07 0 3.6609991789670983e-07 0.00021 3.6610991789670985e-07 0 3.6618100038499843e-07 0 3.6619100038499844e-07 0.00021 3.6620100038499846e-07 0 3.662172592654498e-07 0 3.6622725926544983e-07 0.00021 3.6623725926544984e-07 0 3.6623725926544984e-07 0 3.6624725926544985e-07 0.00021 3.6625725926544986e-07 0 3.6625725926544986e-07 0 3.662672592654499e-07 0.00021 3.662772592654499e-07 0 3.6633704293527065e-07 0 3.6634704293527066e-07 0.00021 3.6635704293527067e-07 0 3.663622115397556e-07 0 3.663722115397556e-07 0.00021 3.663822115397556e-07 0 3.663822115397556e-07 0 3.663922115397556e-07 0.00021 3.664022115397556e-07 0 3.664022115397556e-07 0 3.6641221153975564e-07 0.00021 3.6642221153975565e-07 0 3.6656169478505785e-07 0 3.6657169478505786e-07 0.00021 3.6658169478505787e-07 0 3.6658169478505787e-07 0 3.665916947850579e-07 0.00021 3.666016947850579e-07 0 3.666016947850579e-07 0 3.666116947850579e-07 0.00021 3.666216947850579e-07 0 3.6669082328652565e-07 0 3.6670082328652567e-07 0.00021 3.667108232865257e-07 0 3.667608972701541e-07 0 3.6677089727015414e-07 0.00021 3.6678089727015415e-07 0 3.668381320393442e-07 0 3.6684813203934424e-07 0.00021 3.6685813203934425e-07 0 3.668849524239504e-07 0 3.668949524239504e-07 0.00021 3.669049524239504e-07 0 3.6693601831894913e-07 0 3.6694601831894914e-07 0.00021 3.6695601831894915e-07 0 3.669794782865073e-07 0 3.669894782865073e-07 0.00021 3.669994782865073e-07 0 3.669994782865073e-07 0 3.670094782865073e-07 0.00021 3.6701947828650733e-07 0 3.6701947828650733e-07 0 3.6702947828650734e-07 0.00021 3.6703947828650735e-07 0 3.6703947828650735e-07 0 3.6704947828650737e-07 0.00021 3.670594782865074e-07 0 3.670594782865074e-07 0 3.670694782865074e-07 0.00021 3.670794782865074e-07 0 3.670794782865074e-07 0 3.670894782865074e-07 0.00021 3.670994782865074e-07 0 3.670994782865074e-07 0 3.6710947828650743e-07 0.00021 3.6711947828650745e-07 0 3.6711947828650745e-07 0 3.6712947828650746e-07 0.00021 3.6713947828650747e-07 0 3.6713947828650747e-07 0 3.671494782865075e-07 0.00021 3.671594782865075e-07 0 3.671594782865075e-07 0 3.671694782865075e-07 0.00021 3.671794782865075e-07 0 3.671794782865075e-07 0 3.671894782865075e-07 0.00021 3.6719947828650754e-07 0 3.672668073213881e-07 0 3.672768073213881e-07 0.00021 3.6728680732138814e-07 0 3.6728680732138814e-07 0 3.6729680732138815e-07 0.00021 3.6730680732138816e-07 0 3.6730680732138816e-07 0 3.6731680732138817e-07 0.00021 3.673268073213882e-07 0 3.673268073213882e-07 0 3.673368073213882e-07 0.00021 3.673468073213882e-07 0 3.673468073213882e-07 0 3.673568073213882e-07 0.00021 3.6736680732138823e-07 0 3.6736680732138823e-07 0 3.6737680732138824e-07 0.00021 3.6738680732138825e-07 0 3.6738680732138825e-07 0 3.6739680732138826e-07 0.00021 3.6740680732138827e-07 0 3.6740680732138827e-07 0 3.674168073213883e-07 0.00021 3.674268073213883e-07 0 3.674268073213883e-07 0 3.674368073213883e-07 0.00021 3.674468073213883e-07 0 3.674468073213883e-07 0 3.6745680732138833e-07 0.00021 3.6746680732138834e-07 0 3.6746680732138834e-07 0 3.6747680732138835e-07 0.00021 3.6748680732138836e-07 0 3.6748680732138836e-07 0 3.674968073213884e-07 0.00021 3.675068073213884e-07 0 3.6750864846554197e-07 0 3.67518648465542e-07 0.00021 3.67528648465542e-07 0 3.675782366109786e-07 0 3.675882366109786e-07 0.00021 3.675982366109786e-07 0 3.6760070143050713e-07 0 3.6761070143050714e-07 0.00021 3.6762070143050715e-07 0 3.6764766231554934e-07 0 3.6765766231554935e-07 0.00021 3.6766766231554936e-07 0 3.6768206331945073e-07 0 3.6769206331945075e-07 0.00021 3.6770206331945076e-07 0 3.6770206331945076e-07 0 3.6771206331945077e-07 0.00021 3.677220633194508e-07 0 3.677237373817334e-07 0 3.677337373817334e-07 0.00021 3.6774373738173344e-07 0 3.6774373738173344e-07 0 3.6775373738173345e-07 0.00021 3.6776373738173346e-07 0 3.6778207242448424e-07 0 3.6779207242448425e-07 0.00021 3.6780207242448426e-07 0 3.679133606868304e-07 0 3.679233606868304e-07 0.00021 3.6793336068683043e-07 0 3.6793336068683043e-07 0 3.6794336068683044e-07 0.00021 3.6795336068683045e-07 0 3.6795336068683045e-07 0 3.6796336068683046e-07 0.00021 3.679733606868305e-07 0 3.679733606868305e-07 0 3.679833606868305e-07 0.00021 3.679933606868305e-07 0 3.68000723975158e-07 0 3.68010723975158e-07 0.00021 3.68020723975158e-07 0 3.68020723975158e-07 0 3.6803072397515803e-07 0.00021 3.6804072397515804e-07 0 3.6804072397515804e-07 0 3.6805072397515805e-07 0.00021 3.6806072397515807e-07 0 3.6806072397515807e-07 0 3.680707239751581e-07 0.00021 3.680807239751581e-07 0 3.680903907251209e-07 0 3.6810039072512093e-07 0.00021 3.6811039072512094e-07 0 3.6811039072512094e-07 0 3.6812039072512095e-07 0.00021 3.6813039072512096e-07 0 3.6813039072512096e-07 0 3.68140390725121e-07 0.00021 3.68150390725121e-07 0 3.6815541896840926e-07 0 3.6816541896840927e-07 0.00021 3.681754189684093e-07 0 3.68187033995057e-07 0 3.68197033995057e-07 0.00021 3.68207033995057e-07 0 3.682562055154978e-07 0 3.682662055154978e-07 0.00021 3.682762055154978e-07 0 3.682845695888715e-07 0 3.682945695888715e-07 0.00021 3.6830456958887153e-07 0 3.6830456958887153e-07 0 3.6831456958887154e-07 0.00021 3.6832456958887155e-07 0 3.683274830528533e-07 0 3.683374830528533e-07 0.00021 3.6834748305285334e-07 0 3.6834748305285334e-07 0 3.6835748305285335e-07 0.00021 3.6836748305285336e-07 0 3.6836953633634e-07 0 3.6837953633634003e-07 0.00021 3.6838953633634004e-07 0 3.684073019157316e-07 0 3.684173019157316e-07 0.00021 3.6842730191573163e-07 0 3.684681050536135e-07 0 3.684781050536135e-07 0.00021 3.6848810505361353e-07 0 3.6848810505361353e-07 0 3.6849810505361354e-07 0.00021 3.6850810505361355e-07 0 3.6850810505361355e-07 0 3.6851810505361356e-07 0.00021 3.6852810505361357e-07 0 3.6856240628482653e-07 0 3.6857240628482654e-07 0.00021 3.6858240628482656e-07 0 3.6858240628482656e-07 0 3.6859240628482657e-07 0.00021 3.686024062848266e-07 0 3.686024062848266e-07 0 3.686124062848266e-07 0.00021 3.686224062848266e-07 0 3.686224062848266e-07 0 3.686324062848266e-07 0.00021 3.686424062848266e-07 0 3.686424062848266e-07 0 3.6865240628482664e-07 0.00021 3.6866240628482665e-07 0 3.686851376627694e-07 0 3.686951376627694e-07 0.00021 3.687051376627694e-07 0 3.687968925682372e-07 0 3.688068925682372e-07 0.00021 3.6881689256823723e-07 0 3.689491006019095e-07 0 3.689591006019095e-07 0.00021 3.689691006019095e-07 0 3.690384739150064e-07 0 3.690484739150064e-07 0.00021 3.690584739150064e-07 0 3.690584739150064e-07 0 3.690684739150064e-07 0.00021 3.6907847391500643e-07 0 3.6907847391500643e-07 0 3.6908847391500644e-07 0.00021 3.6909847391500645e-07 0 3.6909847391500645e-07 0 3.6910847391500646e-07 0.00021 3.6911847391500647e-07 0 3.6911847391500647e-07 0 3.691284739150065e-07 0.00021 3.691384739150065e-07 0 3.691598373808512e-07 0 3.691698373808512e-07 0.00021 3.6917983738085123e-07 0 3.6917983738085123e-07 0 3.6918983738085124e-07 0.00021 3.6919983738085125e-07 0 3.6919983738085125e-07 0 3.6920983738085126e-07 0.00021 3.692198373808513e-07 0 3.692198373808513e-07 0 3.692298373808513e-07 0.00021 3.692398373808513e-07 0 3.692398373808513e-07 0 3.692498373808513e-07 0.00021 3.692598373808513e-07 0 3.692598373808513e-07 0 3.6926983738085133e-07 0.00021 3.6927983738085134e-07 0 3.6927983738085134e-07 0 3.6928983738085136e-07 0.00021 3.6929983738085137e-07 0 3.6929983738085137e-07 0 3.693098373808514e-07 0.00021 3.693198373808514e-07 0 3.693198373808514e-07 0 3.693298373808514e-07 0.00021 3.693398373808514e-07 0 3.693398373808514e-07 0 3.693498373808514e-07 0.00021 3.6935983738085144e-07 0 3.6935983738085144e-07 0 3.6936983738085145e-07 0.00021 3.6937983738085146e-07 0 3.6937983738085146e-07 0 3.6938983738085147e-07 0.00021 3.693998373808515e-07 0 3.693998373808515e-07 0 3.694098373808515e-07 0.00021 3.694198373808515e-07 0 3.694198373808515e-07 0 3.694298373808515e-07 0.00021 3.694398373808515e-07 0 3.6949093407584964e-07 0 3.6950093407584965e-07 0.00021 3.6951093407584966e-07 0 3.6951093407584966e-07 0 3.6952093407584967e-07 0.00021 3.695309340758497e-07 0 3.696425817257862e-07 0 3.696525817257862e-07 0.00021 3.696625817257862e-07 0 3.696958998135795e-07 0 3.6970589981357953e-07 0.00021 3.6971589981357954e-07 0 3.6977456736379933e-07 0 3.6978456736379934e-07 0.00021 3.6979456736379936e-07 0 3.698641891986753e-07 0 3.698741891986753e-07 0.00021 3.698841891986753e-07 0 3.6990199210243823e-07 0 3.6991199210243824e-07 0.00021 3.6992199210243825e-07 0 3.6992199210243825e-07 0 3.6993199210243826e-07 0.00021 3.699419921024383e-07 0 3.699419921024383e-07 0 3.699519921024383e-07 0.00021 3.699619921024383e-07 0 3.699619921024383e-07 0 3.699719921024383e-07 0.00021 3.699819921024383e-07 0 3.7000774784877137e-07 0 3.700177478487714e-07 0.00021 3.700277478487714e-07 0 3.700753041702115e-07 0 3.700853041702115e-07 0.00021 3.700953041702115e-07 0 3.700953041702115e-07 0 3.701053041702115e-07 0.00021 3.7011530417021153e-07 0 3.70147151833489e-07 0 3.70157151833489e-07 0.00021 3.70167151833489e-07 0 3.70167151833489e-07 0 3.7017715183348903e-07 0.00021 3.7018715183348905e-07 0 3.702093368381122e-07 0 3.702193368381122e-07 0.00021 3.7022933683811224e-07 0 3.7027438866928624e-07 0 3.7028438866928625e-07 0.00021 3.7029438866928626e-07 0 3.703027842334965e-07 0 3.703127842334965e-07 0.00021 3.7032278423349653e-07 0 3.703311921142284e-07 0 3.7034119211422843e-07 0.00021 3.7035119211422844e-07 0 3.703523228525242e-07 0 3.703623228525242e-07 0.00021 3.703723228525242e-07 0 3.703810031151807e-07 0 3.703910031151807e-07 0.00021 3.704010031151807e-07 0 3.7040818559006695e-07 0 3.7041818559006696e-07 0.00021 3.7042818559006697e-07 0 3.704705193952574e-07 0 3.704805193952574e-07 0.00021 3.704905193952574e-07 0 3.70530792337152e-07 0 3.7054079233715204e-07 0.00021 3.7055079233715205e-07 0 3.705740036448861e-07 0 3.705840036448861e-07 0.00021 3.705940036448861e-07 0 3.706149104134938e-07 0 3.706249104134938e-07 0.00021 3.706349104134938e-07 0 3.706349104134938e-07 0 3.706449104134938e-07 0.00021 3.706549104134938e-07 0 3.706549104134938e-07 0 3.7066491041349383e-07 0.00021 3.7067491041349384e-07 0 3.7080170103692835e-07 0 3.7081170103692836e-07 0.00021 3.7082170103692837e-07 0 3.70869681111459e-07 0 3.70879681111459e-07 0.00021 3.70889681111459e-07 0 3.7097225055164366e-07 0 3.7098225055164367e-07 0.00021 3.709922505516437e-07 0 3.709922505516437e-07 0 3.710022505516437e-07 0.00021 3.710122505516437e-07 0 3.7102882435195556e-07 0 3.7103882435195557e-07 0.00021 3.710488243519556e-07 0 3.710488243519556e-07 0 3.710588243519556e-07 0.00021 3.710688243519556e-07 0 3.7107524397206773e-07 0 3.7108524397206774e-07 0.00021 3.7109524397206775e-07 0 3.7109524397206775e-07 0 3.7110524397206776e-07 0.00021 3.711152439720678e-07 0 3.711152439720678e-07 0 3.711252439720678e-07 0.00021 3.711352439720678e-07 0 3.711352439720678e-07 0 3.711452439720678e-07 0.00021 3.711552439720678e-07 0 3.711552439720678e-07 0 3.7116524397206783e-07 0.00021 3.7117524397206784e-07 0 3.7117524397206784e-07 0 3.7118524397206785e-07 0.00021 3.7119524397206787e-07 0 3.7119524397206787e-07 0 3.712052439720679e-07 0.00021 3.712152439720679e-07 0 3.7123976414239844e-07 0 3.7124976414239845e-07 0.00021 3.7125976414239846e-07 0 3.7128767306509153e-07 0 3.7129767306509154e-07 0.00021 3.7130767306509155e-07 0 3.7130767306509155e-07 0 3.7131767306509157e-07 0.00021 3.713276730650916e-07 0 3.713507805101392e-07 0 3.7136078051013923e-07 0.00021 3.7137078051013924e-07 0 3.7137078051013924e-07 0 3.7138078051013926e-07 0.00021 3.7139078051013927e-07 0 3.7139198973664275e-07 0 3.7140198973664276e-07 0.00021 3.7141198973664277e-07 0 3.7143031025347344e-07 0 3.7144031025347345e-07 0.00021 3.7145031025347347e-07 0 3.7145031025347347e-07 0 3.714603102534735e-07 0.00021 3.714703102534735e-07 0 3.714703102534735e-07 0 3.714803102534735e-07 0.00021 3.714903102534735e-07 0 3.715360994625701e-07 0 3.715460994625701e-07 0.00021 3.715560994625701e-07 0 3.715560994625701e-07 0 3.715660994625701e-07 0.00021 3.715760994625701e-07 0 3.715760994625701e-07 0 3.7158609946257014e-07 0.00021 3.7159609946257015e-07 0 3.7159609946257015e-07 0 3.7160609946257016e-07 0.00021 3.7161609946257017e-07 0 3.7161609946257017e-07 0 3.716260994625702e-07 0.00021 3.716360994625702e-07 0 3.716360994625702e-07 0 3.716460994625702e-07 0.00021 3.716560994625702e-07 0 3.7180971205137044e-07 0 3.7181971205137045e-07 0.00021 3.7182971205137046e-07 0 3.718839215793831e-07 0 3.718939215793831e-07 0.00021 3.719039215793831e-07 0 3.719039215793831e-07 0 3.719139215793831e-07 0.00021 3.7192392157938313e-07 0 3.7200881615914193e-07 0 3.7201881615914194e-07 0.00021 3.7202881615914195e-07 0 3.7203865234534277e-07 0 3.720486523453428e-07 0.00021 3.720586523453428e-07 0 3.720989236830503e-07 0 3.721089236830503e-07 0.00021 3.721189236830503e-07 0 3.721189236830503e-07 0 3.7212892368305033e-07 0.00021 3.7213892368305034e-07 0 3.7218486470166516e-07 0 3.7219486470166517e-07 0.00021 3.722048647016652e-07 0 3.722219682671831e-07 0 3.7223196826718313e-07 0.00021 3.7224196826718314e-07 0 3.7224196826718314e-07 0 3.7225196826718316e-07 0.00021 3.7226196826718317e-07 0 3.7226196826718317e-07 0 3.722719682671832e-07 0.00021 3.722819682671832e-07 0 3.722917675613554e-07 0 3.723017675613554e-07 0.00021 3.723117675613554e-07 0 3.7234150056326886e-07 0 3.723515005632689e-07 0.00021 3.723615005632689e-07 0 3.723615005632689e-07 0 3.723715005632689e-07 0.00021 3.723815005632689e-07 0 3.723815005632689e-07 0 3.723915005632689e-07 0.00021 3.7240150056326893e-07 0 3.7240150056326893e-07 0 3.7241150056326894e-07 0.00021 3.7242150056326895e-07 0 3.7242150056326895e-07 0 3.7243150056326896e-07 0.00021 3.72441500563269e-07 0 3.72441500563269e-07 0 3.72451500563269e-07 0.00021 3.72461500563269e-07 0 3.7249503481571207e-07 0 3.725050348157121e-07 0.00021 3.725150348157121e-07 0 3.725150348157121e-07 0 3.725250348157121e-07 0.00021 3.725350348157121e-07 0 3.725350348157121e-07 0 3.7254503481571213e-07 0.00021 3.7255503481571214e-07 0 3.7255503481571214e-07 0 3.7256503481571215e-07 0.00021 3.7257503481571216e-07 0 3.7257503481571216e-07 0 3.7258503481571217e-07 0.00021 3.725950348157122e-07 0 3.725950348157122e-07 0 3.726050348157122e-07 0.00021 3.726150348157122e-07 0 3.726150348157122e-07 0 3.726250348157122e-07 0.00021 3.7263503481571223e-07 0 3.7263965411097873e-07 0 3.7264965411097874e-07 0.00021 3.7265965411097875e-07 0 3.7265965411097875e-07 0 3.7266965411097876e-07 0.00021 3.726796541109788e-07 0 3.726796541109788e-07 0 3.726896541109788e-07 0.00021 3.726996541109788e-07 0 3.726996541109788e-07 0 3.727096541109788e-07 0.00021 3.727196541109788e-07 0 3.727196541109788e-07 0 3.7272965411097883e-07 0.00021 3.7273965411097884e-07 0 3.7273965411097884e-07 0 3.7274965411097885e-07 0.00021 3.7275965411097887e-07 0 3.7275965411097887e-07 0 3.727696541109789e-07 0.00021 3.727796541109789e-07 0 3.727796541109789e-07 0 3.727896541109789e-07 0.00021 3.727996541109789e-07 0 3.727996541109789e-07 0 3.728096541109789e-07 0.00021 3.7281965411097893e-07 0 3.7281965411097893e-07 0 3.7282965411097894e-07 0.00021 3.7283965411097896e-07 0 3.7283965411097896e-07 0 3.7284965411097897e-07 0.00021 3.72859654110979e-07 0 3.72859654110979e-07 0 3.72869654110979e-07 0.00021 3.72879654110979e-07 0 3.72879654110979e-07 0 3.72889654110979e-07 0.00021 3.72899654110979e-07 0 3.72899654110979e-07 0 3.7290965411097904e-07 0.00021 3.7291965411097905e-07 0 3.7291965411097905e-07 0 3.7292965411097906e-07 0.00021 3.7293965411097907e-07 0 3.7293965411097907e-07 0 3.729496541109791e-07 0.00021 3.729596541109791e-07 0 3.729596541109791e-07 0 3.729696541109791e-07 0.00021 3.729796541109791e-07 0 3.729796541109791e-07 0 3.729896541109791e-07 0.00021 3.7299965411097914e-07 0 3.7299965411097914e-07 0 3.7300965411097915e-07 0.00021 3.7301965411097916e-07 0 3.7301965411097916e-07 0 3.7302965411097917e-07 0.00021 3.730396541109792e-07 0 3.730396541109792e-07 0 3.730496541109792e-07 0.00021 3.730596541109792e-07 0 3.730596541109792e-07 0 3.730696541109792e-07 0.00021 3.7307965411097923e-07 0 3.7307965411097923e-07 0 3.7308965411097924e-07 0.00021 3.7309965411097925e-07 0 3.7309965411097925e-07 0 3.7310965411097926e-07 0.00021 3.7311965411097927e-07 0 3.7311968023554843e-07 0 3.7312968023554844e-07 0.00021 3.7313968023554845e-07 0 3.7314351872843406e-07 0 3.7315351872843407e-07 0.00021 3.731635187284341e-07 0 3.731635187284341e-07 0 3.731735187284341e-07 0.00021 3.731835187284341e-07 0 3.732080202680507e-07 0 3.732180202680507e-07 0.00021 3.732280202680507e-07 0 3.732280202680507e-07 0 3.732380202680507e-07 0.00021 3.732480202680507e-07 0 3.732531765480364e-07 0 3.7326317654803643e-07 0.00021 3.7327317654803644e-07 0 3.733009722203174e-07 0 3.7331097222031743e-07 0.00021 3.7332097222031744e-07 0 3.733475658245441e-07 0 3.7335756582454413e-07 0.00021 3.7336756582454414e-07 0 3.734100268444345e-07 0 3.734200268444345e-07 0.00021 3.7343002684443453e-07 0 3.7343002684443453e-07 0 3.7344002684443454e-07 0.00021 3.7345002684443456e-07 0 3.7345002684443456e-07 0 3.7346002684443457e-07 0.00021 3.734700268444346e-07 0 3.735269942125625e-07 0 3.735369942125625e-07 0.00021 3.735469942125625e-07 0 3.7357648412321036e-07 0 3.7358648412321037e-07 0.00021 3.735964841232104e-07 0 3.7360716112207867e-07 0 3.736171611220787e-07 0.00021 3.736271611220787e-07 0 3.736963199481004e-07 0 3.737063199481004e-07 0.00021 3.737163199481004e-07 0 3.737284665311214e-07 0 3.737384665311214e-07 0.00021 3.7374846653112144e-07 0 3.7374846653112144e-07 0 3.7375846653112145e-07 0.00021 3.7376846653112146e-07 0 3.7376846653112146e-07 0 3.7377846653112147e-07 0.00021 3.737884665311215e-07 0 3.737884665311215e-07 0 3.737984665311215e-07 0.00021 3.738084665311215e-07 0 3.738084665311215e-07 0 3.738184665311215e-07 0.00021 3.7382846653112153e-07 0 3.7382846653112153e-07 0 3.7383846653112154e-07 0.00021 3.7384846653112155e-07 0 3.7384846653112155e-07 0 3.7385846653112156e-07 0.00021 3.7386846653112157e-07 0 3.7386846653112157e-07 0 3.738784665311216e-07 0.00021 3.738884665311216e-07 0 3.738884665311216e-07 0 3.738984665311216e-07 0.00021 3.739084665311216e-07 0 3.739084665311216e-07 0 3.7391846653112163e-07 0.00021 3.7392846653112164e-07 0 3.7392846653112164e-07 0 3.7393846653112165e-07 0.00021 3.7394846653112166e-07 0 3.7394846653112166e-07 0 3.739584665311217e-07 0.00021 3.739684665311217e-07 0 3.739684665311217e-07 0 3.739784665311217e-07 0.00021 3.739884665311217e-07 0 3.739884665311217e-07 0 3.739984665311217e-07 0.00021 3.7400846653112173e-07 0 3.7400846653112173e-07 0 3.7401846653112174e-07 0.00021 3.7402846653112175e-07 0 3.7402846653112175e-07 0 3.7403846653112177e-07 0.00021 3.740484665311218e-07 0 3.740484665311218e-07 0 3.740584665311218e-07 0.00021 3.740684665311218e-07 0 3.740684665311218e-07 0 3.740784665311218e-07 0.00021 3.740884665311218e-07 0 3.740884665311218e-07 0 3.7409846653112183e-07 0.00021 3.7410846653112185e-07 0 3.741839881897265e-07 0 3.741939881897265e-07 0.00021 3.742039881897265e-07 0 3.742039881897265e-07 0 3.742139881897265e-07 0.00021 3.742239881897265e-07 0 3.742239881897265e-07 0 3.7423398818972654e-07 0.00021 3.7424398818972655e-07 0 3.7424398818972655e-07 0 3.7425398818972656e-07 0.00021 3.7426398818972657e-07 0 3.7426398818972657e-07 0 3.742739881897266e-07 0.00021 3.742839881897266e-07 0 3.742839881897266e-07 0 3.742939881897266e-07 0.00021 3.743039881897266e-07 0 3.743758459566321e-07 0 3.743858459566321e-07 0.00021 3.743958459566321e-07 0 3.743958459566321e-07 0 3.744058459566321e-07 0.00021 3.7441584595663213e-07 0 3.7441584595663213e-07 0 3.7442584595663214e-07 0.00021 3.7443584595663215e-07 0 3.7443584595663215e-07 0 3.7444584595663217e-07 0.00021 3.744558459566322e-07 0 3.744558459566322e-07 0 3.744658459566322e-07 0.00021 3.744758459566322e-07 0 3.744758459566322e-07 0 3.744858459566322e-07 0.00021 3.744958459566322e-07 0 3.744958459566322e-07 0 3.7450584595663223e-07 0.00021 3.7451584595663224e-07 0 3.745293042571606e-07 0 3.745393042571606e-07 0.00021 3.745493042571606e-07 0 3.7456404080379766e-07 0 3.745740408037977e-07 0.00021 3.745840408037977e-07 0 3.745840408037977e-07 0 3.745940408037977e-07 0.00021 3.746040408037977e-07 0 3.7462536826357843e-07 0 3.7463536826357845e-07 0.00021 3.7464536826357846e-07 0 3.7464536826357846e-07 0 3.7465536826357847e-07 0.00021 3.746653682635785e-07 0 3.746660669801344e-07 0 3.746760669801344e-07 0.00021 3.7468606698013443e-07 0 3.74716242752217e-07 0 3.74726242752217e-07 0.00021 3.7473624275221704e-07 0 3.747692955519395e-07 0 3.747792955519395e-07 0.00021 3.747892955519395e-07 0 3.747892955519395e-07 0 3.747992955519395e-07 0.00021 3.748092955519395e-07 0 3.748314650056762e-07 0 3.748414650056762e-07 0.00021 3.748514650056762e-07 0 3.74898364895019e-07 0 3.74908364895019e-07 0.00021 3.74918364895019e-07 0 3.7498386535478476e-07 0 3.7499386535478477e-07 0.00021 3.750038653547848e-07 0 3.750048411525197e-07 0 3.750148411525197e-07 0.00021 3.7502484115251973e-07 0 3.7508941513660445e-07 0 3.7509941513660446e-07 0.00021 3.7510941513660447e-07 0 3.7510941513660447e-07 0 3.751194151366045e-07 0.00021 3.751294151366045e-07 0 3.751294151366045e-07 0 3.751394151366045e-07 0.00021 3.751494151366045e-07 0 3.751494151366045e-07 0 3.751594151366045e-07 0.00021 3.7516941513660454e-07 0 3.7516964762484814e-07 0 3.7517964762484815e-07 0.00021 3.7518964762484816e-07 0 3.7518964762484816e-07 0 3.7519964762484817e-07 0.00021 3.752096476248482e-07 0 3.7524829535521956e-07 0 3.7525829535521957e-07 0.00021 3.752682953552196e-07 0 3.753366517429624e-07 0 3.753466517429624e-07 0.00021 3.753566517429624e-07 0 3.7536130122708906e-07 0 3.7537130122708907e-07 0.00021 3.753813012270891e-07 0 3.75383646536856e-07 0 3.75393646536856e-07 0.00021 3.75403646536856e-07 0 3.75403646536856e-07 0 3.7541364653685604e-07 0.00021 3.7542364653685605e-07 0 3.7542364653685605e-07 0 3.7543364653685606e-07 0.00021 3.7544364653685607e-07 0 3.7544364653685607e-07 0 3.754536465368561e-07 0.00021 3.754636465368561e-07 0 3.754636465368561e-07 0 3.754736465368561e-07 0.00021 3.754836465368561e-07 0 3.754997030676492e-07 0 3.755097030676492e-07 0.00021 3.7551970306764924e-07 0 3.755244545774804e-07 0 3.755344545774804e-07 0.00021 3.7554445457748043e-07 0 3.7554445457748043e-07 0 3.7555445457748044e-07 0.00021 3.7556445457748045e-07 0 3.7556445457748045e-07 0 3.7557445457748047e-07 0.00021 3.755844545774805e-07 0 3.756897137610312e-07 0 3.7569971376103123e-07 0.00021 3.7570971376103124e-07 0 3.7570971376103124e-07 0 3.7571971376103125e-07 0.00021 3.7572971376103126e-07 0 3.757417000437088e-07 0 3.757517000437088e-07 0.00021 3.757617000437088e-07 0 3.757877919838076e-07 0 3.757977919838076e-07 0.00021 3.758077919838076e-07 0 3.758190361300489e-07 0 3.7582903613004893e-07 0.00021 3.7583903613004895e-07 0 3.7583903613004895e-07 0 3.7584903613004896e-07 0.00021 3.7585903613004897e-07 0 3.7585903613004897e-07 0 3.75869036130049e-07 0.00021 3.75879036130049e-07 0 3.75879036130049e-07 0 3.75889036130049e-07 0.00021 3.75899036130049e-07 0 3.75899036130049e-07 0 3.75909036130049e-07 0.00021 3.7591903613004904e-07 0 3.7591903613004904e-07 0 3.7592903613004905e-07 0.00021 3.7593903613004906e-07 0 3.7593903613004906e-07 0 3.7594903613004907e-07 0.00021 3.759590361300491e-07 0 3.7603630395967134e-07 0 3.7604630395967135e-07 0.00021 3.7605630395967137e-07 0 3.76073385653546e-07 0 3.76083385653546e-07 0.00021 3.7609338565354603e-07 0 3.7612113178505754e-07 0 3.7613113178505755e-07 0.00021 3.7614113178505756e-07 0 3.7614113178505756e-07 0 3.761511317850576e-07 0.00021 3.761611317850576e-07 0 3.761611317850576e-07 0 3.761711317850576e-07 0.00021 3.761811317850576e-07 0 3.761811317850576e-07 0 3.761911317850576e-07 0.00021 3.7620113178505763e-07 0 3.7620113178505763e-07 0 3.7621113178505764e-07 0.00021 3.7622113178505765e-07 0 3.7622113178505765e-07 0 3.7623113178505767e-07 0.00021 3.762411317850577e-07 0 3.762411317850577e-07 0 3.762511317850577e-07 0.00021 3.762611317850577e-07 0 3.762611317850577e-07 0 3.762711317850577e-07 0.00021 3.762811317850577e-07 0 3.762811317850577e-07 0 3.7629113178505773e-07 0.00021 3.7630113178505774e-07 0 3.7630113178505774e-07 0 3.7631113178505776e-07 0.00021 3.7632113178505777e-07 0 3.7632113178505777e-07 0 3.763311317850578e-07 0.00021 3.763411317850578e-07 0 3.763411317850578e-07 0 3.763511317850578e-07 0.00021 3.763611317850578e-07 0 3.763611317850578e-07 0 3.763711317850578e-07 0.00021 3.7638113178505784e-07 0 3.7638113178505784e-07 0 3.7639113178505785e-07 0.00021 3.7640113178505786e-07 0 3.7640113178505786e-07 0 3.7641113178505787e-07 0.00021 3.764211317850579e-07 0 3.764211317850579e-07 0 3.764311317850579e-07 0.00021 3.764411317850579e-07 0 3.764411317850579e-07 0 3.764511317850579e-07 0.00021 3.764611317850579e-07 0 3.764611317850579e-07 0 3.7647113178505794e-07 0.00021 3.7648113178505795e-07 0 3.7648113178505795e-07 0 3.7649113178505796e-07 0.00021 3.7650113178505797e-07 0 3.765178813275805e-07 0 3.765278813275805e-07 0.00021 3.765378813275805e-07 0 3.7659717768073703e-07 0 3.7660717768073705e-07 0.00021 3.7661717768073706e-07 0 3.7661717768073706e-07 0 3.7662717768073707e-07 0.00021 3.766371776807371e-07 0 3.766426240865306e-07 0 3.7665262408653063e-07 0.00021 3.7666262408653064e-07 0 3.7666262408653064e-07 0 3.7667262408653065e-07 0.00021 3.7668262408653066e-07 0 3.7668262408653066e-07 0 3.7669262408653067e-07 0.00021 3.767026240865307e-07 0 3.767026240865307e-07 0 3.767126240865307e-07 0.00021 3.767226240865307e-07 0 3.767226240865307e-07 0 3.767326240865307e-07 0.00021 3.7674262408653073e-07 0 3.7674262408653073e-07 0 3.7675262408653074e-07 0.00021 3.7676262408653075e-07 0 3.7676262408653075e-07 0 3.7677262408653076e-07 0.00021 3.767826240865308e-07 0 3.767826240865308e-07 0 3.767926240865308e-07 0.00021 3.768026240865308e-07 0 3.768606997268219e-07 0 3.7687069972682193e-07 0.00021 3.7688069972682194e-07 0 3.7688069972682194e-07 0 3.7689069972682196e-07 0.00021 3.7690069972682197e-07 0 3.7690069972682197e-07 0 3.76910699726822e-07 0.00021 3.76920699726822e-07 0 3.76920699726822e-07 0 3.76930699726822e-07 0.00021 3.76940699726822e-07 0 3.76940699726822e-07 0 3.76950699726822e-07 0.00021 3.7696069972682203e-07 0 3.7696069972682203e-07 0 3.7697069972682205e-07 0.00021 3.7698069972682206e-07 0 3.7698069972682206e-07 0 3.7699069972682207e-07 0.00021 3.770006997268221e-07 0 3.770006997268221e-07 0 3.770106997268221e-07 0.00021 3.770206997268221e-07 0 3.770206997268221e-07 0 3.770306997268221e-07 0.00021 3.770406997268221e-07 0 3.770406997268221e-07 0 3.7705069972682214e-07 0.00021 3.7706069972682215e-07 0 3.7706069972682215e-07 0 3.7707069972682216e-07 0.00021 3.7708069972682217e-07 0 3.7708069972682217e-07 0 3.770906997268222e-07 0.00021 3.771006997268222e-07 0 3.7710713566165375e-07 0 3.7711713566165377e-07 0.00021 3.771271356616538e-07 0 3.771642137242174e-07 0 3.771742137242174e-07 0.00021 3.7718421372421743e-07 0 3.7719348330110495e-07 0 3.7720348330110496e-07 0.00021 3.77213483301105e-07 0 3.772279913504169e-07 0 3.772379913504169e-07 0.00021 3.7724799135041693e-07 0 3.7726627795100845e-07 0 3.7727627795100846e-07 0.00021 3.7728627795100847e-07 0 3.7728627795100847e-07 0 3.772962779510085e-07 0.00021 3.773062779510085e-07 0 3.773062779510085e-07 0 3.773162779510085e-07 0.00021 3.773262779510085e-07 0 3.774204456269528e-07 0 3.774304456269528e-07 0.00021 3.774404456269528e-07 0 3.774455531809517e-07 0 3.774555531809517e-07 0.00021 3.774655531809517e-07 0 3.7747747854065417e-07 0 3.774874785406542e-07 0.00021 3.774974785406542e-07 0 3.774974785406542e-07 0 3.775074785406542e-07 0.00021 3.775174785406542e-07 0 3.775174785406542e-07 0 3.775274785406542e-07 0.00021 3.7753747854065424e-07 0 3.775515651358174e-07 0 3.775615651358174e-07 0.00021 3.775715651358174e-07 0 3.775715651358174e-07 0 3.7758156513581743e-07 0.00021 3.7759156513581744e-07 0 3.7760261932158476e-07 0 3.7761261932158477e-07 0.00021 3.776226193215848e-07 0 3.7765026616820805e-07 0 3.7766026616820806e-07 0.00021 3.7767026616820807e-07 0 3.7767786815014313e-07 0 3.7768786815014314e-07 0.00021 3.7769786815014315e-07 0 3.7774690800014025e-07 0 3.7775690800014026e-07 0.00021 3.7776690800014027e-07 0 3.778489741138434e-07 0 3.778589741138434e-07 0.00021 3.778689741138434e-07 0 3.778689741138434e-07 0 3.7787897411384343e-07 0.00021 3.7788897411384344e-07 0 3.7793166274721307e-07 0 3.779416627472131e-07 0.00021 3.779516627472131e-07 0 3.779735717568946e-07 0 3.779835717568946e-07 0.00021 3.779935717568946e-07 0 3.7803612064001896e-07 0 3.78046120640019e-07 0.00021 3.78056120640019e-07 0 3.78056120640019e-07 0 3.78066120640019e-07 0.00021 3.78076120640019e-07 0 3.781120973991182e-07 0 3.781220973991182e-07 0.00021 3.781320973991182e-07 0 3.781320973991182e-07 0 3.781420973991182e-07 0.00021 3.7815209739911824e-07 0 3.7815577202139283e-07 0 3.7816577202139284e-07 0.00021 3.7817577202139285e-07 0 3.7817577202139285e-07 0 3.7818577202139287e-07 0.00021 3.781957720213929e-07 0 3.781957720213929e-07 0 3.782057720213929e-07 0.00021 3.782157720213929e-07 0 3.782157720213929e-07 0 3.782257720213929e-07 0.00021 3.782357720213929e-07 0 3.782357720213929e-07 0 3.7824577202139293e-07 0.00021 3.7825577202139294e-07 0 3.7825745671359184e-07 0 3.7826745671359185e-07 0.00021 3.7827745671359186e-07 0 3.782808502611561e-07 0 3.7829085026115613e-07 0.00021 3.7830085026115615e-07 0 3.7830085026115615e-07 0 3.7831085026115616e-07 0.00021 3.7832085026115617e-07 0 3.7835468346962227e-07 0 3.783646834696223e-07 0.00021 3.783746834696223e-07 0 3.783746834696223e-07 0 3.783846834696223e-07 0.00021 3.783946834696223e-07 0 3.783946834696223e-07 0 3.784046834696223e-07 0.00021 3.7841468346962234e-07 0 3.7841468346962234e-07 0 3.7842468346962235e-07 0.00021 3.7843468346962236e-07 0 3.7843468346962236e-07 0 3.7844468346962237e-07 0.00021 3.784546834696224e-07 0 3.7850370819925827e-07 0 3.785137081992583e-07 0.00021 3.785237081992583e-07 0 3.7861801288385085e-07 0 3.7862801288385086e-07 0.00021 3.7863801288385087e-07 0 3.7863801288385087e-07 0 3.786480128838509e-07 0.00021 3.786580128838509e-07 0 3.786580128838509e-07 0 3.786680128838509e-07 0.00021 3.786780128838509e-07 0 3.7869067314000985e-07 0 3.7870067314000986e-07 0.00021 3.787106731400099e-07 0 3.787106731400099e-07 0 3.787206731400099e-07 0.00021 3.787306731400099e-07 0 3.787775215798137e-07 0 3.787875215798137e-07 0.00021 3.7879752157981373e-07 0 3.788195029285013e-07 0 3.788295029285013e-07 0.00021 3.7883950292850133e-07 0 3.7885129743932484e-07 0 3.7886129743932485e-07 0.00021 3.7887129743932486e-07 0 3.7887129743932486e-07 0 3.7888129743932487e-07 0.00021 3.788912974393249e-07 0 3.788912974393249e-07 0 3.789012974393249e-07 0.00021 3.789112974393249e-07 0 3.7893834730283934e-07 0 3.7894834730283935e-07 0.00021 3.7895834730283936e-07 0 3.7899239576382836e-07 0 3.7900239576382837e-07 0.00021 3.790123957638284e-07 0 3.790123957638284e-07 0 3.790223957638284e-07 0.00021 3.790323957638284e-07 0 3.791707884444361e-07 0 3.791807884444361e-07 0.00021 3.791907884444361e-07 0 3.791907884444361e-07 0 3.7920078844443613e-07 0.00021 3.7921078844443614e-07 0 3.7921078844443614e-07 0 3.7922078844443615e-07 0.00021 3.7923078844443616e-07 0 3.7923078844443616e-07 0 3.792407884444362e-07 0.00021 3.792507884444362e-07 0 3.793150528076037e-07 0 3.793250528076037e-07 0.00021 3.7933505280760373e-07 0 3.7937294373784005e-07 0 3.7938294373784006e-07 0.00021 3.7939294373784007e-07 0 3.794186269558414e-07 0 3.794286269558414e-07 0.00021 3.7943862695584143e-07 0 3.794397906486886e-07 0 3.794497906486886e-07 0.00021 3.794597906486886e-07 0 3.7953530097262005e-07 0 3.7954530097262007e-07 0.00021 3.795553009726201e-07 0 3.795553009726201e-07 0 3.795653009726201e-07 0.00021 3.795753009726201e-07 0 3.795753009726201e-07 0 3.795853009726201e-07 0.00021 3.795953009726201e-07 0 3.796114897845733e-07 0 3.7962148978457333e-07 0.00021 3.7963148978457334e-07 0 3.7965986014585433e-07 0 3.7966986014585434e-07 0.00021 3.7967986014585435e-07 0 3.79736378901975e-07 0 3.7974637890197504e-07 0.00021 3.7975637890197505e-07 0 3.7979520641950474e-07 0 3.7980520641950475e-07 0.00021 3.7981520641950476e-07 0 3.7981520641950476e-07 0 3.798252064195048e-07 0.00021 3.798352064195048e-07 0 3.798352064195048e-07 0 3.798452064195048e-07 0.00021 3.798552064195048e-07 0 3.798552064195048e-07 0 3.798652064195048e-07 0.00021 3.7987520641950483e-07 0 3.800001989153841e-07 0 3.800101989153841e-07 0.00021 3.800201989153841e-07 0 3.8002818523608394e-07 0 3.8003818523608395e-07 0.00021 3.8004818523608396e-07 0 3.8004818523608396e-07 0 3.80058185236084e-07 0.00021 3.80068185236084e-07 0 3.80068185236084e-07 0 3.80078185236084e-07 0.00021 3.80088185236084e-07 0 3.80088185236084e-07 0 3.80098185236084e-07 0.00021 3.8010818523608403e-07 0 3.8013224262430244e-07 0 3.8014224262430245e-07 0.00021 3.8015224262430246e-07 0 3.8015224262430246e-07 0 3.801622426243025e-07 0.00021 3.801722426243025e-07 0 3.801722426243025e-07 0 3.801822426243025e-07 0.00021 3.801922426243025e-07 0 3.801922426243025e-07 0 3.802022426243025e-07 0.00021 3.8021224262430253e-07 0 3.8021224262430253e-07 0 3.8022224262430254e-07 0.00021 3.8023224262430255e-07 0 3.8023454649624705e-07 0 3.8024454649624706e-07 0.00021 3.8025454649624707e-07 0 3.8025454649624707e-07 0 3.802645464962471e-07 0.00021 3.802745464962471e-07 0 3.8027653013009645e-07 0 3.8028653013009646e-07 0.00021 3.802965301300965e-07 0 3.802965301300965e-07 0 3.803065301300965e-07 0.00021 3.803165301300965e-07 0 3.803165301300965e-07 0 3.803265301300965e-07 0.00021 3.803365301300965e-07 0 3.803365301300965e-07 0 3.8034653013009653e-07 0.00021 3.8035653013009654e-07 0 3.804445805671264e-07 0 3.804545805671264e-07 0.00021 3.804645805671264e-07 0 3.804673144703859e-07 0 3.804773144703859e-07 0.00021 3.804873144703859e-07 0 3.804873144703859e-07 0 3.8049731447038593e-07 0.00021 3.8050731447038594e-07 0 3.8050731447038594e-07 0 3.8051731447038595e-07 0.00021 3.8052731447038596e-07 0 3.8052731447038596e-07 0 3.8053731447038597e-07 0.00021 3.80547314470386e-07 0 3.80547314470386e-07 0 3.80557314470386e-07 0.00021 3.80567314470386e-07 0 3.805917920531312e-07 0 3.806017920531312e-07 0.00021 3.806117920531312e-07 0 3.8068924236744814e-07 0 3.8069924236744815e-07 0.00021 3.8070924236744816e-07 0 3.807371685804987e-07 0 3.807471685804987e-07 0.00021 3.807571685804987e-07 0 3.807571685804987e-07 0 3.807671685804987e-07 0.00021 3.8077716858049873e-07 0 3.8078659878886953e-07 0 3.8079659878886954e-07 0.00021 3.8080659878886955e-07 0 3.808798738957156e-07 0 3.808898738957156e-07 0.00021 3.8089987389571563e-07 0 3.809843185103768e-07 0 3.809943185103768e-07 0.00021 3.810043185103768e-07 0 3.8109747204141105e-07 0 3.8110747204141106e-07 0.00021 3.8111747204141107e-07 0 3.811503669319929e-07 0 3.811603669319929e-07 0.00021 3.811703669319929e-07 0 3.8119399338864055e-07 0 3.8120399338864056e-07 0.00021 3.8121399338864057e-07 0 3.8121399338864057e-07 0 3.812239933886406e-07 0.00021 3.812339933886406e-07 0 3.812339933886406e-07 0 3.812439933886406e-07 0.00021 3.812539933886406e-07 0 3.812539933886406e-07 0 3.812639933886406e-07 0.00021 3.8127399338864064e-07 0 3.8127399338864064e-07 0 3.8128399338864065e-07 0.00021 3.8129399338864066e-07 0 3.8129399338864066e-07 0 3.8130399338864067e-07 0.00021 3.813139933886407e-07 0 3.813139933886407e-07 0 3.813239933886407e-07 0.00021 3.813339933886407e-07 0 3.813339933886407e-07 0 3.813439933886407e-07 0.00021 3.8135399338864073e-07 0 3.814164016633802e-07 0 3.8142640166338023e-07 0.00021 3.8143640166338024e-07 0 3.8147101404603445e-07 0 3.8148101404603446e-07 0.00021 3.814910140460345e-07 0 3.815029930919876e-07 0 3.815129930919876e-07 0.00021 3.815229930919876e-07 0 3.815684922980672e-07 0 3.8157849229806723e-07 0.00021 3.8158849229806724e-07 0 3.816492436805644e-07 0 3.816592436805644e-07 0.00021 3.816692436805644e-07 0 3.816692436805644e-07 0 3.816792436805644e-07 0.00021 3.8168924368056443e-07 0 3.8168924368056443e-07 0 3.8169924368056444e-07 0.00021 3.8170924368056445e-07 0 3.8177036539157545e-07 0 3.8178036539157547e-07 0.00021 3.817903653915755e-07 0 3.817903653915755e-07 0 3.818003653915755e-07 0.00021 3.818103653915755e-07 0 3.818103653915755e-07 0 3.818203653915755e-07 0.00021 3.818303653915755e-07 0 3.818436584320161e-07 0 3.818536584320161e-07 0.00021 3.818636584320161e-07 0 3.818636584320161e-07 0 3.8187365843201613e-07 0.00021 3.8188365843201614e-07 0 3.8188365843201614e-07 0 3.8189365843201615e-07 0.00021 3.8190365843201616e-07 0 3.8190365843201616e-07 0 3.819136584320162e-07 0.00021 3.819236584320162e-07 0 3.819236584320162e-07 0 3.819336584320162e-07 0.00021 3.819436584320162e-07 0 3.819436584320162e-07 0 3.819536584320162e-07 0.00021 3.8196365843201623e-07 0 3.8196365843201623e-07 0 3.8197365843201624e-07 0.00021 3.8198365843201626e-07 0 3.8198365843201626e-07 0 3.8199365843201627e-07 0.00021 3.820036584320163e-07 0 3.820036584320163e-07 0 3.820136584320163e-07 0.00021 3.820236584320163e-07 0 3.820236584320163e-07 0 3.820336584320163e-07 0.00021 3.820436584320163e-07 0 3.8207689546870235e-07 0 3.8208689546870236e-07 0.00021 3.8209689546870237e-07 0 3.8211719395363646e-07 0 3.8212719395363647e-07 0.00021 3.821371939536365e-07 0 3.821371939536365e-07 0 3.821471939536365e-07 0.00021 3.821571939536365e-07 0 3.821577560758531e-07 0 3.821677560758531e-07 0.00021 3.8217775607585313e-07 0 3.821862233328468e-07 0 3.821962233328468e-07 0.00021 3.8220622333284683e-07 0 3.822136301546449e-07 0 3.822236301546449e-07 0.00021 3.822336301546449e-07 0 3.8229916946940594e-07 0 3.8230916946940596e-07 0.00021 3.8231916946940597e-07 0 3.8232935069745755e-07 0 3.8233935069745756e-07 0.00021 3.8234935069745757e-07 0 3.823851762453049e-07 0 3.8239517624530493e-07 0.00021 3.8240517624530494e-07 0 3.8244183635904257e-07 0 3.824518363590426e-07 0.00021 3.824618363590426e-07 0 3.824618363590426e-07 0 3.824718363590426e-07 0.00021 3.824818363590426e-07 0 3.824818363590426e-07 0 3.824918363590426e-07 0.00021 3.8250183635904264e-07 0 3.8250183635904264e-07 0 3.8251183635904265e-07 0.00021 3.8252183635904266e-07 0 3.8252183635904266e-07 0 3.8253183635904267e-07 0.00021 3.825418363590427e-07 0 3.825418363590427e-07 0 3.825518363590427e-07 0.00021 3.825618363590427e-07 0 3.825618363590427e-07 0 3.825718363590427e-07 0.00021 3.825818363590427e-07 0 3.825818363590427e-07 0 3.8259183635904274e-07 0.00021 3.8260183635904275e-07 0 3.8260265843618544e-07 0 3.8261265843618546e-07 0.00021 3.8262265843618547e-07 0 3.827026269335268e-07 0 3.8271262693352683e-07 0.00021 3.8272262693352684e-07 0 3.8272262693352684e-07 0 3.8273262693352685e-07 0.00021 3.8274262693352686e-07 0 3.8274262693352686e-07 0 3.827526269335269e-07 0.00021 3.827626269335269e-07 0 3.827626269335269e-07 0 3.827726269335269e-07 0.00021 3.827826269335269e-07 0 3.827826269335269e-07 0 3.827926269335269e-07 0.00021 3.8280262693352693e-07 0 3.8280262693352693e-07 0 3.8281262693352694e-07 0.00021 3.8282262693352696e-07 0 3.8282262693352696e-07 0 3.8283262693352697e-07 0.00021 3.82842626933527e-07 0 3.82842626933527e-07 0 3.82852626933527e-07 0.00021 3.82862626933527e-07 0 3.828731980863139e-07 0 3.8288319808631393e-07 0.00021 3.8289319808631394e-07 0 3.8289319808631394e-07 0 3.8290319808631396e-07 0.00021 3.8291319808631397e-07 0 3.829775368918824e-07 0 3.829875368918824e-07 0.00021 3.829975368918824e-07 0 3.830036227212268e-07 0 3.830136227212268e-07 0.00021 3.830236227212268e-07 0 3.83072984561174e-07 0 3.8308298456117403e-07 0.00021 3.8309298456117404e-07 0 3.8311013273385997e-07 0 3.8312013273386e-07 0.00021 3.8313013273386e-07 0 3.8313013273386e-07 0 3.8314013273386e-07 0.00021 3.8315013273386e-07 0 3.8315420300548617e-07 0 3.831642030054862e-07 0.00021 3.831742030054862e-07 0 3.831742030054862e-07 0 3.831842030054862e-07 0.00021 3.831942030054862e-07 0 3.831942030054862e-07 0 3.832042030054862e-07 0.00021 3.8321420300548623e-07 0 3.8321420300548623e-07 0 3.8322420300548625e-07 0.00021 3.8323420300548626e-07 0 3.8323420300548626e-07 0 3.8324420300548627e-07 0.00021 3.832542030054863e-07 0 3.832542030054863e-07 0 3.832642030054863e-07 0.00021 3.832742030054863e-07 0 3.832742030054863e-07 0 3.832842030054863e-07 0.00021 3.832942030054863e-07 0 3.832942030054863e-07 0 3.8330420300548634e-07 0.00021 3.8331420300548635e-07 0 3.8331420300548635e-07 0 3.8332420300548636e-07 0.00021 3.8333420300548637e-07 0 3.8333420300548637e-07 0 3.833442030054864e-07 0.00021 3.833542030054864e-07 0 3.833542030054864e-07 0 3.833642030054864e-07 0.00021 3.833742030054864e-07 0 3.833742030054864e-07 0 3.8338420300548643e-07 0.00021 3.8339420300548644e-07 0 3.8350742520324884e-07 0 3.8351742520324885e-07 0.00021 3.8352742520324886e-07 0 3.8352742520324886e-07 0 3.8353742520324887e-07 0.00021 3.835474252032489e-07 0 3.835474252032489e-07 0 3.835574252032489e-07 0.00021 3.835674252032489e-07 0 3.835674252032489e-07 0 3.835774252032489e-07 0.00021 3.8358742520324893e-07 0 3.836007633502201e-07 0 3.836107633502201e-07 0.00021 3.836207633502201e-07 0 3.8362173859690226e-07 0 3.8363173859690227e-07 0.00021 3.836417385969023e-07 0 3.836417385969023e-07 0 3.836517385969023e-07 0.00021 3.836617385969023e-07 0 3.836617385969023e-07 0 3.836717385969023e-07 0.00021 3.8368173859690233e-07 0 3.837317167260233e-07 0 3.8374171672602333e-07 0.00021 3.8375171672602334e-07 0 3.8378271316166736e-07 0 3.837927131616674e-07 0.00021 3.838027131616674e-07 0 3.838027131616674e-07 0 3.838127131616674e-07 0.00021 3.838227131616674e-07 0 3.838263197004455e-07 0 3.838363197004455e-07 0.00021 3.838463197004455e-07 0 3.838463197004455e-07 0 3.838563197004455e-07 0.00021 3.8386631970044553e-07 0 3.838880095267695e-07 0 3.838980095267695e-07 0.00021 3.839080095267695e-07 0 3.8393478295140345e-07 0 3.8394478295140346e-07 0.00021 3.839547829514035e-07 0 3.8401616657935427e-07 0 3.840261665793543e-07 0.00021 3.840361665793543e-07 0 3.840361665793543e-07 0 3.840461665793543e-07 0.00021 3.840561665793543e-07 0 3.840561665793543e-07 0 3.840661665793543e-07 0.00021 3.8407616657935433e-07 0 3.841273075090973e-07 0 3.841373075090973e-07 0.00021 3.8414730750909733e-07 0 3.8414730750909733e-07 0 3.8415730750909734e-07 0.00021 3.8416730750909735e-07 0 3.8416730750909735e-07 0 3.8417730750909736e-07 0.00021 3.841873075090974e-07 0 3.841873075090974e-07 0 3.841973075090974e-07 0.00021 3.842073075090974e-07 0 3.842073075090974e-07 0 3.842173075090974e-07 0.00021 3.842273075090974e-07 0 3.842273075090974e-07 0 3.8423730750909743e-07 0.00021 3.8424730750909744e-07 0 3.8424730750909744e-07 0 3.8425730750909745e-07 0.00021 3.8426730750909746e-07 0 3.8426730750909746e-07 0 3.842773075090975e-07 0.00021 3.842873075090975e-07 0 3.842972988956493e-07 0 3.8430729889564933e-07 0.00021 3.8431729889564934e-07 0 3.8431729889564934e-07 0 3.8432729889564935e-07 0.00021 3.8433729889564936e-07 0 3.8433729889564936e-07 0 3.8434729889564937e-07 0.00021 3.843572988956494e-07 0 3.843572988956494e-07 0 3.843672988956494e-07 0.00021 3.843772988956494e-07 0 3.843772988956494e-07 0 3.843872988956494e-07 0.00021 3.8439729889564943e-07 0 3.8439729889564943e-07 0 3.8440729889564944e-07 0.00021 3.8441729889564945e-07 0 3.8441729889564945e-07 0 3.8442729889564946e-07 0.00021 3.844372988956495e-07 0 3.8448400636319877e-07 0 3.844940063631988e-07 0.00021 3.845040063631988e-07 0 3.8453393581178997e-07 0 3.8454393581179e-07 0.00021 3.8455393581179e-07 0 3.845632162183704e-07 0 3.845732162183704e-07 0.00021 3.8458321621837043e-07 0 3.8459816614066455e-07 0 3.8460816614066456e-07 0.00021 3.8461816614066457e-07 0 3.8461816614066457e-07 0 3.846281661406646e-07 0.00021 3.846381661406646e-07 0 3.8487036398888876e-07 0 3.8488036398888877e-07 0.00021 3.848903639888888e-07 0 3.8494175030547343e-07 0 3.8495175030547344e-07 0.00021 3.8496175030547346e-07 0 3.8496175030547346e-07 0 3.8497175030547347e-07 0.00021 3.849817503054735e-07 0 3.85012915494372e-07 0 3.85022915494372e-07 0.00021 3.8503291549437204e-07 0 3.850566420893019e-07 0 3.8506664208930193e-07 0.00021 3.8507664208930194e-07 0 3.8507664208930194e-07 0 3.8508664208930195e-07 0.00021 3.8509664208930196e-07 0 3.85186919454933e-07 0 3.85196919454933e-07 0.00021 3.85206919454933e-07 0 3.8521676551217056e-07 0 3.852267655121706e-07 0.00021 3.852367655121706e-07 0 3.852396391002794e-07 0 3.8524963910027944e-07 0.00021 3.8525963910027945e-07 0 3.8527011905673783e-07 0 3.8528011905673784e-07 0.00021 3.8529011905673785e-07 0 3.8531998318105764e-07 0 3.8532998318105765e-07 0.00021 3.8533998318105766e-07 0 3.8533998318105766e-07 0 3.8534998318105767e-07 0.00021 3.853599831810577e-07 0 3.853599831810577e-07 0 3.853699831810577e-07 0.00021 3.853799831810577e-07 0 3.853799831810577e-07 0 3.853899831810577e-07 0.00021 3.8539998318105773e-07 0 3.854137954876393e-07 0 3.854237954876393e-07 0.00021 3.8543379548763934e-07 0 3.8543379548763934e-07 0 3.8544379548763935e-07 0.00021 3.8545379548763936e-07 0 3.8545379548763936e-07 0 3.8546379548763937e-07 0.00021 3.854737954876394e-07 0 3.854765461147548e-07 0 3.854865461147548e-07 0.00021 3.8549654611475483e-07 0 3.8549654611475483e-07 0 3.8550654611475484e-07 0.00021 3.8551654611475485e-07 0 3.8551661586210566e-07 0 3.855266158621057e-07 0.00021 3.855366158621057e-07 0 3.8555156390049027e-07 0 3.855615639004903e-07 0.00021 3.855715639004903e-07 0 3.855715639004903e-07 0 3.855815639004903e-07 0.00021 3.855915639004903e-07 0 3.8559548604380595e-07 0 3.8560548604380596e-07 0.00021 3.8561548604380597e-07 0 3.8563803852253556e-07 0 3.8564803852253557e-07 0.00021 3.856580385225356e-07 0 3.856580385225356e-07 0 3.856680385225356e-07 0.00021 3.856780385225356e-07 0 3.856780385225356e-07 0 3.856880385225356e-07 0.00021 3.8569803852253563e-07 0 3.857525339464077e-07 0 3.857625339464077e-07 0.00021 3.857725339464077e-07 0 3.857936533552647e-07 0 3.858036533552647e-07 0.00021 3.8581365335526473e-07 0 3.858497427563833e-07 0 3.8585974275638333e-07 0.00021 3.8586974275638334e-07 0 3.8586974275638334e-07 0 3.8587974275638335e-07 0.00021 3.8588974275638336e-07 0 3.8588974275638336e-07 0 3.858997427563834e-07 0.00021 3.859097427563834e-07 0 3.859097427563834e-07 0 3.859197427563834e-07 0.00021 3.859297427563834e-07 0 3.859297427563834e-07 0 3.859397427563834e-07 0.00021 3.8594974275638343e-07 0 3.8594974275638343e-07 0 3.8595974275638344e-07 0.00021 3.8596974275638345e-07 0 3.8596974275638345e-07 0 3.8597974275638346e-07 0.00021 3.859897427563835e-07 0 3.859897427563835e-07 0 3.859997427563835e-07 0.00021 3.860097427563835e-07 0 3.860097427563835e-07 0 3.860197427563835e-07 0.00021 3.860297427563835e-07 0 3.860297427563835e-07 0 3.8603974275638353e-07 0.00021 3.8604974275638354e-07 0 3.860600555850539e-07 0 3.860700555850539e-07 0.00021 3.8608005558505393e-07 0 3.8616480028153676e-07 0 3.861748002815368e-07 0.00021 3.861848002815368e-07 0 3.861848002815368e-07 0 3.861948002815368e-07 0.00021 3.862048002815368e-07 0 3.862048002815368e-07 0 3.862148002815368e-07 0.00021 3.8622480028153683e-07 0 3.8627949886095263e-07 0 3.8628949886095264e-07 0.00021 3.8629949886095265e-07 0 3.863653829083478e-07 0 3.8637538290834784e-07 0.00021 3.8638538290834785e-07 0 3.8643205853151333e-07 0 3.8644205853151335e-07 0.00021 3.8645205853151336e-07 0 3.8645205853151336e-07 0 3.8646205853151337e-07 0.00021 3.864720585315134e-07 0 3.8647827391154873e-07 0 3.8648827391154874e-07 0.00021 3.8649827391154876e-07 0 3.8649827391154876e-07 0 3.8650827391154877e-07 0.00021 3.865182739115488e-07 0 3.865182739115488e-07 0 3.865282739115488e-07 0.00021 3.865382739115488e-07 0 3.865382739115488e-07 0 3.865482739115488e-07 0.00021 3.865582739115488e-07 0 3.865807814511848e-07 0 3.865907814511848e-07 0.00021 3.866007814511848e-07 0 3.866116700095341e-07 0 3.866216700095341e-07 0.00021 3.8663167000953413e-07 0 3.8665988138816845e-07 0 3.8666988138816846e-07 0.00021 3.866798813881685e-07 0 3.866798813881685e-07 0 3.866898813881685e-07 0.00021 3.866998813881685e-07 0 3.866998813881685e-07 0 3.867098813881685e-07 0.00021 3.867198813881685e-07 0 3.867198813881685e-07 0 3.8672988138816853e-07 0.00021 3.8673988138816854e-07 0 3.867757139191063e-07 0 3.867857139191063e-07 0.00021 3.867957139191063e-07 0 3.867957139191063e-07 0 3.868057139191063e-07 0.00021 3.868157139191063e-07 0 3.868157139191063e-07 0 3.8682571391910634e-07 0.00021 3.8683571391910635e-07 0 3.8683571391910635e-07 0 3.8684571391910636e-07 0.00021 3.8685571391910637e-07 0 3.868563873874786e-07 0 3.868663873874786e-07 0.00021 3.868763873874786e-07 0 3.869264439802042e-07 0 3.869364439802042e-07 0.00021 3.8694644398020423e-07 0 3.869680695384678e-07 0 3.869780695384678e-07 0.00021 3.8698806953846783e-07 0 3.8703689069299683e-07 0 3.8704689069299684e-07 0.00021 3.8705689069299685e-07 0 3.8705689069299685e-07 0 3.8706689069299686e-07 0.00021 3.8707689069299687e-07 0 3.8707689069299687e-07 0 3.870868906929969e-07 0.00021 3.870968906929969e-07 0 3.870968906929969e-07 0 3.871068906929969e-07 0.00021 3.871168906929969e-07 0 3.871447123568839e-07 0 3.871547123568839e-07 0.00021 3.871647123568839e-07 0 3.871647123568839e-07 0 3.871747123568839e-07 0.00021 3.8718471235688394e-07 0 3.871921145366774e-07 0 3.872021145366774e-07 0.00021 3.872121145366774e-07 0 3.8721530434642383e-07 0 3.8722530434642384e-07 0.00021 3.8723530434642385e-07 0 3.8723530434642385e-07 0 3.8724530434642386e-07 0.00021 3.872553043464239e-07 0 3.872553043464239e-07 0 3.872653043464239e-07 0.00021 3.872753043464239e-07 0 3.872753043464239e-07 0 3.872853043464239e-07 0.00021 3.872953043464239e-07 0 3.872968168059774e-07 0 3.873068168059774e-07 0.00021 3.873168168059774e-07 0 3.873318662375879e-07 0 3.873418662375879e-07 0.00021 3.873518662375879e-07 0 3.873518662375879e-07 0 3.873618662375879e-07 0.00021 3.873718662375879e-07 0 3.873718662375879e-07 0 3.8738186623758794e-07 0.00021 3.8739186623758795e-07 0 3.8739186623758795e-07 0 3.8740186623758796e-07 0.00021 3.8741186623758797e-07 0 3.8741186623758797e-07 0 3.87421866237588e-07 0.00021 3.87431866237588e-07 0 3.87431866237588e-07 0 3.87441866237588e-07 0.00021 3.87451866237588e-07 0 3.87451866237588e-07 0 3.87461866237588e-07 0.00021 3.8747186623758804e-07 0 3.8747186623758804e-07 0 3.8748186623758805e-07 0.00021 3.8749186623758806e-07 0 3.8749186623758806e-07 0 3.8750186623758807e-07 0.00021 3.875118662375881e-07 0 3.875118662375881e-07 0 3.875218662375881e-07 0.00021 3.875318662375881e-07 0 3.875318662375881e-07 0 3.875418662375881e-07 0.00021 3.8755186623758813e-07 0 3.8755186623758813e-07 0 3.8756186623758814e-07 0.00021 3.8757186623758815e-07 0 3.8757186623758815e-07 0 3.8758186623758816e-07 0.00021 3.8759186623758817e-07 0 3.8759186623758817e-07 0 3.876018662375882e-07 0.00021 3.876118662375882e-07 0 3.876118662375882e-07 0 3.876218662375882e-07 0.00021 3.876318662375882e-07 0 3.876318662375882e-07 0 3.8764186623758823e-07 0.00021 3.8765186623758824e-07 0 3.8765186623758824e-07 0 3.8766186623758825e-07 0.00021 3.8767186623758826e-07 0 3.8767186623758826e-07 0 3.876818662375883e-07 0.00021 3.876918662375883e-07 0 3.876918662375883e-07 0 3.877018662375883e-07 0.00021 3.877118662375883e-07 0 3.877118662375883e-07 0 3.877218662375883e-07 0.00021 3.8773186623758833e-07 0 3.8773186623758833e-07 0 3.8774186623758834e-07 0.00021 3.8775186623758835e-07 0 3.8775186623758835e-07 0 3.8776186623758837e-07 0.00021 3.877718662375884e-07 0 3.877718662375884e-07 0 3.877818662375884e-07 0.00021 3.877918662375884e-07 0 3.8779204967979246e-07 0 3.8780204967979247e-07 0.00021 3.878120496797925e-07 0 3.878120496797925e-07 0 3.878220496797925e-07 0.00021 3.878320496797925e-07 0 3.878320496797925e-07 0 3.878420496797925e-07 0.00021 3.8785204967979253e-07 0 3.8785204967979253e-07 0 3.8786204967979254e-07 0.00021 3.8787204967979255e-07 0 3.8787204967979255e-07 0 3.8788204967979256e-07 0.00021 3.878920496797926e-07 0 3.8789656218815635e-07 0 3.8790656218815636e-07 0.00021 3.8791656218815637e-07 0 3.8791656218815637e-07 0 3.879265621881564e-07 0.00021 3.879365621881564e-07 0 3.879365621881564e-07 0 3.879465621881564e-07 0.00021 3.879565621881564e-07 0 3.879565621881564e-07 0 3.8796656218815643e-07 0.00021 3.8797656218815644e-07 0 3.8797656218815644e-07 0 3.8798656218815645e-07 0.00021 3.8799656218815646e-07 0 3.8799656218815646e-07 0 3.8800656218815647e-07 0.00021 3.880165621881565e-07 0 3.880165621881565e-07 0 3.880265621881565e-07 0.00021 3.880365621881565e-07 0 3.880484122400932e-07 0 3.880584122400932e-07 0.00021 3.880684122400932e-07 0 3.881053770290474e-07 0 3.8811537702904743e-07 0.00021 3.8812537702904744e-07 0 3.8812537702904744e-07 0 3.8813537702904745e-07 0.00021 3.8814537702904746e-07 0 3.88145592397402e-07 0 3.88155592397402e-07 0.00021 3.8816559239740204e-07 0 3.881851770524333e-07 0 3.881951770524333e-07 0.00021 3.8820517705243333e-07 0 3.8821051224017054e-07 0 3.8822051224017055e-07 0.00021 3.8823051224017056e-07 0 3.882313950148787e-07 0 3.8824139501487873e-07 0.00021 3.8825139501487875e-07 0 3.8825139501487875e-07 0 3.8826139501487876e-07 0.00021 3.8827139501487877e-07 0 3.8835183917386723e-07 0 3.8836183917386724e-07 0.00021 3.8837183917386725e-07 0 3.883793711505298e-07 0 3.883893711505298e-07 0.00021 3.8839937115052983e-07 0 3.8839937115052983e-07 0 3.8840937115052984e-07 0.00021 3.8841937115052985e-07 0 3.884221258367423e-07 0 3.884321258367423e-07 0.00021 3.884421258367423e-07 0 3.884421258367423e-07 0 3.8845212583674234e-07 0.00021 3.8846212583674235e-07 0 3.884959967043143e-07 0 3.885059967043143e-07 0.00021 3.885159967043143e-07 0 3.885159967043143e-07 0 3.8852599670431433e-07 0.00021 3.8853599670431435e-07 0 3.885828923363841e-07 0 3.885928923363841e-07 0.00021 3.8860289233638413e-07 0 3.8860289233638413e-07 0 3.8861289233638415e-07 0.00021 3.8862289233638416e-07 0 3.8862289233638416e-07 0 3.8863289233638417e-07 0.00021 3.886428923363842e-07 0 3.886754280342102e-07 0 3.886854280342102e-07 0.00021 3.886954280342102e-07 0 3.887005425169166e-07 0 3.887105425169166e-07 0.00021 3.8872054251691664e-07 0 3.887271796505584e-07 0 3.887371796505584e-07 0.00021 3.8874717965055843e-07 0 3.8874811498316027e-07 0 3.887581149831603e-07 0.00021 3.887681149831603e-07 0 3.887681149831603e-07 0 3.887781149831603e-07 0.00021 3.887881149831603e-07 0 3.8880176181369444e-07 0 3.8881176181369445e-07 0.00021 3.8882176181369446e-07 0 3.8883529661047556e-07 0 3.8884529661047557e-07 0.00021 3.888552966104756e-07 0 3.8886693954644136e-07 0 3.888769395464414e-07 0.00021 3.888869395464414e-07 0 3.888869395464414e-07 0 3.888969395464414e-07 0.00021 3.889069395464414e-07 0 3.889199440443835e-07 0 3.889299440443835e-07 0.00021 3.889399440443835e-07 0 3.8895288056703167e-07 0 3.889628805670317e-07 0.00021 3.889728805670317e-07 0 3.8898697786046714e-07 0 3.8899697786046715e-07 0.00021 3.8900697786046716e-07 0 3.8900697786046716e-07 0 3.8901697786046717e-07 0.00021 3.890269778604672e-07 0 3.890269778604672e-07 0 3.890369778604672e-07 0.00021 3.890469778604672e-07 0 3.890469778604672e-07 0 3.890569778604672e-07 0.00021 3.8906697786046723e-07 0 3.8906697786046723e-07 0 3.8907697786046724e-07 0.00021 3.8908697786046725e-07 0 3.891205959590816e-07 0 3.891305959590816e-07 0.00021 3.8914059595908163e-07 0 3.8914606273132425e-07 0 3.8915606273132426e-07 0.00021 3.8916606273132427e-07 0 3.8922000909152426e-07 0 3.8923000909152427e-07 0.00021 3.892400090915243e-07 0 3.892638920349926e-07 0 3.892738920349926e-07 0.00021 3.892838920349926e-07 0 3.89524543808128e-07 0 3.89534543808128e-07 0.00021 3.8954454380812803e-07 0 3.895739377881181e-07 0 3.895839377881181e-07 0.00021 3.895939377881181e-07 0 3.8960898990916206e-07 0 3.896189899091621e-07 0.00021 3.896289899091621e-07 0 3.896289899091621e-07 0 3.896389899091621e-07 0.00021 3.896489899091621e-07 0 3.896586450535317e-07 0 3.896686450535317e-07 0.00021 3.8967864505353173e-07 0 3.896979275803757e-07 0 3.897079275803757e-07 0.00021 3.897179275803757e-07 0 3.897394059194623e-07 0 3.8974940591946233e-07 0.00021 3.8975940591946234e-07 0 3.8975940591946234e-07 0 3.8976940591946235e-07 0.00021 3.8977940591946236e-07 0 3.897801041377831e-07 0 3.897901041377831e-07 0.00021 3.898001041377831e-07 0 3.8980316150790143e-07 0 3.8981316150790144e-07 0.00021 3.8982316150790145e-07 0 3.8982316150790145e-07 0 3.8983316150790147e-07 0.00021 3.898431615079015e-07 0 3.898973737070978e-07 0 3.899073737070978e-07 0.00021 3.899173737070978e-07 0 3.899486796485598e-07 0 3.899586796485598e-07 0.00021 3.899686796485598e-07 0 3.899686796485598e-07 0 3.899786796485598e-07 0.00021 3.899886796485598e-07 0 3.9003535879501264e-07 0 3.9004535879501265e-07 0.00021 3.9005535879501267e-07 0 3.9005535879501267e-07 0 3.900653587950127e-07 0.00021 3.900753587950127e-07 0 3.900812169417181e-07 0 3.900912169417181e-07 0.00021 3.901012169417181e-07 0 3.901012169417181e-07 0 3.901112169417181e-07 0.00021 3.901212169417181e-07 0 3.901284991056762e-07 0 3.9013849910567623e-07 0.00021 3.9014849910567624e-07 0 3.9014849910567624e-07 0 3.9015849910567626e-07 0.00021 3.9016849910567627e-07 0 3.9016849910567627e-07 0 3.901784991056763e-07 0.00021 3.901884991056763e-07 0 3.901884991056763e-07 0 3.901984991056763e-07 0.00021 3.902084991056763e-07 0 3.902084991056763e-07 0 3.902184991056763e-07 0.00021 3.9022849910567634e-07 0 3.9022849910567634e-07 0 3.9023849910567635e-07 0.00021 3.9024849910567636e-07 0 3.9024849910567636e-07 0 3.9025849910567637e-07 0.00021 3.902684991056764e-07 0 3.903007875770761e-07 0 3.9031078757707614e-07 0.00021 3.9032078757707615e-07 0 3.9032078757707615e-07 0 3.9033078757707616e-07 0.00021 3.9034078757707617e-07 0 3.903892013477582e-07 0 3.9039920134775823e-07 0.00021 3.9040920134775824e-07 0 3.9040920134775824e-07 0 3.9041920134775826e-07 0.00021 3.9042920134775827e-07 0 3.904346901993287e-07 0 3.9044469019932873e-07 0.00021 3.9045469019932874e-07 0 3.905245458506629e-07 0 3.905345458506629e-07 0.00021 3.9054454585066293e-07 0 3.9054454585066293e-07 0 3.9055454585066294e-07 0.00021 3.9056454585066295e-07 0 3.9056454585066295e-07 0 3.9057454585066297e-07 0.00021 3.90584545850663e-07 0 3.90584545850663e-07 0 3.90594545850663e-07 0.00021 3.90604545850663e-07 0 3.906553600596869e-07 0 3.906653600596869e-07 0.00021 3.906753600596869e-07 0 3.906753600596869e-07 0 3.9068536005968693e-07 0.00021 3.9069536005968695e-07 0 3.9069536005968695e-07 0 3.9070536005968696e-07 0.00021 3.9071536005968697e-07 0 3.9072362511450706e-07 0 3.907336251145071e-07 0.00021 3.907436251145071e-07 0 3.907436251145071e-07 0 3.907536251145071e-07 0.00021 3.907636251145071e-07 0 3.907636251145071e-07 0 3.907736251145071e-07 0.00021 3.9078362511450713e-07 0 3.9078362511450713e-07 0 3.9079362511450714e-07 0.00021 3.9080362511450715e-07 0 3.908532964588585e-07 0 3.908632964588585e-07 0.00021 3.908732964588585e-07 0 3.908732964588585e-07 0 3.908832964588585e-07 0.00021 3.908932964588585e-07 0 3.909036638438226e-07 0 3.9091366384382264e-07 0.00021 3.9092366384382265e-07 0 3.9094420909876097e-07 0 3.90954209098761e-07 0.00021 3.90964209098761e-07 0 3.90964209098761e-07 0 3.90974209098761e-07 0.00021 3.90984209098761e-07 0 3.910873114816933e-07 0 3.9109731148169333e-07 0.00021 3.9110731148169334e-07 0 3.9110731148169334e-07 0 3.9111731148169335e-07 0.00021 3.9112731148169337e-07 0 3.9112731148169337e-07 0 3.911373114816934e-07 0.00021 3.911473114816934e-07 0 3.912066879184024e-07 0 3.912166879184024e-07 0.00021 3.912266879184024e-07 0 3.912266879184024e-07 0 3.912366879184024e-07 0.00021 3.912466879184024e-07 0 3.912466879184024e-07 0 3.9125668791840243e-07 0.00021 3.9126668791840244e-07 0 3.9126668791840244e-07 0 3.9127668791840245e-07 0.00021 3.9128668791840247e-07 0 3.9128668791840247e-07 0 3.912966879184025e-07 0.00021 3.913066879184025e-07 0 3.913066879184025e-07 0 3.913166879184025e-07 0.00021 3.913266879184025e-07 0 3.913266879184025e-07 0 3.913366879184025e-07 0.00021 3.9134668791840253e-07 0 3.9134668791840253e-07 0 3.9135668791840255e-07 0.00021 3.9136668791840256e-07 0 3.913785601249486e-07 0 3.913885601249486e-07 0.00021 3.913985601249486e-07 0 3.913985601249486e-07 0 3.9140856012494864e-07 0.00021 3.9141856012494865e-07 0 3.9148419989198297e-07 0 3.91494199891983e-07 0.00021 3.91504199891983e-07 0 3.91504199891983e-07 0 3.91514199891983e-07 0.00021 3.91524199891983e-07 0 3.915282407736009e-07 0 3.915382407736009e-07 0.00021 3.915482407736009e-07 0 3.9156736157212196e-07 0 3.9157736157212197e-07 0.00021 3.91587361572122e-07 0 3.9160881683744034e-07 0 3.9161881683744035e-07 0.00021 3.9162881683744037e-07 0 3.9162881683744037e-07 0 3.916388168374404e-07 0.00021 3.916488168374404e-07 0 3.9165377407335064e-07 0 3.9166377407335065e-07 0.00021 3.9167377407335066e-07 0 3.9173021264831743e-07 0 3.9174021264831744e-07 0.00021 3.9175021264831745e-07 0 3.917874424019808e-07 0 3.917974424019808e-07 0.00021 3.918074424019808e-07 0 3.918236821145448e-07 0 3.918336821145448e-07 0.00021 3.918436821145448e-07 0 3.918436821145448e-07 0 3.918536821145448e-07 0.00021 3.9186368211454483e-07 0 3.918643427594867e-07 0 3.918743427594867e-07 0.00021 3.918843427594867e-07 0 3.918843427594867e-07 0 3.918943427594867e-07 0.00021 3.9190434275948673e-07 0 3.9190434275948673e-07 0 3.9191434275948674e-07 0.00021 3.9192434275948675e-07 0 3.9192434275948675e-07 0 3.9193434275948676e-07 0.00021 3.919443427594868e-07 0 3.9196937527457186e-07 0 3.9197937527457187e-07 0.00021 3.919893752745719e-07 0 3.920268863584388e-07 0 3.920368863584388e-07 0.00021 3.920468863584388e-07 0 3.920468863584388e-07 0 3.9205688635843884e-07 0.00021 3.9206688635843885e-07 0 3.9206688635843885e-07 0 3.9207688635843886e-07 0.00021 3.9208688635843887e-07 0 3.9208688635843887e-07 0 3.920968863584389e-07 0.00021 3.921068863584389e-07 0 3.921068863584389e-07 0 3.921168863584389e-07 0.00021 3.921268863584389e-07 0 3.9216052911875847e-07 0 3.921705291187585e-07 0.00021 3.921805291187585e-07 0 3.921805291187585e-07 0 3.921905291187585e-07 0.00021 3.922005291187585e-07 0 3.922005291187585e-07 0 3.922105291187585e-07 0.00021 3.9222052911875853e-07 0 3.9223085994470046e-07 0 3.9224085994470047e-07 0.00021 3.922508599447005e-07 0 3.9245904463730466e-07 0 3.9246904463730467e-07 0.00021 3.924790446373047e-07 0 3.924935884187712e-07 0 3.9250358841877123e-07 0.00021 3.9251358841877124e-07 0 3.9251358841877124e-07 0 3.9252358841877125e-07 0.00021 3.9253358841877126e-07 0 3.92535666508655e-07 0 3.92545666508655e-07 0.00021 3.92555666508655e-07 0 3.92555666508655e-07 0 3.92565666508655e-07 0.00021 3.92575666508655e-07 0 3.925766575220675e-07 0 3.9258665752206753e-07 0.00021 3.9259665752206754e-07 0 3.9259665752206754e-07 0 3.9260665752206756e-07 0.00021 3.9261665752206757e-07 0 3.9261665752206757e-07 0 3.926266575220676e-07 0.00021 3.926366575220676e-07 0 3.926366575220676e-07 0 3.926466575220676e-07 0.00021 3.926566575220676e-07 0 3.926604531901008e-07 0 3.926704531901008e-07 0.00021 3.926804531901008e-07 0 3.926804531901008e-07 0 3.9269045319010083e-07 0.00021 3.9270045319010084e-07 0 3.9270045319010084e-07 0 3.9271045319010085e-07 0.00021 3.9272045319010086e-07 0 3.9272045319010086e-07 0 3.927304531901009e-07 0.00021 3.927404531901009e-07 0 3.927636884592696e-07 0 3.927736884592696e-07 0.00021 3.927836884592696e-07 0 3.9280513777925583e-07 0 3.9281513777925584e-07 0.00021 3.9282513777925585e-07 0 3.9282513777925585e-07 0 3.9283513777925586e-07 0.00021 3.928451377792559e-07 0 3.9285721856598234e-07 0 3.9286721856598235e-07 0.00021 3.9287721856598236e-07 0 3.9287721856598236e-07 0 3.9288721856598237e-07 0.00021 3.928972185659824e-07 0 3.92906737714542e-07 0 3.9291673771454203e-07 0.00021 3.9292673771454205e-07 0 3.92976556318063e-07 0 3.92986556318063e-07 0.00021 3.9299655631806303e-07 0 3.9299655631806303e-07 0 3.9300655631806304e-07 0.00021 3.9301655631806305e-07 0 3.9301655631806305e-07 0 3.9302655631806306e-07 0.00021 3.930365563180631e-07 0 3.930365563180631e-07 0 3.930465563180631e-07 0.00021 3.930565563180631e-07 0 3.930565563180631e-07 0 3.930665563180631e-07 0.00021 3.930765563180631e-07 0 3.930765563180631e-07 0 3.9308655631806313e-07 0.00021 3.9309655631806314e-07 0 3.9309655631806314e-07 0 3.9310655631806315e-07 0.00021 3.9311655631806316e-07 0 3.9311655631806316e-07 0 3.931265563180632e-07 0.00021 3.931365563180632e-07 0 3.9315274537303204e-07 0 3.9316274537303205e-07 0.00021 3.9317274537303206e-07 0 3.9317274537303206e-07 0 3.931827453730321e-07 0.00021 3.931927453730321e-07 0 3.9323074980788065e-07 0 3.9324074980788066e-07 0.00021 3.9325074980788067e-07 0 3.932819984291558e-07 0 3.932919984291558e-07 0.00021 3.933019984291558e-07 0 3.933386584628117e-07 0 3.933486584628117e-07 0.00021 3.9335865846281173e-07 0 3.933772200986322e-07 0 3.933872200986322e-07 0.00021 3.933972200986322e-07 0 3.934326415463266e-07 0 3.934426415463266e-07 0.00021 3.9345264154632663e-07 0 3.9345264154632663e-07 0 3.9346264154632664e-07 0.00021 3.9347264154632666e-07 0 3.9347264154632666e-07 0 3.9348264154632667e-07 0.00021 3.934926415463267e-07 0 3.934926415463267e-07 0 3.935026415463267e-07 0.00021 3.935126415463267e-07 0 3.9355521859460903e-07 0 3.9356521859460904e-07 0.00021 3.9357521859460905e-07 0 3.9357521859460905e-07 0 3.9358521859460907e-07 0.00021 3.935952185946091e-07 0 3.9378127105767524e-07 0 3.9379127105767525e-07 0.00021 3.9380127105767526e-07 0 3.9380488421144523e-07 0 3.9381488421144524e-07 0.00021 3.9382488421144526e-07 0 3.9384140303690167e-07 0 3.938514030369017e-07 0.00021 3.938614030369017e-07 0 3.938614030369017e-07 0 3.938714030369017e-07 0.00021 3.938814030369017e-07 0 3.938814030369017e-07 0 3.9389140303690173e-07 0.00021 3.9390140303690174e-07 0 3.939228435815237e-07 0 3.939328435815237e-07 0.00021 3.9394284358152373e-07 0 3.940448741778459e-07 0 3.940548741778459e-07 0.00021 3.940648741778459e-07 0 3.940648741778459e-07 0 3.9407487417784593e-07 0.00021 3.9408487417784594e-07 0 3.940881760792929e-07 0 3.940981760792929e-07 0.00021 3.941081760792929e-07 0 3.941081760792929e-07 0 3.941181760792929e-07 0.00021 3.941281760792929e-07 0 3.94167641997667e-07 0 3.9417764199766703e-07 0.00021 3.9418764199766704e-07 0 3.9418764199766704e-07 0 3.9419764199766705e-07 0.00021 3.9420764199766706e-07 0 3.942225518492352e-07 0 3.942325518492352e-07 0.00021 3.9424255184923524e-07 0 3.9424809379523984e-07 0 3.9425809379523985e-07 0.00021 3.9426809379523986e-07 0 3.9426809379523986e-07 0 3.9427809379523987e-07 0.00021 3.942880937952399e-07 0 3.9431939874038963e-07 0 3.9432939874038964e-07 0.00021 3.9433939874038966e-07 0 3.9433939874038966e-07 0 3.9434939874038967e-07 0.00021 3.943593987403897e-07 0 3.944027841852436e-07 0 3.944127841852436e-07 0.00021 3.944227841852436e-07 0 3.944705700979059e-07 0 3.944805700979059e-07 0.00021 3.9449057009790593e-07 0 3.94511599080195e-07 0 3.94521599080195e-07 0.00021 3.94531599080195e-07 0 3.94531599080195e-07 0 3.9454159908019503e-07 0.00021 3.9455159908019504e-07 0 3.9455159908019504e-07 0 3.9456159908019505e-07 0.00021 3.9457159908019506e-07 0 3.94589658403456e-07 0 3.94599658403456e-07 0.00021 3.94609658403456e-07 0 3.9461960186447627e-07 0 3.946296018644763e-07 0.00021 3.946396018644763e-07 0 3.946396018644763e-07 0 3.946496018644763e-07 0.00021 3.946596018644763e-07 0 3.946596018644763e-07 0 3.9466960186447633e-07 0.00021 3.9467960186447634e-07 0 3.9468699608522767e-07 0 3.946969960852277e-07 0.00021 3.947069960852277e-07 0 3.9476215657774355e-07 0 3.9477215657774356e-07 0.00021 3.947821565777436e-07 0 3.947821565777436e-07 0 3.947921565777436e-07 0.00021 3.948021565777436e-07 0 3.948021565777436e-07 0 3.948121565777436e-07 0.00021 3.948221565777436e-07 0 3.9482683903611385e-07 0 3.9483683903611386e-07 0.00021 3.9484683903611387e-07 0 3.9484683903611387e-07 0 3.948568390361139e-07 0.00021 3.948668390361139e-07 0 3.9487328826034034e-07 0 3.9488328826034036e-07 0.00021 3.9489328826034037e-07 0 3.9489328826034037e-07 0 3.949032882603404e-07 0.00021 3.949132882603404e-07 0 3.949394216442371e-07 0 3.949494216442371e-07 0.00021 3.949594216442371e-07 0 3.9499510927020496e-07 0 3.9500510927020497e-07 0.00021 3.95015109270205e-07 0 3.9502093422025387e-07 0 3.950309342202539e-07 0.00021 3.950409342202539e-07 0 3.950409342202539e-07 0 3.950509342202539e-07 0.00021 3.950609342202539e-07 0 3.950609342202539e-07 0 3.9507093422025393e-07 0.00021 3.9508093422025394e-07 0 3.95084898054254e-07 0 3.95094898054254e-07 0.00021 3.95104898054254e-07 0 3.95104898054254e-07 0 3.95114898054254e-07 0.00021 3.9512489805425404e-07 0 3.9512489805425404e-07 0 3.9513489805425405e-07 0.00021 3.9514489805425406e-07 0 3.9514489805425406e-07 0 3.9515489805425407e-07 0.00021 3.951648980542541e-07 0 3.951648980542541e-07 0 3.951748980542541e-07 0.00021 3.951848980542541e-07 0 3.951848980542541e-07 0 3.951948980542541e-07 0.00021 3.952048980542541e-07 0 3.952048980542541e-07 0 3.9521489805425414e-07 0.00021 3.9522489805425415e-07 0 3.9527555701990973e-07 0 3.9528555701990974e-07 0.00021 3.9529555701990975e-07 0 3.9529555701990975e-07 0 3.9530555701990976e-07 0.00021 3.9531555701990977e-07 0 3.9531958919850494e-07 0 3.9532958919850495e-07 0.00021 3.9533958919850496e-07 0 3.9533958919850496e-07 0 3.9534958919850497e-07 0.00021 3.95359589198505e-07 0 3.9537000293389086e-07 0 3.9538000293389087e-07 0.00021 3.953900029338909e-07 0 3.953900029338909e-07 0 3.954000029338909e-07 0.00021 3.954100029338909e-07 0 3.954100029338909e-07 0 3.954200029338909e-07 0.00021 3.9543000293389093e-07 0 3.9543000293389093e-07 0 3.9544000293389094e-07 0.00021 3.9545000293389095e-07 0 3.9545000293389095e-07 0 3.9546000293389096e-07 0.00021 3.95470002933891e-07 0 3.95470002933891e-07 0 3.95480002933891e-07 0.00021 3.95490002933891e-07 0 3.95490002933891e-07 0 3.95500002933891e-07 0.00021 3.95510002933891e-07 0 3.95510002933891e-07 0 3.9552000293389103e-07 0.00021 3.9553000293389104e-07 0 3.955985593543135e-07 0 3.956085593543135e-07 0.00021 3.956185593543135e-07 0 3.956185593543135e-07 0 3.9562855935431353e-07 0.00021 3.9563855935431354e-07 0 3.9563855935431354e-07 0 3.9564855935431355e-07 0.00021 3.9565855935431356e-07 0 3.9565855935431356e-07 0 3.9566855935431357e-07 0.00021 3.956785593543136e-07 0 3.957020429373376e-07 0 3.957120429373376e-07 0.00021 3.957220429373376e-07 0 3.9576903823394595e-07 0 3.9577903823394597e-07 0.00021 3.95789038233946e-07 0 3.95789038233946e-07 0 3.95799038233946e-07 0.00021 3.95809038233946e-07 0 3.95809038233946e-07 0 3.95819038233946e-07 0.00021 3.95829038233946e-07 0 3.958293985156051e-07 0 3.958393985156051e-07 0.00021 3.9584939851560513e-07 0 3.9586412928209966e-07 0 3.9587412928209967e-07 0.00021 3.958841292820997e-07 0 3.958841292820997e-07 0 3.958941292820997e-07 0.00021 3.959041292820997e-07 0 3.959402020513258e-07 0 3.959502020513258e-07 0.00021 3.959602020513258e-07 0 3.959626370628824e-07 0 3.959726370628824e-07 0.00021 3.959826370628824e-07 0 3.9602949702426835e-07 0 3.9603949702426836e-07 0.00021 3.9604949702426837e-07 0 3.9604949702426837e-07 0 3.960594970242684e-07 0.00021 3.960694970242684e-07 0 3.960694970242684e-07 0 3.960794970242684e-07 0.00021 3.960894970242684e-07 0 3.960894970242684e-07 0 3.9609949702426843e-07 0.00021 3.9610949702426844e-07 0 3.9610949702426844e-07 0 3.9611949702426845e-07 0.00021 3.9612949702426846e-07 0 3.9612949702426846e-07 0 3.961394970242685e-07 0.00021 3.961494970242685e-07 0 3.961786221559769e-07 0 3.961886221559769e-07 0.00021 3.9619862215597693e-07 0 3.9619862215597693e-07 0 3.9620862215597694e-07 0.00021 3.9621862215597695e-07 0 3.962675526464458e-07 0 3.962775526464458e-07 0.00021 3.9628755264644583e-07 0 3.9629277918708e-07 0 3.9630277918708003e-07 0.00021 3.9631277918708004e-07 0 3.9634837629563394e-07 0 3.9635837629563395e-07 0.00021 3.9636837629563396e-07 0 3.964280477840811e-07 0 3.964380477840811e-07 0.00021 3.9644804778408113e-07 0 3.9646557330041705e-07 0 3.9647557330041707e-07 0.00021 3.964855733004171e-07 0 3.965704407967622e-07 0 3.965804407967622e-07 0.00021 3.965904407967622e-07 0 3.965904407967622e-07 0 3.9660044079676223e-07 0.00021 3.9661044079676224e-07 0 3.9661044079676224e-07 0 3.9662044079676225e-07 0.00021 3.9663044079676226e-07 0 3.9663044079676226e-07 0 3.966404407967623e-07 0.00021 3.966504407967623e-07 0 3.966504407967623e-07 0 3.966604407967623e-07 0.00021 3.966704407967623e-07 0 3.966704407967623e-07 0 3.966804407967623e-07 0.00021 3.9669044079676233e-07 0 3.9669044079676233e-07 0 3.9670044079676234e-07 0.00021 3.9671044079676235e-07 0 3.9671044079676235e-07 0 3.9672044079676237e-07 0.00021 3.967304407967624e-07 0 3.968019298342391e-07 0 3.968119298342391e-07 0.00021 3.9682192983423914e-07 0 3.96827163418462e-07 0 3.96837163418462e-07 0.00021 3.96847163418462e-07 0 3.96895483581627e-07 0 3.9690548358162703e-07 0.00021 3.9691548358162704e-07 0 3.9691548358162704e-07 0 3.9692548358162705e-07 0.00021 3.9693548358162706e-07 0 3.9693548358162706e-07 0 3.969454835816271e-07 0.00021 3.969554835816271e-07 0 3.9700980968324184e-07 0 3.9701980968324185e-07 0.00021 3.9702980968324187e-07 0 3.9702980968324187e-07 0 3.970398096832419e-07 0.00021 3.970498096832419e-07 0 3.9707301444891176e-07 0 3.9708301444891177e-07 0.00021 3.970930144489118e-07 0 3.97096575968521e-07 0 3.9710657596852103e-07 0.00021 3.9711657596852105e-07 0 3.971440359354251e-07 0 3.9715403593542513e-07 0.00021 3.9716403593542514e-07 0 3.972278348580583e-07 0 3.972378348580583e-07 0.00021 3.972478348580583e-07 0 3.972478348580583e-07 0 3.9725783485805833e-07 0.00021 3.9726783485805834e-07 0 3.973583733630092e-07 0 3.973683733630092e-07 0.00021 3.973783733630092e-07 0 3.973783733630092e-07 0 3.973883733630092e-07 0.00021 3.9739837336300923e-07 0 3.9739837336300923e-07 0 3.9740837336300924e-07 0.00021 3.9741837336300925e-07 0 3.9741837336300925e-07 0 3.9742837336300926e-07 0.00021 3.974383733630093e-07 0 3.9748841114059545e-07 0 3.9749841114059546e-07 0.00021 3.975084111405955e-07 0 3.975084111405955e-07 0 3.975184111405955e-07 0.00021 3.975284111405955e-07 0 3.9753496343040485e-07 0 3.9754496343040487e-07 0.00021 3.975549634304049e-07 0 3.975867400603325e-07 0 3.975967400603325e-07 0.00021 3.976067400603325e-07 0 3.976418845461402e-07 0 3.976518845461402e-07 0.00021 3.976618845461402e-07 0 3.976618845461402e-07 0 3.976718845461402e-07 0.00021 3.976818845461402e-07 0 3.976818845461402e-07 0 3.9769188454614023e-07 0.00021 3.9770188454614024e-07 0 3.9770188454614024e-07 0 3.9771188454614025e-07 0.00021 3.9772188454614026e-07 0 3.9772188454614026e-07 0 3.977318845461403e-07 0.00021 3.977418845461403e-07 0 3.977418845461403e-07 0 3.977518845461403e-07 0.00021 3.977618845461403e-07 0 3.9776333933732126e-07 0 3.9777333933732127e-07 0.00021 3.977833393373213e-07 0 3.977833393373213e-07 0 3.977933393373213e-07 0.00021 3.978033393373213e-07 0 3.9783861941126334e-07 0 3.9784861941126335e-07 0.00021 3.9785861941126336e-07 0 3.9786302900793116e-07 0 3.9787302900793117e-07 0.00021 3.978830290079312e-07 0 3.978830290079312e-07 0 3.978930290079312e-07 0.00021 3.979030290079312e-07 0 3.979030290079312e-07 0 3.979130290079312e-07 0.00021 3.9792302900793123e-07 0 3.9792302900793123e-07 0 3.9793302900793124e-07 0.00021 3.9794302900793125e-07 0 3.9794302900793125e-07 0 3.9795302900793126e-07 0.00021 3.9796302900793127e-07 0 3.97981337375023e-07 0 3.97991337375023e-07 0.00021 3.98001337375023e-07 0 3.98001337375023e-07 0 3.98011337375023e-07 0.00021 3.9802133737502304e-07 0 3.98049726202111e-07 0 3.98059726202111e-07 0.00021 3.9806972620211104e-07 0 3.9806972620211104e-07 0 3.9807972620211105e-07 0.00021 3.9808972620211106e-07 0 3.9808972620211106e-07 0 3.9809972620211107e-07 0.00021 3.981097262021111e-07 0 3.981097262021111e-07 0 3.981197262021111e-07 0.00021 3.981297262021111e-07 0 3.981297262021111e-07 0 3.981397262021111e-07 0.00021 3.9814972620211113e-07 0 3.9814972620211113e-07 0 3.9815972620211114e-07 0.00021 3.9816972620211115e-07 0 3.9817530226888446e-07 0 3.9818530226888447e-07 0.00021 3.981953022688845e-07 0 3.981992948656523e-07 0 3.982092948656523e-07 0.00021 3.9821929486565233e-07 0 3.9821929486565233e-07 0 3.9822929486565234e-07 0.00021 3.9823929486565235e-07 0 3.982711170750415e-07 0 3.982811170750415e-07 0.00021 3.9829111707504154e-07 0 3.983874522287017e-07 0 3.983974522287017e-07 0.00021 3.984074522287017e-07 0 3.9851565181339256e-07 0 3.9852565181339257e-07 0.00021 3.985356518133926e-07 0 3.985663553673976e-07 0 3.985763553673976e-07 0.00021 3.985863553673976e-07 0 3.985863553673976e-07 0 3.985963553673976e-07 0.00021 3.9860635536739764e-07 0 3.9860635536739764e-07 0 3.9861635536739765e-07 0.00021 3.9862635536739766e-07 0 3.9862635536739766e-07 0 3.9863635536739767e-07 0.00021 3.986463553673977e-07 0 3.9865701065614497e-07 0 3.98667010656145e-07 0.00021 3.98677010656145e-07 0 3.98677010656145e-07 0 3.98687010656145e-07 0.00021 3.98697010656145e-07 0 3.987151725286065e-07 0 3.987251725286065e-07 0.00021 3.987351725286065e-07 0 3.9891304241249894e-07 0 3.9892304241249896e-07 0.00021 3.9893304241249897e-07 0 3.9893304241249897e-07 0 3.98943042412499e-07 0.00021 3.98953042412499e-07 0 3.98953042412499e-07 0 3.98963042412499e-07 0.00021 3.98973042412499e-07 0 3.98973042412499e-07 0 3.98983042412499e-07 0.00021 3.9899304241249903e-07 0 3.9899304241249903e-07 0 3.9900304241249905e-07 0.00021 3.9901304241249906e-07 0 3.9901304241249906e-07 0 3.9902304241249907e-07 0.00021 3.990330424124991e-07 0 3.990330424124991e-07 0 3.990430424124991e-07 0.00021 3.990530424124991e-07 0 3.990530424124991e-07 0 3.990630424124991e-07 0.00021 3.990730424124991e-07 0 3.991138044642459e-07 0 3.991238044642459e-07 0.00021 3.9913380446424593e-07 0 3.9913380446424593e-07 0 3.9914380446424594e-07 0.00021 3.9915380446424595e-07 0 3.9916800561857324e-07 0 3.9917800561857325e-07 0.00021 3.9918800561857326e-07 0 3.992391000506824e-07 0 3.992491000506824e-07 0.00021 3.9925910005068244e-07 0 3.9925910005068244e-07 0 3.9926910005068245e-07 0.00021 3.9927910005068246e-07 0 3.9927910005068246e-07 0 3.9928910005068247e-07 0.00021 3.992991000506825e-07 0 3.992991000506825e-07 0 3.993091000506825e-07 0.00021 3.993191000506825e-07 0 3.993191000506825e-07 0 3.993291000506825e-07 0.00021 3.993391000506825e-07 0 3.993391000506825e-07 0 3.9934910005068254e-07 0.00021 3.9935910005068255e-07 0 3.9935910005068255e-07 0 3.9936910005068256e-07 0.00021 3.9937910005068257e-07 0 3.9937910005068257e-07 0 3.993891000506826e-07 0.00021 3.993991000506826e-07 0 3.9944140738283566e-07 0 3.9945140738283567e-07 0.00021 3.994614073828357e-07 0 3.994614073828357e-07 0 3.994714073828357e-07 0.00021 3.994814073828357e-07 0 3.994849878630392e-07 0 3.994949878630392e-07 0.00021 3.995049878630392e-07 0 3.9960359165685754e-07 0 3.9961359165685755e-07 0.00021 3.9962359165685756e-07 0 3.996302275348604e-07 0 3.996402275348604e-07 0.00021 3.996502275348604e-07 0 3.996502275348604e-07 0 3.9966022753486043e-07 0.00021 3.9967022753486044e-07 0 3.9967022753486044e-07 0 3.9968022753486046e-07 0.00021 3.9969022753486047e-07 0 3.9976176263832044e-07 0 3.9977176263832045e-07 0.00021 3.9978176263832047e-07 0 3.9978176263832047e-07 0 3.997917626383205e-07 0.00021 3.998017626383205e-07 0 3.998734654136293e-07 0 3.998834654136293e-07 0.00021 3.998934654136293e-07 0 3.9991500403967617e-07 0 3.999250040396762e-07 0.00021 3.999350040396762e-07 0 3.999350040396762e-07 0 3.999450040396762e-07 0.00021 3.999550040396762e-07 0 3.999550040396762e-07 0 3.999650040396762e-07 0.00021 3.9997500403967624e-07 0 3.9997500403967624e-07 0 3.9998500403967625e-07 0.00021 3.9999500403967626e-07 0 4.000202638351837e-07 0 4.000302638351837e-07 0.00021 4.000402638351837e-07 0 4.000421722329798e-07 0 4.0005217223297983e-07 0.00021 4.0006217223297984e-07 0 4.0006217223297984e-07 0 4.0007217223297985e-07 0.00021 4.0008217223297986e-07 0 4.000911817244688e-07 0 4.001011817244688e-07 0.00021 4.001111817244688e-07 0 4.0024065098526424e-07 0 4.0025065098526425e-07 0.00021 4.0026065098526426e-07 0 4.0026065098526426e-07 0 4.002706509852643e-07 0.00021 4.002806509852643e-07 0 4.002806509852643e-07 0 4.002906509852643e-07 0.00021 4.003006509852643e-07 0 4.003006509852643e-07 0 4.003106509852643e-07 0.00021 4.0032065098526433e-07 0 4.0032065098526433e-07 0 4.0033065098526434e-07 0.00021 4.0034065098526436e-07 0 4.0039586059553937e-07 0 4.004058605955394e-07 0.00021 4.004158605955394e-07 0 4.004158605955394e-07 0 4.004258605955394e-07 0.00021 4.004358605955394e-07 0 4.004358605955394e-07 0 4.004458605955394e-07 0.00021 4.0045586059553943e-07 0 4.0047487895131514e-07 0 4.0048487895131515e-07 0.00021 4.0049487895131517e-07 0 4.0049487895131517e-07 0 4.005048789513152e-07 0.00021 4.005148789513152e-07 0 4.005148789513152e-07 0 4.005248789513152e-07 0.00021 4.005348789513152e-07 0 4.005348789513152e-07 0 4.005448789513152e-07 0.00021 4.0055487895131523e-07 0 4.0055487895131523e-07 0 4.0056487895131524e-07 0.00021 4.0057487895131526e-07 0 4.0057487895131526e-07 0 4.0058487895131527e-07 0.00021 4.005948789513153e-07 0 4.0062855773298813e-07 0 4.0063855773298814e-07 0.00021 4.0064855773298815e-07 0 4.007655495828505e-07 0 4.0077554958285054e-07 0.00021 4.0078554958285055e-07 0 4.007859896557521e-07 0 4.007959896557521e-07 0.00021 4.008059896557521e-07 0 4.008225012094439e-07 0 4.008325012094439e-07 0.00021 4.0084250120944393e-07 0 4.009021527847747e-07 0 4.0091215278477473e-07 0.00021 4.0092215278477475e-07 0 4.009533400402893e-07 0 4.009633400402893e-07 0.00021 4.009733400402893e-07 0 4.009733400402893e-07 0 4.009833400402893e-07 0.00021 4.009933400402893e-07 0 4.009933400402893e-07 0 4.0100334004028933e-07 0.00021 4.0101334004028934e-07 0 4.0101334004028934e-07 0 4.0102334004028935e-07 0.00021 4.0103334004028936e-07 0 4.0103334004028936e-07 0 4.010433400402894e-07 0.00021 4.010533400402894e-07 0 4.012382317308911e-07 0 4.0124823173089114e-07 0.00021 4.0125823173089115e-07 0 4.01384030105039e-07 0 4.01394030105039e-07 0.00021 4.01404030105039e-07 0 4.014557526584184e-07 0 4.014657526584184e-07 0.00021 4.014757526584184e-07 0 4.0149420358111895e-07 0 4.0150420358111896e-07 0.00021 4.0151420358111897e-07 0 4.0155695127894225e-07 0 4.0156695127894226e-07 0.00021 4.015769512789423e-07 0 4.015769512789423e-07 0 4.015869512789423e-07 0.00021 4.015969512789423e-07 0 4.0163468280765224e-07 0 4.0164468280765225e-07 0.00021 4.0165468280765226e-07 0 4.0165468280765226e-07 0 4.0166468280765227e-07 0.00021 4.016746828076523e-07 0 4.016746828076523e-07 0 4.016846828076523e-07 0.00021 4.016946828076523e-07 0 4.016946828076523e-07 0 4.017046828076523e-07 0.00021 4.017146828076523e-07 0 4.017146828076523e-07 0 4.0172468280765234e-07 0.00021 4.0173468280765235e-07 0 4.0176630577760644e-07 0 4.0177630577760645e-07 0.00021 4.0178630577760646e-07 0 4.0178630577760646e-07 0 4.017963057776065e-07 0.00021 4.018063057776065e-07 0 4.018149856621465e-07 0 4.018249856621465e-07 0.00021 4.0183498566214654e-07 0 4.018898499826415e-07 0 4.018998499826415e-07 0.00021 4.019098499826415e-07 0 4.0194229485393777e-07 0 4.019522948539378e-07 0.00021 4.019622948539378e-07 0 4.0205128012593597e-07 0 4.02061280125936e-07 0.00021 4.02071280125936e-07 0 4.02071280125936e-07 0 4.02081280125936e-07 0.00021 4.02091280125936e-07 0 4.02091280125936e-07 0 4.0210128012593603e-07 0.00021 4.0211128012593604e-07 0 4.0211128012593604e-07 0 4.0212128012593605e-07 0.00021 4.0213128012593606e-07 0 4.0213301860942195e-07 0 4.0214301860942196e-07 0.00021 4.0215301860942197e-07 0 4.021622745473421e-07 0 4.021722745473421e-07 0.00021 4.021822745473421e-07 0 4.021822745473421e-07 0 4.021922745473421e-07 0.00021 4.0220227454734213e-07 0 4.0220227454734213e-07 0 4.0221227454734215e-07 0.00021 4.0222227454734216e-07 0 4.022341772112795e-07 0 4.022441772112795e-07 0.00021 4.022541772112795e-07 0 4.022892364531763e-07 0 4.022992364531763e-07 0.00021 4.0230923645317633e-07 0 4.023473892492905e-07 0 4.023573892492905e-07 0.00021 4.023673892492905e-07 0 4.023673892492905e-07 0 4.023773892492905e-07 0.00021 4.0238738924929053e-07 0 4.0238738924929053e-07 0 4.0239738924929054e-07 0.00021 4.0240738924929055e-07 0 4.0240738924929055e-07 0 4.0241738924929056e-07 0.00021 4.024273892492906e-07 0 4.024854255689561e-07 0 4.024954255689561e-07 0.00021 4.025054255689561e-07 0 4.025054255689561e-07 0 4.025154255689561e-07 0.00021 4.025254255689561e-07 0 4.025446281092569e-07 0 4.025546281092569e-07 0.00021 4.025646281092569e-07 0 4.0261854314407744e-07 0 4.0262854314407745e-07 0.00021 4.0263854314407747e-07 0 4.026512467711547e-07 0 4.0266124677115473e-07 0.00021 4.0267124677115474e-07 0 4.0267124677115474e-07 0 4.0268124677115475e-07 0.00021 4.0269124677115476e-07 0 4.027058202105168e-07 0 4.0271582021051683e-07 0.00021 4.0272582021051684e-07 0 4.027343528144248e-07 0 4.027443528144248e-07 0.00021 4.027543528144248e-07 0 4.027596693280731e-07 0 4.0276966932807314e-07 0.00021 4.0277966932807315e-07 0 4.0281824060824395e-07 0 4.0282824060824397e-07 0.00021 4.02838240608244e-07 0 4.0289601950406714e-07 0 4.0290601950406715e-07 0.00021 4.0291601950406716e-07 0 4.029593454480521e-07 0 4.0296934544805213e-07 0.00021 4.0297934544805214e-07 0 4.0297934544805214e-07 0 4.0298934544805215e-07 0.00021 4.0299934544805216e-07 0 4.03010164215015e-07 0 4.03020164215015e-07 0.00021 4.03030164215015e-07 0 4.03030164215015e-07 0 4.03040164215015e-07 0.00021 4.0305016421501504e-07 0 4.0305016421501504e-07 0 4.0306016421501505e-07 0.00021 4.0307016421501506e-07 0 4.031561032218053e-07 0 4.031661032218053e-07 0.00021 4.031761032218053e-07 0 4.032011216126309e-07 0 4.0321112161263094e-07 0.00021 4.0322112161263095e-07 0 4.032235070749223e-07 0 4.032335070749223e-07 0.00021 4.032435070749223e-07 0 4.032435070749223e-07 0 4.032535070749223e-07 0.00021 4.0326350707492233e-07 0 4.0326350707492233e-07 0 4.0327350707492234e-07 0.00021 4.0328350707492235e-07 0 4.0328350707492235e-07 0 4.0329350707492236e-07 0.00021 4.033035070749224e-07 0 4.033035070749224e-07 0 4.033135070749224e-07 0.00021 4.033235070749224e-07 0 4.033235070749224e-07 0 4.033335070749224e-07 0.00021 4.033435070749224e-07 0 4.033435070749224e-07 0 4.0335350707492243e-07 0.00021 4.0336350707492244e-07 0 4.0336566933108904e-07 0 4.0337566933108905e-07 0.00021 4.0338566933108906e-07 0 4.034028482954778e-07 0 4.034128482954778e-07 0.00021 4.034228482954778e-07 0 4.034228482954778e-07 0 4.034328482954778e-07 0.00021 4.0344284829547783e-07 0 4.034457025746972e-07 0 4.034557025746972e-07 0.00021 4.034657025746972e-07 0 4.035287752186277e-07 0 4.035387752186277e-07 0.00021 4.035487752186277e-07 0 4.035487752186277e-07 0 4.035587752186277e-07 0.00021 4.0356877521862774e-07 0 4.0356877521862774e-07 0 4.0357877521862775e-07 0.00021 4.0358877521862776e-07 0 4.0359385730653634e-07 0 4.0360385730653636e-07 0.00021 4.0361385730653637e-07 0 4.036560150157419e-07 0 4.036660150157419e-07 0.00021 4.036760150157419e-07 0 4.036994451784901e-07 0 4.037094451784901e-07 0.00021 4.0371944517849013e-07 0 4.0373484382105357e-07 0 4.037448438210536e-07 0.00021 4.037548438210536e-07 0 4.038080416914696e-07 0 4.038180416914696e-07 0.00021 4.038280416914696e-07 0 4.038280416914696e-07 0 4.038380416914696e-07 0.00021 4.038480416914696e-07 0 4.0392597838743955e-07 0 4.0393597838743956e-07 0.00021 4.039459783874396e-07 0 4.039459783874396e-07 0 4.039559783874396e-07 0.00021 4.039659783874396e-07 0 4.039659783874396e-07 0 4.039759783874396e-07 0.00021 4.039859783874396e-07 0 4.039859783874396e-07 0 4.0399597838743963e-07 0.00021 4.0400597838743964e-07 0 4.0400597838743964e-07 0 4.0401597838743966e-07 0.00021 4.0402597838743967e-07 0 4.0409245572834253e-07 0 4.0410245572834255e-07 0.00021 4.0411245572834256e-07 0 4.0411245572834256e-07 0 4.0412245572834257e-07 0.00021 4.041324557283426e-07 0 4.041509055106161e-07 0 4.041609055106161e-07 0.00021 4.0417090551061613e-07 0 4.0419608648798026e-07 0 4.0420608648798027e-07 0.00021 4.042160864879803e-07 0 4.042160864879803e-07 0 4.042260864879803e-07 0.00021 4.042360864879803e-07 0 4.042360864879803e-07 0 4.042460864879803e-07 0.00021 4.042560864879803e-07 0 4.042560864879803e-07 0 4.0426608648798034e-07 0.00021 4.0427608648798035e-07 0 4.042768450269329e-07 0 4.042868450269329e-07 0.00021 4.042968450269329e-07 0 4.042987785794262e-07 0 4.043087785794262e-07 0.00021 4.043187785794262e-07 0 4.0433789969217725e-07 0 4.0434789969217727e-07 0.00021 4.043578996921773e-07 0 4.043578996921773e-07 0 4.043678996921773e-07 0.00021 4.043778996921773e-07 0 4.043778996921773e-07 0 4.043878996921773e-07 0.00021 4.043978996921773e-07 0 4.043978996921773e-07 0 4.0440789969217733e-07 0.00021 4.0441789969217734e-07 0 4.0442263570320405e-07 0 4.0443263570320406e-07 0.00021 4.0444263570320407e-07 0 4.0449593857278203e-07 0 4.0450593857278204e-07 0.00021 4.0451593857278206e-07 0 4.0451593857278206e-07 0 4.0452593857278207e-07 0.00021 4.045359385727821e-07 0 4.045359385727821e-07 0 4.045459385727821e-07 0.00021 4.045559385727821e-07 0 4.045847175283341e-07 0 4.045947175283341e-07 0.00021 4.046047175283341e-07 0 4.046047175283341e-07 0 4.0461471752833413e-07 0.00021 4.0462471752833414e-07 0 4.0462471752833414e-07 0 4.0463471752833416e-07 0.00021 4.0464471752833417e-07 0 4.0464471752833417e-07 0 4.046547175283342e-07 0.00021 4.046647175283342e-07 0 4.047388758107201e-07 0 4.0474887581072013e-07 0.00021 4.0475887581072014e-07 0 4.0475887581072014e-07 0 4.0476887581072015e-07 0.00021 4.0477887581072017e-07 0 4.0477887581072017e-07 0 4.047888758107202e-07 0.00021 4.047988758107202e-07 0 4.047988758107202e-07 0 4.048088758107202e-07 0.00021 4.048188758107202e-07 0 4.048188758107202e-07 0 4.048288758107202e-07 0.00021 4.0483887581072023e-07 0 4.0484540959814195e-07 0 4.0485540959814196e-07 0.00021 4.0486540959814197e-07 0 4.0486540959814197e-07 0 4.04875409598142e-07 0.00021 4.04885409598142e-07 0 4.0491661600053385e-07 0 4.0492661600053386e-07 0.00021 4.049366160005339e-07 0 4.049366160005339e-07 0 4.049466160005339e-07 0.00021 4.049566160005339e-07 0 4.049566160005339e-07 0 4.049666160005339e-07 0.00021 4.049766160005339e-07 0 4.0501269728137936e-07 0 4.0502269728137937e-07 0.00021 4.050326972813794e-07 0 4.050366006113555e-07 0 4.050466006113555e-07 0.00021 4.050566006113555e-07 0 4.050943506971793e-07 0 4.051043506971793e-07 0.00021 4.0511435069717933e-07 0 4.0511435069717933e-07 0 4.0512435069717934e-07 0.00021 4.0513435069717935e-07 0 4.0513435069717935e-07 0 4.0514435069717936e-07 0.00021 4.051543506971794e-07 0 4.051543506971794e-07 0 4.051643506971794e-07 0.00021 4.051743506971794e-07 0 4.051743506971794e-07 0 4.051843506971794e-07 0.00021 4.051943506971794e-07 0 4.0520111451625056e-07 0 4.0521111451625057e-07 0.00021 4.052211145162506e-07 0 4.0523308597189715e-07 0 4.0524308597189716e-07 0.00021 4.0525308597189717e-07 0 4.0525308597189717e-07 0 4.052630859718972e-07 0.00021 4.052730859718972e-07 0 4.05304657823691e-07 0 4.05314657823691e-07 0.00021 4.0532465782369103e-07 0 4.054093419709464e-07 0 4.0541934197094643e-07 0.00021 4.0542934197094645e-07 0 4.054686038509844e-07 0 4.054786038509844e-07 0.00021 4.0548860385098444e-07 0 4.0552270978011705e-07 0 4.0553270978011707e-07 0.00021 4.055427097801171e-07 0 4.055427097801171e-07 0 4.055527097801171e-07 0.00021 4.055627097801171e-07 0 4.055695567172226e-07 0 4.055795567172226e-07 0.00021 4.055895567172226e-07 0 4.055958376680467e-07 0 4.056058376680467e-07 0.00021 4.056158376680467e-07 0 4.0566540286735046e-07 0 4.056754028673505e-07 0.00021 4.056854028673505e-07 0 4.0568907480872393e-07 0 4.0569907480872394e-07 0.00021 4.0570907480872395e-07 0 4.0570907480872395e-07 0 4.0571907480872396e-07 0.00021 4.0572907480872397e-07 0 4.0572907480872397e-07 0 4.05739074808724e-07 0.00021 4.05749074808724e-07 0 4.05749074808724e-07 0 4.05759074808724e-07 0.00021 4.05769074808724e-07 0 4.05769074808724e-07 0 4.0577907480872403e-07 0.00021 4.0578907480872404e-07 0 4.0578907480872404e-07 0 4.0579907480872405e-07 0.00021 4.0580907480872406e-07 0 4.0580907480872406e-07 0 4.058190748087241e-07 0.00021 4.058290748087241e-07 0 4.058290748087241e-07 0 4.058390748087241e-07 0.00021 4.058490748087241e-07 0 4.058490748087241e-07 0 4.058590748087241e-07 0.00021 4.0586907480872413e-07 0 4.0586907480872413e-07 0 4.0587907480872414e-07 0.00021 4.0588907480872415e-07 0 4.0588907480872415e-07 0 4.0589907480872417e-07 0.00021 4.059090748087242e-07 0 4.059090748087242e-07 0 4.059190748087242e-07 0.00021 4.059290748087242e-07 0 4.059290748087242e-07 0 4.059390748087242e-07 0.00021 4.059490748087242e-07 0 4.059490748087242e-07 0 4.0595907480872423e-07 0.00021 4.0596907480872425e-07 0 4.0596907480872425e-07 0 4.0597907480872426e-07 0.00021 4.0598907480872427e-07 0 4.0598907480872427e-07 0 4.059990748087243e-07 0.00021 4.060090748087243e-07 0 4.060090748087243e-07 0 4.060190748087243e-07 0.00021 4.060290748087243e-07 0 4.060290748087243e-07 0 4.060390748087243e-07 0.00021 4.0604907480872434e-07 0 4.0604907480872434e-07 0 4.0605907480872435e-07 0.00021 4.0606907480872436e-07 0 4.0608216716140225e-07 0 4.0609216716140227e-07 0.00021 4.061021671614023e-07 0 4.06109697710557e-07 0 4.06119697710557e-07 0.00021 4.06129697710557e-07 0 4.061631204367812e-07 0 4.061731204367812e-07 0.00021 4.061831204367812e-07 0 4.061831204367812e-07 0 4.061931204367812e-07 0.00021 4.0620312043678123e-07 0 4.0620312043678123e-07 0 4.0621312043678125e-07 0.00021 4.0622312043678126e-07 0 4.06227260309702e-07 0 4.06237260309702e-07 0.00021 4.06247260309702e-07 0 4.0628393799835533e-07 0 4.0629393799835534e-07 0.00021 4.0630393799835535e-07 0 4.0633929640161645e-07 0 4.0634929640161646e-07 0.00021 4.0635929640161647e-07 0 4.064469737763267e-07 0 4.064569737763267e-07 0.00021 4.064669737763267e-07 0 4.064669737763267e-07 0 4.064769737763267e-07 0.00021 4.0648697377632673e-07 0 4.0648697377632673e-07 0 4.0649697377632674e-07 0.00021 4.0650697377632675e-07 0 4.0650697377632675e-07 0 4.0651697377632676e-07 0.00021 4.0652697377632677e-07 0 4.0652697377632677e-07 0 4.065369737763268e-07 0.00021 4.065469737763268e-07 0 4.065469737763268e-07 0 4.065569737763268e-07 0.00021 4.065669737763268e-07 0 4.065669737763268e-07 0 4.0657697377632683e-07 0.00021 4.0658697377632684e-07 0 4.0658697377632684e-07 0 4.0659697377632685e-07 0.00021 4.0660697377632686e-07 0 4.0661799310432343e-07 0 4.0662799310432344e-07 0.00021 4.0663799310432346e-07 0 4.067651981771012e-07 0 4.067751981771012e-07 0.00021 4.067851981771012e-07 0 4.067851981771012e-07 0 4.067951981771012e-07 0.00021 4.068051981771012e-07 0 4.068051981771012e-07 0 4.0681519817710123e-07 0.00021 4.0682519817710124e-07 0 4.068574985797338e-07 0 4.0686749857973383e-07 0.00021 4.0687749857973384e-07 0 4.0687749857973384e-07 0 4.0688749857973385e-07 0.00021 4.0689749857973386e-07 0 4.0689749857973386e-07 0 4.0690749857973387e-07 0.00021 4.069174985797339e-07 0 4.0706663395498647e-07 0 4.070766339549865e-07 0.00021 4.070866339549865e-07 0 4.070866339549865e-07 0 4.070966339549865e-07 0.00021 4.071066339549865e-07 0 4.071066339549865e-07 0 4.071166339549865e-07 0.00021 4.0712663395498654e-07 0 4.071344705960016e-07 0 4.071444705960016e-07 0.00021 4.071544705960016e-07 0 4.071761195398608e-07 0 4.0718611953986083e-07 0.00021 4.0719611953986084e-07 0 4.0719611953986084e-07 0 4.0720611953986085e-07 0.00021 4.0721611953986086e-07 0 4.0721611953986086e-07 0 4.072261195398609e-07 0.00021 4.072361195398609e-07 0 4.072485539100855e-07 0 4.072585539100855e-07 0.00021 4.072685539100855e-07 0 4.072740625110234e-07 0 4.072840625110234e-07 0.00021 4.072940625110234e-07 0 4.072940625110234e-07 0 4.073040625110234e-07 0.00021 4.073140625110234e-07 0 4.073140625110234e-07 0 4.0732406251102344e-07 0.00021 4.0733406251102345e-07 0 4.0742202856643987e-07 0 4.074320285664399e-07 0.00021 4.074420285664399e-07 0 4.0747607157180826e-07 0 4.0748607157180827e-07 0.00021 4.074960715718083e-07 0 4.0750559885565113e-07 0 4.0751559885565114e-07 0.00021 4.0752559885565115e-07 0 4.0752559885565115e-07 0 4.0753559885565116e-07 0.00021 4.075455988556512e-07 0 4.0765397800079426e-07 0 4.0766397800079427e-07 0.00021 4.076739780007943e-07 0 4.0767944014260317e-07 0 4.076894401426032e-07 0.00021 4.076994401426032e-07 0 4.077065450160057e-07 0 4.077165450160057e-07 0.00021 4.077265450160057e-07 0 4.077356498216451e-07 0 4.077456498216451e-07 0.00021 4.0775564982164513e-07 0 4.077862829796407e-07 0 4.077962829796407e-07 0.00021 4.0780628297964073e-07 0 4.0780628297964073e-07 0 4.0781628297964074e-07 0.00021 4.0782628297964075e-07 0 4.0782628297964075e-07 0 4.0783628297964076e-07 0.00021 4.078462829796408e-07 0 4.079716544847016e-07 0 4.0798165448470163e-07 0.00021 4.0799165448470164e-07 0 4.0802675606962544e-07 0 4.0803675606962545e-07 0.00021 4.0804675606962546e-07 0 4.0806719490804755e-07 0 4.0807719490804756e-07 0.00021 4.0808719490804757e-07 0 4.081105913573294e-07 0 4.0812059135732943e-07 0.00021 4.0813059135732944e-07 0 4.082566334471745e-07 0 4.0826663344717453e-07 0.00021 4.0827663344717454e-07 0 4.0827663344717454e-07 0 4.0828663344717455e-07 0.00021 4.0829663344717457e-07 0 4.0829663344717457e-07 0 4.083066334471746e-07 0.00021 4.083166334471746e-07 0 4.083166334471746e-07 0 4.083266334471746e-07 0.00021 4.083366334471746e-07 0 4.083366334471746e-07 0 4.083466334471746e-07 0.00021 4.0835663344717463e-07 0 4.0835663344717463e-07 0 4.0836663344717465e-07 0.00021 4.0837663344717466e-07 0 4.0837888974837044e-07 0 4.0838888974837046e-07 0.00021 4.0839888974837047e-07 0 4.0843573767169773e-07 0 4.0844573767169774e-07 0.00021 4.0845573767169775e-07 0 4.0845573767169775e-07 0 4.0846573767169776e-07 0.00021 4.0847573767169777e-07 0 4.0848033287556266e-07 0 4.0849033287556267e-07 0.00021 4.085003328755627e-07 0 4.085086664156785e-07 0 4.085186664156785e-07 0.00021 4.085286664156785e-07 0 4.085286664156785e-07 0 4.085386664156785e-07 0.00021 4.0854866641567853e-07 0 4.0854866641567853e-07 0 4.0855866641567854e-07 0.00021 4.0856866641567855e-07 0 4.0856866641567855e-07 0 4.0857866641567856e-07 0.00021 4.0858866641567857e-07 0 4.0858866641567857e-07 0 4.085986664156786e-07 0.00021 4.086086664156786e-07 0 4.086086664156786e-07 0 4.086186664156786e-07 0.00021 4.086286664156786e-07 0 4.086286664156786e-07 0 4.0863866641567863e-07 0.00021 4.0864866641567864e-07 0 4.0864866641567864e-07 0 4.0865866641567865e-07 0.00021 4.0866866641567866e-07 0 4.0866866641567866e-07 0 4.086786664156787e-07 0.00021 4.086886664156787e-07 0 4.086886664156787e-07 0 4.086986664156787e-07 0.00021 4.087086664156787e-07 0 4.087086664156787e-07 0 4.087186664156787e-07 0.00021 4.0872866641567873e-07 0 4.0875762849148837e-07 0 4.087676284914884e-07 0.00021 4.087776284914884e-07 0 4.0885957975711747e-07 0 4.088695797571175e-07 0.00021 4.088795797571175e-07 0 4.088795797571175e-07 0 4.088895797571175e-07 0.00021 4.088995797571175e-07 0 4.088995797571175e-07 0 4.089095797571175e-07 0.00021 4.0891957975711753e-07 0 4.0891957975711753e-07 0 4.0892957975711755e-07 0.00021 4.0893957975711756e-07 0 4.0893957975711756e-07 0 4.0894957975711757e-07 0.00021 4.089595797571176e-07 0 4.089595797571176e-07 0 4.089695797571176e-07 0.00021 4.089795797571176e-07 0 4.089795797571176e-07 0 4.089895797571176e-07 0.00021 4.089995797571176e-07 0 4.0900557021251925e-07 0 4.0901557021251926e-07 0.00021 4.0902557021251927e-07 0 4.0904637772265935e-07 0 4.0905637772265937e-07 0.00021 4.090663777226594e-07 0 4.090715119099176e-07 0 4.090815119099176e-07 0.00021 4.090915119099176e-07 0 4.090915119099176e-07 0 4.0910151190991763e-07 0.00021 4.0911151190991764e-07 0 4.0911151190991764e-07 0 4.0912151190991765e-07 0.00021 4.0913151190991767e-07 0 4.0913151190991767e-07 0 4.091415119099177e-07 0.00021 4.091515119099177e-07 0 4.091515119099177e-07 0 4.091615119099177e-07 0.00021 4.091715119099177e-07 0 4.091715119099177e-07 0 4.091815119099177e-07 0.00021 4.0919151190991773e-07 0 4.092038998280976e-07 0 4.0921389982809764e-07 0.00021 4.0922389982809765e-07 0 4.092825802333786e-07 0 4.092925802333786e-07 0.00021 4.0930258023337863e-07 0 4.0930258023337863e-07 0 4.0931258023337864e-07 0.00021 4.0932258023337865e-07 0 4.0934537289086155e-07 0 4.0935537289086156e-07 0.00021 4.0936537289086157e-07 0 4.093680876733975e-07 0 4.093780876733975e-07 0.00021 4.0938808767339753e-07 0 4.0938874184675933e-07 0 4.0939874184675934e-07 0.00021 4.0940874184675935e-07 0 4.0944701873477936e-07 0 4.094570187347794e-07 0.00021 4.094670187347794e-07 0 4.09473592441671e-07 0 4.0948359244167103e-07 0.00021 4.0949359244167104e-07 0 4.095949933988928e-07 0 4.096049933988928e-07 0.00021 4.0961499339889284e-07 0 4.0965205224210483e-07 0 4.0966205224210484e-07 0.00021 4.0967205224210485e-07 0 4.0967205224210485e-07 0 4.0968205224210487e-07 0.00021 4.096920522421049e-07 0 4.0969835340774327e-07 0 4.097083534077433e-07 0.00021 4.097183534077433e-07 0 4.0972036200567484e-07 0 4.0973036200567485e-07 0.00021 4.0974036200567486e-07 0 4.0975627820179865e-07 0 4.0976627820179866e-07 0.00021 4.0977627820179867e-07 0 4.097840927375333e-07 0 4.0979409273753333e-07 0.00021 4.0980409273753334e-07 0 4.0980409273753334e-07 0 4.0981409273753335e-07 0.00021 4.0982409273753337e-07 0 4.0982409273753337e-07 0 4.098340927375334e-07 0.00021 4.098440927375334e-07 0 4.0986130064451637e-07 0 4.098713006445164e-07 0.00021 4.098813006445164e-07 0 4.09918764962544e-07 0 4.0992876496254403e-07 0.00021 4.0993876496254404e-07 0 4.0993876496254404e-07 0 4.0994876496254405e-07 0.00021 4.0995876496254406e-07 0 4.0995876496254406e-07 0 4.099687649625441e-07 0.00021 4.099787649625441e-07 0 4.0998245519717676e-07 0 4.0999245519717677e-07 0.00021 4.100024551971768e-07 0 4.100024551971768e-07 0 4.100124551971768e-07 0.00021 4.100224551971768e-07 0 4.100224551971768e-07 0 4.100324551971768e-07 0.00021 4.100424551971768e-07 0 4.100424551971768e-07 0 4.1005245519717684e-07 0.00021 4.1006245519717685e-07 0 4.1006245519717685e-07 0 4.1007245519717686e-07 0.00021 4.1008245519717687e-07 0 4.1008245519717687e-07 0 4.100924551971769e-07 0.00021 4.101024551971769e-07 0 4.101024551971769e-07 0 4.101124551971769e-07 0.00021 4.101224551971769e-07 0 4.101224551971769e-07 0 4.1013245519717693e-07 0.00021 4.1014245519717694e-07 0 4.1014245519717694e-07 0 4.1015245519717695e-07 0.00021 4.1016245519717696e-07 0 4.1017721758522983e-07 0 4.1018721758522985e-07 0.00021 4.1019721758522986e-07 0 4.1021880630018105e-07 0 4.1022880630018106e-07 0.00021 4.102388063001811e-07 0 4.102388063001811e-07 0 4.102488063001811e-07 0.00021 4.102588063001811e-07 0 4.103251996437529e-07 0 4.1033519964375294e-07 0.00021 4.1034519964375295e-07 0 4.1036095465369566e-07 0 4.1037095465369567e-07 0.00021 4.103809546536957e-07 0 4.1038921428170407e-07 0 4.103992142817041e-07 0.00021 4.104092142817041e-07 0 4.104092142817041e-07 0 4.104192142817041e-07 0.00021 4.104292142817041e-07 0 4.104292142817041e-07 0 4.104392142817041e-07 0.00021 4.1044921428170413e-07 0 4.1044921428170413e-07 0 4.1045921428170414e-07 0.00021 4.1046921428170416e-07 0 4.1046921428170416e-07 0 4.1047921428170417e-07 0.00021 4.104892142817042e-07 0 4.104892142817042e-07 0 4.104992142817042e-07 0.00021 4.105092142817042e-07 0 4.105092142817042e-07 0 4.105192142817042e-07 0.00021 4.105292142817042e-07 0 4.105292142817042e-07 0 4.1053921428170424e-07 0.00021 4.1054921428170425e-07 0 4.1054921428170425e-07 0 4.1055921428170426e-07 0.00021 4.1056921428170427e-07 0 4.1056921428170427e-07 0 4.105792142817043e-07 0.00021 4.105892142817043e-07 0 4.105892142817043e-07 0 4.105992142817043e-07 0.00021 4.106092142817043e-07 0 4.106231328825396e-07 0 4.106331328825396e-07 0.00021 4.106431328825396e-07 0 4.106431328825396e-07 0 4.1065313288253964e-07 0.00021 4.1066313288253965e-07 0 4.1068399694610516e-07 0 4.1069399694610517e-07 0.00021 4.107039969461052e-07 0 4.107039969461052e-07 0 4.107139969461052e-07 0.00021 4.107239969461052e-07 0 4.107239969461052e-07 0 4.107339969461052e-07 0.00021 4.1074399694610523e-07 0 4.1074399694610523e-07 0 4.1075399694610524e-07 0.00021 4.1076399694610525e-07 0 4.1076399694610525e-07 0 4.1077399694610526e-07 0.00021 4.107839969461053e-07 0 4.107839969461053e-07 0 4.107939969461053e-07 0.00021 4.108039969461053e-07 0 4.108039969461053e-07 0 4.108139969461053e-07 0.00021 4.108239969461053e-07 0 4.108239969461053e-07 0 4.1083399694610533e-07 0.00021 4.1084399694610534e-07 0 4.1084399694610534e-07 0 4.1085399694610535e-07 0.00021 4.1086399694610537e-07 0 4.1086399694610537e-07 0 4.108739969461054e-07 0.00021 4.108839969461054e-07 0 4.108839969461054e-07 0 4.108939969461054e-07 0.00021 4.109039969461054e-07 0 4.109039969461054e-07 0 4.109139969461054e-07 0.00021 4.1092399694610543e-07 0 4.1092399694610543e-07 0 4.1093399694610545e-07 0.00021 4.1094399694610546e-07 0 4.1094399694610546e-07 0 4.1095399694610547e-07 0.00021 4.109639969461055e-07 0 4.109639969461055e-07 0 4.109739969461055e-07 0.00021 4.109839969461055e-07 0 4.109839969461055e-07 0 4.109939969461055e-07 0.00021 4.110039969461055e-07 0 4.110039969461055e-07 0 4.1101399694610554e-07 0.00021 4.1102399694610555e-07 0 4.1102399694610555e-07 0 4.1103399694610556e-07 0.00021 4.1104399694610557e-07 0 4.1104399694610557e-07 0 4.110539969461056e-07 0.00021 4.110639969461056e-07 0 4.110639969461056e-07 0 4.110739969461056e-07 0.00021 4.110839969461056e-07 0 4.1109758429126593e-07 0 4.1110758429126594e-07 0.00021 4.1111758429126595e-07 0 4.1112622397346237e-07 0 4.111362239734624e-07 0.00021 4.111462239734624e-07 0 4.1115884194262624e-07 0 4.1116884194262625e-07 0.00021 4.1117884194262626e-07 0 4.1119121570358514e-07 0 4.1120121570358515e-07 0.00021 4.1121121570358517e-07 0 4.1121121570358517e-07 0 4.112212157035852e-07 0.00021 4.112312157035852e-07 0 4.112312157035852e-07 0 4.112412157035852e-07 0.00021 4.112512157035852e-07 0 4.1127604804243675e-07 0 4.1128604804243676e-07 0.00021 4.1129604804243677e-07 0 4.1129604804243677e-07 0 4.113060480424368e-07 0.00021 4.113160480424368e-07 0 4.113160480424368e-07 0 4.113260480424368e-07 0.00021 4.113360480424368e-07 0 4.1138851397266576e-07 0 4.1139851397266577e-07 0.00021 4.114085139726658e-07 0 4.114085139726658e-07 0 4.114185139726658e-07 0.00021 4.114285139726658e-07 0 4.115020040720109e-07 0 4.115120040720109e-07 0.00021 4.115220040720109e-07 0 4.115220040720109e-07 0 4.115320040720109e-07 0.00021 4.1154200407201094e-07 0 4.1154200407201094e-07 0 4.1155200407201095e-07 0.00021 4.1156200407201096e-07 0 4.1157800780222004e-07 0 4.1158800780222005e-07 0.00021 4.1159800780222006e-07 0 4.1159800780222006e-07 0 4.116080078022201e-07 0.00021 4.116180078022201e-07 0 4.116521961824021e-07 0 4.1166219618240213e-07 0.00021 4.1167219618240214e-07 0 4.116953046250115e-07 0 4.117053046250115e-07 0.00021 4.117153046250115e-07 0 4.1182487533997027e-07 0 4.118348753399703e-07 0.00021 4.118448753399703e-07 0 4.1190196832961575e-07 0 4.1191196832961576e-07 0.00021 4.1192196832961577e-07 0 4.1192196832961577e-07 0 4.119319683296158e-07 0.00021 4.119419683296158e-07 0 4.119641082719145e-07 0 4.119741082719145e-07 0.00021 4.119841082719145e-07 0 4.119841082719145e-07 0 4.119941082719145e-07 0.00021 4.120041082719145e-07 0 4.1209138721352476e-07 0 4.1210138721352477e-07 0.00021 4.121113872135248e-07 0 4.121113872135248e-07 0 4.121213872135248e-07 0.00021 4.121313872135248e-07 0 4.121313872135248e-07 0 4.121413872135248e-07 0.00021 4.1215138721352483e-07 0 4.1215138721352483e-07 0 4.1216138721352484e-07 0.00021 4.1217138721352485e-07 0 4.1217634157471386e-07 0 4.1218634157471387e-07 0.00021 4.121963415747139e-07 0 4.121963415747139e-07 0 4.122063415747139e-07 0.00021 4.122163415747139e-07 0 4.122163415747139e-07 0 4.122263415747139e-07 0.00021 4.122363415747139e-07 0 4.122363415747139e-07 0 4.1224634157471394e-07 0.00021 4.1225634157471395e-07 0 4.1225634157471395e-07 0 4.1226634157471396e-07 0.00021 4.1227634157471397e-07 0 4.1227634157471397e-07 0 4.12286341574714e-07 0.00021 4.12296341574714e-07 0 4.123087016463643e-07 0 4.123187016463643e-07 0.00021 4.123287016463643e-07 0 4.1235926215042727e-07 0 4.123692621504273e-07 0.00021 4.123792621504273e-07 0 4.123843685333031e-07 0 4.1239436853330313e-07 0.00021 4.1240436853330314e-07 0 4.124467724105036e-07 0 4.1245677241050363e-07 0.00021 4.1246677241050364e-07 0 4.1246677241050364e-07 0 4.1247677241050365e-07 0.00021 4.1248677241050367e-07 0 4.1248677241050367e-07 0 4.124967724105037e-07 0.00021 4.125067724105037e-07 0 4.125067724105037e-07 0 4.125167724105037e-07 0.00021 4.125267724105037e-07 0 4.1257729049737687e-07 0 4.125872904973769e-07 0.00021 4.125972904973769e-07 0 4.126040965135869e-07 0 4.126140965135869e-07 0.00021 4.126240965135869e-07 0 4.1262624192207004e-07 0 4.1263624192207005e-07 0.00021 4.1264624192207006e-07 0 4.1264624192207006e-07 0 4.126562419220701e-07 0.00021 4.126662419220701e-07 0 4.126662419220701e-07 0 4.126762419220701e-07 0.00021 4.126862419220701e-07 0 4.126862419220701e-07 0 4.126962419220701e-07 0.00021 4.1270624192207013e-07 0 4.1271132003426123e-07 0 4.1272132003426124e-07 0.00021 4.1273132003426125e-07 0 4.1273132003426125e-07 0 4.1274132003426126e-07 0.00021 4.127513200342613e-07 0 4.1276069023106663e-07 0 4.1277069023106664e-07 0.00021 4.1278069023106665e-07 0 4.127813116785426e-07 0 4.127913116785426e-07 0.00021 4.128013116785426e-07 0 4.128697208052499e-07 0 4.128797208052499e-07 0.00021 4.128897208052499e-07 0 4.1294377136830915e-07 0 4.1295377136830917e-07 0.00021 4.129637713683092e-07 0 4.129637713683092e-07 0 4.129737713683092e-07 0.00021 4.129837713683092e-07 0 4.130098573705682e-07 0 4.130198573705682e-07 0.00021 4.1302985737056823e-07 0 4.130465936899607e-07 0 4.130565936899607e-07 0.00021 4.130665936899607e-07 0 4.1307334172825773e-07 0 4.1308334172825774e-07 0.00021 4.1309334172825775e-07 0 4.1309334172825775e-07 0 4.1310334172825776e-07 0.00021 4.1311334172825777e-07 0 4.1311334172825777e-07 0 4.131233417282578e-07 0.00021 4.131333417282578e-07 0 4.131333417282578e-07 0 4.131433417282578e-07 0.00021 4.131533417282578e-07 0 4.1319820159827944e-07 0 4.1320820159827945e-07 0.00021 4.1321820159827946e-07 0 4.132662684846219e-07 0 4.1327626848462193e-07 0.00021 4.1328626848462194e-07 0 4.132916402344951e-07 0 4.1330164023449514e-07 0.00021 4.1331164023449515e-07 0 4.1331164023449515e-07 0 4.1332164023449516e-07 0.00021 4.1333164023449517e-07 0 4.1333164023449517e-07 0 4.133416402344952e-07 0.00021 4.133516402344952e-07 0 4.133516402344952e-07 0 4.133616402344952e-07 0.00021 4.133716402344952e-07 0 4.133716402344952e-07 0 4.1338164023449523e-07 0.00021 4.1339164023449524e-07 0 4.1351368147578986e-07 0 4.1352368147578987e-07 0.00021 4.135336814757899e-07 0 4.135336814757899e-07 0 4.135436814757899e-07 0.00021 4.135536814757899e-07 0 4.136125595178895e-07 0 4.1362255951788954e-07 0.00021 4.1363255951788955e-07 0 4.1363255951788955e-07 0 4.1364255951788956e-07 0.00021 4.1365255951788957e-07 0 4.1366192278649576e-07 0 4.136719227864958e-07 0.00021 4.136819227864958e-07 0 4.137053803412089e-07 0 4.137153803412089e-07 0.00021 4.137253803412089e-07 0 4.137715762271724e-07 0 4.137815762271724e-07 0.00021 4.1379157622717244e-07 0 4.138637850325746e-07 0 4.138737850325746e-07 0.00021 4.1388378503257463e-07 0 4.13947095795994e-07 0 4.13957095795994e-07 0.00021 4.13967095795994e-07 0 4.13967095795994e-07 0 4.13977095795994e-07 0.00021 4.1398709579599404e-07 0 4.1398709579599404e-07 0 4.1399709579599405e-07 0.00021 4.1400709579599406e-07 0 4.140131382200106e-07 0 4.140231382200106e-07 0.00021 4.140331382200106e-07 0 4.1405080159293844e-07 0 4.1406080159293845e-07 0.00021 4.1407080159293846e-07 0 4.14127760965063e-07 0 4.14137760965063e-07 0.00021 4.1414776096506303e-07 0 4.142114226133468e-07 0 4.142214226133468e-07 0.00021 4.142314226133468e-07 0 4.142396254782604e-07 0 4.1424962547826043e-07 0.00021 4.1425962547826045e-07 0 4.142627515717634e-07 0 4.1427275157176343e-07 0.00021 4.1428275157176344e-07 0 4.1428518824228086e-07 0 4.1429518824228087e-07 0.00021 4.143051882422809e-07 0 4.144437478890249e-07 0 4.144537478890249e-07 0.00021 4.1446374788902493e-07 0 4.1454335225923845e-07 0 4.1455335225923846e-07 0.00021 4.1456335225923847e-07 0 4.1456335225923847e-07 0 4.145733522592385e-07 0.00021 4.145833522592385e-07 0 4.1466556141985225e-07 0 4.1467556141985226e-07 0.00021 4.1468556141985227e-07 0 4.147100549280616e-07 0 4.1472005492806164e-07 0.00021 4.1473005492806165e-07 0 4.147549482279493e-07 0 4.147649482279493e-07 0.00021 4.1477494822794933e-07 0 4.148497662073722e-07 0 4.148597662073722e-07 0.00021 4.148697662073722e-07 0 4.1490864811180657e-07 0 4.149186481118066e-07 0.00021 4.149286481118066e-07 0 4.149468714502917e-07 0 4.149568714502917e-07 0.00021 4.149668714502917e-07 0 4.149668714502917e-07 0 4.149768714502917e-07 0.00021 4.1498687145029173e-07 0 4.1498687145029173e-07 0 4.1499687145029174e-07 0.00021 4.1500687145029175e-07 0 4.1500687145029175e-07 0 4.1501687145029177e-07 0.00021 4.150268714502918e-07 0 4.150268714502918e-07 0 4.150368714502918e-07 0.00021 4.150468714502918e-07 0 4.150793940178994e-07 0 4.150893940178994e-07 0.00021 4.150993940178994e-07 0 4.151134032317536e-07 0 4.151234032317536e-07 0.00021 4.151334032317536e-07 0 4.151334032317536e-07 0 4.151434032317536e-07 0.00021 4.1515340323175363e-07 0 4.1515340323175363e-07 0 4.1516340323175364e-07 0.00021 4.1517340323175365e-07 0 4.1517340323175365e-07 0 4.1518340323175367e-07 0.00021 4.151934032317537e-07 0 4.151934032317537e-07 0 4.152034032317537e-07 0.00021 4.152134032317537e-07 0 4.152134032317537e-07 0 4.152234032317537e-07 0.00021 4.152334032317537e-07 0 4.152334032317537e-07 0 4.1524340323175373e-07 0.00021 4.1525340323175375e-07 0 4.1525340323175375e-07 0 4.1526340323175376e-07 0.00021 4.1527340323175377e-07 0 4.1527340323175377e-07 0 4.152834032317538e-07 0.00021 4.152934032317538e-07 0 4.152934032317538e-07 0 4.153034032317538e-07 0.00021 4.153134032317538e-07 0 4.153134032317538e-07 0 4.153234032317538e-07 0.00021 4.1533340323175384e-07 0 4.1533340323175384e-07 0 4.1534340323175385e-07 0.00021 4.1535340323175386e-07 0 4.1535340323175386e-07 0 4.1536340323175387e-07 0.00021 4.153734032317539e-07 0 4.153734032317539e-07 0 4.153834032317539e-07 0.00021 4.153934032317539e-07 0 4.153934032317539e-07 0 4.154034032317539e-07 0.00021 4.1541340323175393e-07 0 4.1541340323175393e-07 0 4.1542340323175394e-07 0.00021 4.1543340323175395e-07 0 4.1543340323175395e-07 0 4.1544340323175396e-07 0.00021 4.1545340323175397e-07 0 4.1545340323175397e-07 0 4.15463403231754e-07 0.00021 4.15473403231754e-07 0 4.15473403231754e-07 0 4.15483403231754e-07 0.00021 4.15493403231754e-07 0 4.155105563775116e-07 0 4.1552055637751164e-07 0.00021 4.1553055637751165e-07 0 4.1553055637751165e-07 0 4.1554055637751166e-07 0.00021 4.1555055637751167e-07 0 4.156534217458008e-07 0 4.1566342174580084e-07 0.00021 4.1567342174580085e-07 0 4.1569303580711613e-07 0 4.1570303580711614e-07 0.00021 4.1571303580711616e-07 0 4.157160168214059e-07 0 4.157260168214059e-07 0.00021 4.157360168214059e-07 0 4.157360168214059e-07 0 4.157460168214059e-07 0.00021 4.157560168214059e-07 0 4.157560168214059e-07 0 4.1576601682140594e-07 0.00021 4.1577601682140595e-07 0 4.1578146750214173e-07 0 4.1579146750214175e-07 0.00021 4.1580146750214176e-07 0 4.1580146750214176e-07 0 4.1581146750214177e-07 0.00021 4.158214675021418e-07 0 4.1584142491342114e-07 0 4.1585142491342115e-07 0.00021 4.1586142491342116e-07 0 4.1586142491342116e-07 0 4.158714249134212e-07 0.00021 4.158814249134212e-07 0 4.158814249134212e-07 0 4.158914249134212e-07 0.00021 4.159014249134212e-07 0 4.159014249134212e-07 0 4.159114249134212e-07 0.00021 4.1592142491342123e-07 0 4.1594431647008194e-07 0 4.1595431647008195e-07 0.00021 4.1596431647008196e-07 0 4.1596431647008196e-07 0 4.15974316470082e-07 0.00021 4.15984316470082e-07 0 4.1599663332785954e-07 0 4.1600663332785955e-07 0.00021 4.1601663332785956e-07 0 4.16024577016766e-07 0 4.16034577016766e-07 0.00021 4.16044577016766e-07 0 4.160475975075782e-07 0 4.160575975075782e-07 0.00021 4.160675975075782e-07 0 4.160675975075782e-07 0 4.160775975075782e-07 0.00021 4.1608759750757823e-07 0 4.1608759750757823e-07 0 4.1609759750757824e-07 0.00021 4.1610759750757825e-07 0 4.1615963513778657e-07 0 4.161696351377866e-07 0.00021 4.161796351377866e-07 0 4.162047949354242e-07 0 4.162147949354242e-07 0.00021 4.162247949354242e-07 0 4.162247949354242e-07 0 4.162347949354242e-07 0.00021 4.162447949354242e-07 0 4.162447949354242e-07 0 4.1625479493542423e-07 0.00021 4.1626479493542425e-07 0 4.162688666107532e-07 0 4.162788666107532e-07 0.00021 4.162888666107532e-07 0 4.1629838444407465e-07 0 4.1630838444407467e-07 0.00021 4.163183844440747e-07 0 4.1637793464675094e-07 0 4.1638793464675096e-07 0.00021 4.1639793464675097e-07 0 4.1639793464675097e-07 0 4.16407934646751e-07 0.00021 4.16417934646751e-07 0 4.165231384336459e-07 0 4.165331384336459e-07 0.00021 4.165431384336459e-07 0 4.165537046236247e-07 0 4.1656370462362473e-07 0.00021 4.1657370462362475e-07 0 4.1657370462362475e-07 0 4.1658370462362476e-07 0.00021 4.1659370462362477e-07 0 4.1659370462362477e-07 0 4.166037046236248e-07 0.00021 4.166137046236248e-07 0 4.166137046236248e-07 0 4.166237046236248e-07 0.00021 4.166337046236248e-07 0 4.167043917291108e-07 0 4.167143917291108e-07 0.00021 4.167243917291108e-07 0 4.167243917291108e-07 0 4.167343917291108e-07 0.00021 4.167443917291108e-07 0 4.167521834419168e-07 0 4.167621834419168e-07 0.00021 4.167721834419168e-07 0 4.167721834419168e-07 0 4.167821834419168e-07 0.00021 4.1679218344191683e-07 0 4.1679218344191683e-07 0 4.1680218344191684e-07 0.00021 4.1681218344191685e-07 0 4.1681218344191685e-07 0 4.1682218344191686e-07 0.00021 4.1683218344191687e-07 0 4.168361373644752e-07 0 4.168461373644752e-07 0.00021 4.168561373644752e-07 0 4.1685998189252907e-07 0 4.168699818925291e-07 0.00021 4.168799818925291e-07 0 4.168823209186663e-07 0 4.1689232091866633e-07 0.00021 4.1690232091866634e-07 0 4.1690232091866634e-07 0 4.1691232091866636e-07 0.00021 4.1692232091866637e-07 0 4.1692232091866637e-07 0 4.169323209186664e-07 0.00021 4.169423209186664e-07 0 4.169423209186664e-07 0 4.169523209186664e-07 0.00021 4.169623209186664e-07 0 4.1699505830131086e-07 0 4.1700505830131087e-07 0.00021 4.170150583013109e-07 0 4.170150583013109e-07 0 4.170250583013109e-07 0.00021 4.170350583013109e-07 0 4.170836695625742e-07 0 4.170936695625742e-07 0.00021 4.171036695625742e-07 0 4.171036695625742e-07 0 4.171136695625742e-07 0.00021 4.1712366956257423e-07 0 4.1712366956257423e-07 0 4.1713366956257424e-07 0.00021 4.1714366956257425e-07 0 4.1714366956257425e-07 0 4.1715366956257426e-07 0.00021 4.171636695625743e-07 0 4.171636695625743e-07 0 4.171736695625743e-07 0.00021 4.171836695625743e-07 0 4.171836695625743e-07 0 4.171936695625743e-07 0.00021 4.172036695625743e-07 0 4.172636722836239e-07 0 4.172736722836239e-07 0.00021 4.172836722836239e-07 0 4.1728890457558943e-07 0 4.1729890457558944e-07 0.00021 4.1730890457558945e-07 0 4.1733339297585767e-07 0 4.173433929758577e-07 0.00021 4.173533929758577e-07 0 4.1736688353049854e-07 0 4.1737688353049855e-07 0.00021 4.1738688353049856e-07 0 4.1748432606302065e-07 0 4.1749432606302066e-07 0.00021 4.175043260630207e-07 0 4.175043260630207e-07 0 4.175143260630207e-07 0.00021 4.175243260630207e-07 0 4.175243260630207e-07 0 4.175343260630207e-07 0.00021 4.175443260630207e-07 0 4.175443260630207e-07 0 4.1755432606302073e-07 0.00021 4.1756432606302074e-07 0 4.1756432606302074e-07 0 4.1757432606302076e-07 0.00021 4.1758432606302077e-07 0 4.1758432606302077e-07 0 4.175943260630208e-07 0.00021 4.176043260630208e-07 0 4.176043260630208e-07 0 4.176143260630208e-07 0.00021 4.176243260630208e-07 0 4.176243260630208e-07 0 4.176343260630208e-07 0.00021 4.1764432606302083e-07 0 4.1764432606302083e-07 0 4.1765432606302085e-07 0.00021 4.1766432606302086e-07 0 4.1766432606302086e-07 0 4.1767432606302087e-07 0.00021 4.176843260630209e-07 0 4.176843260630209e-07 0 4.176943260630209e-07 0.00021 4.177043260630209e-07 0 4.177043260630209e-07 0 4.177143260630209e-07 0.00021 4.177243260630209e-07 0 4.177243260630209e-07 0 4.1773432606302094e-07 0.00021 4.1774432606302095e-07 0 4.1774432606302095e-07 0 4.1775432606302096e-07 0.00021 4.1776432606302097e-07 0 4.1776432606302097e-07 0 4.17774326063021e-07 0.00021 4.17784326063021e-07 0 4.17784326063021e-07 0 4.17794326063021e-07 0.00021 4.17804326063021e-07 0 4.17804326063021e-07 0 4.1781432606302103e-07 0.00021 4.1782432606302104e-07 0 4.1782432606302104e-07 0 4.1783432606302105e-07 0.00021 4.1784432606302106e-07 0 4.178781451869078e-07 0 4.178881451869078e-07 0.00021 4.178981451869078e-07 0 4.178981451869078e-07 0 4.1790814518690783e-07 0.00021 4.1791814518690785e-07 0 4.1791814518690785e-07 0 4.1792814518690786e-07 0.00021 4.1793814518690787e-07 0 4.1793814518690787e-07 0 4.179481451869079e-07 0.00021 4.179581451869079e-07 0 4.179581451869079e-07 0 4.179681451869079e-07 0.00021 4.179781451869079e-07 0 4.1802124016655064e-07 0 4.1803124016655065e-07 0.00021 4.1804124016655066e-07 0 4.180919935078447e-07 0 4.181019935078447e-07 0.00021 4.181119935078447e-07 0 4.181119935078447e-07 0 4.181219935078447e-07 0.00021 4.181319935078447e-07 0 4.1816253294161414e-07 0 4.1817253294161415e-07 0.00021 4.1818253294161416e-07 0 4.1818253294161416e-07 0 4.1819253294161417e-07 0.00021 4.182025329416142e-07 0 4.182300952395616e-07 0 4.182400952395616e-07 0.00021 4.182500952395616e-07 0 4.1826025802386227e-07 0 4.182702580238623e-07 0.00021 4.182802580238623e-07 0 4.183542236145047e-07 0 4.1836422361450474e-07 0.00021 4.1837422361450475e-07 0 4.183996963443866e-07 0 4.184096963443866e-07 0.00021 4.184196963443866e-07 0 4.184196963443866e-07 0 4.1842969634438663e-07 0.00021 4.1843969634438664e-07 0 4.1843969634438664e-07 0 4.1844969634438666e-07 0.00021 4.1845969634438667e-07 0 4.1845969634438667e-07 0 4.184696963443867e-07 0.00021 4.184796963443867e-07 0 4.1857761232423775e-07 0 4.1858761232423776e-07 0.00021 4.185976123242378e-07 0 4.186355946902879e-07 0 4.186455946902879e-07 0.00021 4.1865559469028794e-07 0 4.186584353604151e-07 0 4.1866843536041513e-07 0.00021 4.1867843536041514e-07 0 4.1868364977087075e-07 0 4.1869364977087076e-07 0.00021 4.187036497708708e-07 0 4.1871377411176653e-07 0 4.1872377411176654e-07 0.00021 4.1873377411176655e-07 0 4.187381454134171e-07 0 4.187481454134171e-07 0.00021 4.187581454134171e-07 0 4.1877092367211333e-07 0 4.1878092367211335e-07 0.00021 4.1879092367211336e-07 0 4.188067602036703e-07 0 4.1881676020367033e-07 0.00021 4.1882676020367034e-07 0 4.1882968676355375e-07 0 4.1883968676355376e-07 0.00021 4.1884968676355377e-07 0 4.1885107447397687e-07 0 4.188610744739769e-07 0.00021 4.188710744739769e-07 0 4.1888689707243533e-07 0 4.1889689707243534e-07 0.00021 4.1890689707243535e-07 0 4.1895930204546385e-07 0 4.1896930204546387e-07 0.00021 4.189793020454639e-07 0 4.19048037675823e-07 0 4.19058037675823e-07 0.00021 4.19068037675823e-07 0 4.19068037675823e-07 0 4.19078037675823e-07 0.00021 4.1908803767582303e-07 0 4.1908803767582303e-07 0 4.1909803767582304e-07 0.00021 4.1910803767582305e-07 0 4.191440305891806e-07 0 4.191540305891806e-07 0.00021 4.191640305891806e-07 0 4.191640305891806e-07 0 4.1917403058918063e-07 0.00021 4.1918403058918064e-07 0 4.1918403058918064e-07 0 4.1919403058918065e-07 0.00021 4.1920403058918066e-07 0 4.1920403058918066e-07 0 4.192140305891807e-07 0.00021 4.192240305891807e-07 0 4.192240305891807e-07 0 4.192340305891807e-07 0.00021 4.192440305891807e-07 0 4.192938489823775e-07 0 4.193038489823775e-07 0.00021 4.1931384898237753e-07 0 4.1931455277836145e-07 0 4.1932455277836147e-07 0.00021 4.193345527783615e-07 0 4.193345527783615e-07 0 4.193445527783615e-07 0.00021 4.193545527783615e-07 0 4.193545527783615e-07 0 4.193645527783615e-07 0.00021 4.193745527783615e-07 0 4.193745527783615e-07 0 4.1938455277836153e-07 0.00021 4.1939455277836154e-07 0 4.1939455277836154e-07 0 4.1940455277836156e-07 0.00021 4.1941455277836157e-07 0 4.1941455277836157e-07 0 4.194245527783616e-07 0.00021 4.194345527783616e-07 0 4.1943488523319873e-07 0 4.1944488523319875e-07 0.00021 4.1945488523319876e-07 0 4.1948573240386746e-07 0 4.1949573240386747e-07 0.00021 4.195057324038675e-07 0 4.196482270700055e-07 0 4.196582270700055e-07 0.00021 4.196682270700055e-07 0 4.1968712404522215e-07 0 4.1969712404522217e-07 0.00021 4.197071240452222e-07 0 4.197071240452222e-07 0 4.197171240452222e-07 0.00021 4.197271240452222e-07 0 4.197271240452222e-07 0 4.197371240452222e-07 0.00021 4.197471240452222e-07 0 4.197471240452222e-07 0 4.1975712404522223e-07 0.00021 4.1976712404522224e-07 0 4.1976712404522224e-07 0 4.1977712404522226e-07 0.00021 4.1978712404522227e-07 0 4.1986144445691985e-07 0 4.1987144445691986e-07 0.00021 4.198814444569199e-07 0 4.198814444569199e-07 0 4.198914444569199e-07 0.00021 4.199014444569199e-07 0 4.1992343051140516e-07 0 4.1993343051140517e-07 0.00021 4.199434305114052e-07 0 4.199434305114052e-07 0 4.199534305114052e-07 0.00021 4.199634305114052e-07 0 4.199634305114052e-07 0 4.199734305114052e-07 0.00021 4.1998343051140523e-07 0 4.1998343051140523e-07 0 4.1999343051140524e-07 0.00021 4.2000343051140525e-07 0 4.2000343051140525e-07 0 4.2001343051140526e-07 0.00021 4.200234305114053e-07 0 4.2008987781111285e-07 0 4.2009987781111286e-07 0.00021 4.2010987781111287e-07 0 4.2010987781111287e-07 0 4.201198778111129e-07 0.00021 4.201298778111129e-07 0 4.2013846007993437e-07 0 4.201484600799344e-07 0.00021 4.201584600799344e-07 0 4.2018384338136e-07 0 4.2019384338136004e-07 0.00021 4.2020384338136005e-07 0 4.202754279765491e-07 0 4.202854279765491e-07 0.00021 4.202954279765491e-07 0 4.202954279765491e-07 0 4.203054279765491e-07 0.00021 4.2031542797654913e-07 0 4.2031542797654913e-07 0 4.2032542797654914e-07 0.00021 4.2033542797654915e-07 0 4.2033542797654915e-07 0 4.2034542797654917e-07 0.00021 4.203554279765492e-07 0 4.203554279765492e-07 0 4.203654279765492e-07 0.00021 4.203754279765492e-07 0 4.203754279765492e-07 0 4.203854279765492e-07 0.00021 4.203954279765492e-07 0 4.203954279765492e-07 0 4.2040542797654923e-07 0.00021 4.2041542797654924e-07 0 4.2041542797654924e-07 0 4.2042542797654926e-07 0.00021 4.2043542797654927e-07 0 4.2043542797654927e-07 0 4.204454279765493e-07 0.00021 4.204554279765493e-07 0 4.204554279765493e-07 0 4.204654279765493e-07 0.00021 4.204754279765493e-07 0 4.204754279765493e-07 0 4.204854279765493e-07 0.00021 4.2049542797654934e-07 0 4.205153861087207e-07 0 4.205253861087207e-07 0.00021 4.205353861087207e-07 0 4.205524140077495e-07 0 4.2056241400774953e-07 0.00021 4.2057241400774954e-07 0 4.2060630446840005e-07 0 4.2061630446840006e-07 0.00021 4.206263044684001e-07 0 4.2065086496974246e-07 0 4.2066086496974247e-07 0.00021 4.206708649697425e-07 0 4.206708649697425e-07 0 4.206808649697425e-07 0.00021 4.206908649697425e-07 0 4.206908649697425e-07 0 4.207008649697425e-07 0.00021 4.2071086496974253e-07 0 4.207112682526318e-07 0 4.2072126825263183e-07 0.00021 4.2073126825263184e-07 0 4.207322766784858e-07 0 4.207422766784858e-07 0.00021 4.2075227667848583e-07 0 4.207792566411991e-07 0 4.207892566411991e-07 0.00021 4.2079925664119913e-07 0 4.2079925664119913e-07 0 4.2080925664119915e-07 0.00021 4.2081925664119916e-07 0 4.2082319478087096e-07 0 4.20833194780871e-07 0.00021 4.20843194780871e-07 0 4.2085968622289063e-07 0 4.2086968622289064e-07 0.00021 4.2087968622289065e-07 0 4.2099938148952136e-07 0 4.2100938148952137e-07 0.00021 4.210193814895214e-07 0 4.210193814895214e-07 0 4.210293814895214e-07 0.00021 4.210393814895214e-07 0 4.210393814895214e-07 0 4.210493814895214e-07 0.00021 4.2105938148952143e-07 0 4.2105938148952143e-07 0 4.2106938148952144e-07 0.00021 4.2107938148952145e-07 0 4.2107938148952145e-07 0 4.2108938148952146e-07 0.00021 4.2109938148952147e-07 0 4.2109938148952147e-07 0 4.211093814895215e-07 0.00021 4.211193814895215e-07 0 4.211193814895215e-07 0 4.211293814895215e-07 0.00021 4.211393814895215e-07 0 4.211393814895215e-07 0 4.2114938148952153e-07 0.00021 4.2115938148952154e-07 0 4.2115938148952154e-07 0 4.2116938148952155e-07 0.00021 4.2117938148952156e-07 0 4.211893949874938e-07 0 4.211993949874938e-07 0.00021 4.212093949874938e-07 0 4.212093949874938e-07 0 4.212193949874938e-07 0.00021 4.212293949874938e-07 0 4.212355672179111e-07 0 4.212455672179111e-07 0.00021 4.212555672179111e-07 0 4.212555672179111e-07 0 4.212655672179111e-07 0.00021 4.212755672179111e-07 0 4.212755672179111e-07 0 4.2128556721791113e-07 0.00021 4.2129556721791114e-07 0 4.2129640354827365e-07 0 4.2130640354827366e-07 0.00021 4.2131640354827367e-07 0 4.213501819997691e-07 0 4.213601819997691e-07 0.00021 4.213701819997691e-07 0 4.2138960836549906e-07 0 4.2139960836549907e-07 0.00021 4.214096083654991e-07 0 4.214721193549826e-07 0 4.214821193549826e-07 0.00021 4.214921193549826e-07 0 4.214921193549826e-07 0 4.2150211935498263e-07 0.00021 4.2151211935498265e-07 0 4.2151211935498265e-07 0 4.2152211935498266e-07 0.00021 4.2153211935498267e-07 0 4.2153211935498267e-07 0 4.215421193549827e-07 0.00021 4.215521193549827e-07 0 4.215521193549827e-07 0 4.215621193549827e-07 0.00021 4.215721193549827e-07 0 4.215721193549827e-07 0 4.215821193549827e-07 0.00021 4.2159211935498274e-07 0 4.2161305529563085e-07 0 4.2162305529563086e-07 0.00021 4.2163305529563087e-07 0 4.2165357980892566e-07 0 4.2166357980892567e-07 0.00021 4.216735798089257e-07 0 4.216735798089257e-07 0 4.216835798089257e-07 0.00021 4.216935798089257e-07 0 4.217284599505602e-07 0 4.217384599505602e-07 0.00021 4.217484599505602e-07 0 4.218049659897528e-07 0 4.218149659897528e-07 0.00021 4.218249659897528e-07 0 4.21864881828253e-07 0 4.21874881828253e-07 0.00021 4.21884881828253e-07 0 4.21884881828253e-07 0 4.21894881828253e-07 0.00021 4.21904881828253e-07 0 4.21904881828253e-07 0 4.2191488182825303e-07 0.00021 4.2192488182825304e-07 0 4.2192488182825304e-07 0 4.2193488182825305e-07 0.00021 4.2194488182825306e-07 0 4.2194488182825306e-07 0 4.219548818282531e-07 0.00021 4.219648818282531e-07 0 4.219648818282531e-07 0 4.219748818282531e-07 0.00021 4.219848818282531e-07 0 4.219848818282531e-07 0 4.219948818282531e-07 0.00021 4.2200488182825313e-07 0 4.2200488182825313e-07 0 4.2201488182825314e-07 0.00021 4.2202488182825316e-07 0 4.2202488182825316e-07 0 4.2203488182825317e-07 0.00021 4.220448818282532e-07 0 4.220998601379836e-07 0 4.221098601379836e-07 0.00021 4.221198601379836e-07 0 4.221198601379836e-07 0 4.2212986013798363e-07 0.00021 4.2213986013798364e-07 0 4.221428616436226e-07 0 4.221528616436226e-07 0.00021 4.221628616436226e-07 0 4.2217532440138426e-07 0 4.2218532440138427e-07 0.00021 4.221953244013843e-07 0 4.221989078583321e-07 0 4.2220890785833213e-07 0.00021 4.2221890785833214e-07 0 4.2221890785833214e-07 0 4.2222890785833215e-07 0.00021 4.2223890785833216e-07 0 4.2223890785833216e-07 0 4.2224890785833217e-07 0.00021 4.222589078583322e-07 0 4.222589078583322e-07 0 4.222689078583322e-07 0.00021 4.222789078583322e-07 0 4.222789078583322e-07 0 4.222889078583322e-07 0.00021 4.2229890785833223e-07 0 4.2229890785833223e-07 0 4.2230890785833224e-07 0.00021 4.2231890785833225e-07 0 4.2231890785833225e-07 0 4.2232890785833226e-07 0.00021 4.223389078583323e-07 0 4.223389078583323e-07 0 4.223489078583323e-07 0.00021 4.223589078583323e-07 0 4.223912782336254e-07 0 4.224012782336254e-07 0.00021 4.224112782336254e-07 0 4.224112782336254e-07 0 4.224212782336254e-07 0.00021 4.2243127823362543e-07 0 4.224401498549632e-07 0 4.224501498549632e-07 0.00021 4.2246014985496324e-07 0 4.2246014985496324e-07 0 4.2247014985496325e-07 0.00021 4.2248014985496326e-07 0 4.2249803343289254e-07 0 4.2250803343289255e-07 0.00021 4.2251803343289256e-07 0 4.2251803343289256e-07 0 4.2252803343289257e-07 0.00021 4.225380334328926e-07 0 4.225695848939773e-07 0 4.225795848939773e-07 0.00021 4.225895848939773e-07 0 4.226252040360984e-07 0 4.226352040360984e-07 0.00021 4.2264520403609844e-07 0 4.2265887321107663e-07 0 4.2266887321107664e-07 0.00021 4.2267887321107665e-07 0 4.2267887321107665e-07 0 4.2268887321107666e-07 0.00021 4.226988732110767e-07 0 4.226988732110767e-07 0 4.227088732110767e-07 0.00021 4.227188732110767e-07 0 4.227188732110767e-07 0 4.227288732110767e-07 0.00021 4.227388732110767e-07 0 4.227388732110767e-07 0 4.2274887321107673e-07 0.00021 4.2275887321107674e-07 0 4.2275887321107674e-07 0 4.2276887321107675e-07 0.00021 4.2277887321107677e-07 0 4.2277887321107677e-07 0 4.227888732110768e-07 0.00021 4.227988732110768e-07 0 4.227988732110768e-07 0 4.228088732110768e-07 0.00021 4.228188732110768e-07 0 4.228188732110768e-07 0 4.228288732110768e-07 0.00021 4.2283887321107683e-07 0 4.2283887321107683e-07 0 4.2284887321107684e-07 0.00021 4.2285887321107686e-07 0 4.22860485042261e-07 0 4.22870485042261e-07 0.00021 4.22880485042261e-07 0 4.22880485042261e-07 0 4.22890485042261e-07 0.00021 4.2290048504226104e-07 0 4.2290048504226104e-07 0 4.2291048504226105e-07 0.00021 4.2292048504226106e-07 0 4.2292048504226106e-07 0 4.2293048504226107e-07 0.00021 4.229404850422611e-07 0 4.229404850422611e-07 0 4.229504850422611e-07 0.00021 4.229604850422611e-07 0 4.2301561377826224e-07 0 4.2302561377826225e-07 0.00021 4.2303561377826227e-07 0 4.2303561377826227e-07 0 4.230456137782623e-07 0.00021 4.230556137782623e-07 0 4.230556137782623e-07 0 4.230656137782623e-07 0.00021 4.230756137782623e-07 0 4.2313258477690493e-07 0 4.2314258477690494e-07 0.00021 4.2315258477690495e-07 0 4.2319091063137517e-07 0 4.232009106313752e-07 0.00021 4.232109106313752e-07 0 4.232109106313752e-07 0 4.232209106313752e-07 0.00021 4.232309106313752e-07 0 4.232309106313752e-07 0 4.232409106313752e-07 0.00021 4.2325091063137524e-07 0 4.2325091063137524e-07 0 4.2326091063137525e-07 0.00021 4.2327091063137526e-07 0 4.2327091063137526e-07 0 4.2328091063137527e-07 0.00021 4.232909106313753e-07 0 4.232909106313753e-07 0 4.233009106313753e-07 0.00021 4.233109106313753e-07 0 4.2333321623052726e-07 0 4.2334321623052727e-07 0.00021 4.233532162305273e-07 0 4.233554987441246e-07 0 4.233654987441246e-07 0.00021 4.2337549874412464e-07 0 4.23376375334236e-07 0 4.23386375334236e-07 0.00021 4.23396375334236e-07 0 4.2342204098652424e-07 0 4.2343204098652425e-07 0.00021 4.2344204098652427e-07 0 4.2344204098652427e-07 0 4.234520409865243e-07 0.00021 4.234620409865243e-07 0 4.234739135261912e-07 0 4.234839135261912e-07 0.00021 4.234939135261912e-07 0 4.234939135261912e-07 0 4.235039135261912e-07 0.00021 4.2351391352619123e-07 0 4.2351391352619123e-07 0 4.2352391352619124e-07 0.00021 4.2353391352619125e-07 0 4.2357669478522655e-07 0 4.2358669478522656e-07 0.00021 4.235966947852266e-07 0 4.235966947852266e-07 0 4.236066947852266e-07 0.00021 4.236166947852266e-07 0 4.236166947852266e-07 0 4.236266947852266e-07 0.00021 4.236366947852266e-07 0 4.236786149189732e-07 0 4.236886149189732e-07 0.00021 4.236986149189732e-07 0 4.236986149189732e-07 0 4.2370861491897323e-07 0.00021 4.2371861491897324e-07 0 4.2376141162840523e-07 0 4.2377141162840525e-07 0.00021 4.2378141162840526e-07 0 4.2378141162840526e-07 0 4.2379141162840527e-07 0.00021 4.238014116284053e-07 0 4.238523541773369e-07 0 4.2386235417733694e-07 0.00021 4.2387235417733695e-07 0 4.2387235417733695e-07 0 4.2388235417733696e-07 0.00021 4.2389235417733697e-07 0 4.2389235417733697e-07 0 4.23902354177337e-07 0.00021 4.23912354177337e-07 0 4.239887732697237e-07 0 4.239987732697237e-07 0.00021 4.240087732697237e-07 0 4.2401881597914266e-07 0 4.2402881597914267e-07 0.00021 4.240388159791427e-07 0 4.240388159791427e-07 0 4.240488159791427e-07 0.00021 4.240588159791427e-07 0 4.240588159791427e-07 0 4.240688159791427e-07 0.00021 4.2407881597914273e-07 0 4.2407881597914273e-07 0 4.2408881597914274e-07 0.00021 4.2409881597914275e-07 0 4.2409881597914275e-07 0 4.2410881597914276e-07 0.00021 4.241188159791428e-07 0 4.241188159791428e-07 0 4.241288159791428e-07 0.00021 4.241388159791428e-07 0 4.241388159791428e-07 0 4.241488159791428e-07 0.00021 4.241588159791428e-07 0 4.241588159791428e-07 0 4.2416881597914283e-07 0.00021 4.2417881597914284e-07 0 4.2417881597914284e-07 0 4.2418881597914285e-07 0.00021 4.2419881597914287e-07 0 4.2419881597914287e-07 0 4.242088159791429e-07 0.00021 4.242188159791429e-07 0 4.242188159791429e-07 0 4.242288159791429e-07 0.00021 4.242388159791429e-07 0 4.2427308282861775e-07 0 4.2428308282861776e-07 0.00021 4.2429308282861777e-07 0 4.243035299253096e-07 0 4.243135299253096e-07 0.00021 4.243235299253096e-07 0 4.243539490974964e-07 0 4.243639490974964e-07 0.00021 4.243739490974964e-07 0 4.2438795427108325e-07 0 4.2439795427108326e-07 0.00021 4.244079542710833e-07 0 4.244079542710833e-07 0 4.244179542710833e-07 0.00021 4.244279542710833e-07 0 4.2447027989985106e-07 0 4.2448027989985107e-07 0.00021 4.244902798998511e-07 0 4.245492453977668e-07 0 4.2455924539776683e-07 0.00021 4.2456924539776684e-07 0 4.2456982022307304e-07 0 4.2457982022307305e-07 0.00021 4.2458982022307306e-07 0 4.2458982022307306e-07 0 4.245998202230731e-07 0.00021 4.246098202230731e-07 0 4.246321331609309e-07 0 4.246421331609309e-07 0.00021 4.246521331609309e-07 0 4.2465581389855727e-07 0 4.246658138985573e-07 0.00021 4.246758138985573e-07 0 4.246758138985573e-07 0 4.246858138985573e-07 0.00021 4.246958138985573e-07 0 4.247269243593124e-07 0 4.247369243593124e-07 0.00021 4.2474692435931244e-07 0 4.2481450425706427e-07 0 4.248245042570643e-07 0.00021 4.248345042570643e-07 0 4.248345042570643e-07 0 4.248445042570643e-07 0.00021 4.248545042570643e-07 0 4.248545042570643e-07 0 4.248645042570643e-07 0.00021 4.2487450425706433e-07 0 4.2487450425706433e-07 0 4.2488450425706434e-07 0.00021 4.2489450425706436e-07 0 4.2489450425706436e-07 0 4.2490450425706437e-07 0.00021 4.249145042570644e-07 0 4.249145042570644e-07 0 4.249245042570644e-07 0.00021 4.249345042570644e-07 0 4.249345042570644e-07 0 4.249445042570644e-07 0.00021 4.249545042570644e-07 0 4.249545042570644e-07 0 4.2496450425706444e-07 0.00021 4.2497450425706445e-07 0 4.2497450425706445e-07 0 4.2498450425706446e-07 0.00021 4.2499450425706447e-07 0 4.2500150856938976e-07 0 4.2501150856938977e-07 0.00021 4.250215085693898e-07 0 4.2502822490440345e-07 0 4.2503822490440346e-07 0.00021 4.2504822490440347e-07 0 4.250647568127055e-07 0 4.2507475681270554e-07 0.00021 4.2508475681270555e-07 0 4.2508990424931486e-07 0 4.2509990424931487e-07 0.00021 4.251099042493149e-07 0 4.251099042493149e-07 0 4.251199042493149e-07 0.00021 4.251299042493149e-07 0 4.251360405026642e-07 0 4.251460405026642e-07 0.00021 4.251560405026642e-07 0 4.251561979137498e-07 0 4.251661979137498e-07 0.00021 4.2517619791374984e-07 0 4.2517619791374984e-07 0 4.2518619791374985e-07 0.00021 4.2519619791374986e-07 0 4.2519619791374986e-07 0 4.2520619791374987e-07 0.00021 4.252161979137499e-07 0 4.252161979137499e-07 0 4.252261979137499e-07 0.00021 4.252361979137499e-07 0 4.252361979137499e-07 0 4.252461979137499e-07 0.00021 4.2525619791374993e-07 0 4.2525619791374993e-07 0 4.2526619791374994e-07 0.00021 4.2527619791374995e-07 0 4.252831272760791e-07 0 4.252931272760791e-07 0.00021 4.253031272760791e-07 0 4.2532220793618635e-07 0 4.2533220793618636e-07 0.00021 4.253422079361864e-07 0 4.2536561858943434e-07 0 4.2537561858943435e-07 0.00021 4.2538561858943436e-07 0 4.2538561858943436e-07 0 4.2539561858943437e-07 0.00021 4.254056185894344e-07 0 4.254056185894344e-07 0 4.254156185894344e-07 0.00021 4.254256185894344e-07 0 4.254256185894344e-07 0 4.254356185894344e-07 0.00021 4.254456185894344e-07 0 4.254456185894344e-07 0 4.2545561858943444e-07 0.00021 4.2546561858943445e-07 0 4.2546561858943445e-07 0 4.2547561858943446e-07 0.00021 4.2548561858943447e-07 0 4.255444969069529e-07 0 4.255544969069529e-07 0.00021 4.255644969069529e-07 0 4.257668444360784e-07 0 4.2577684443607843e-07 0.00021 4.2578684443607844e-07 0 4.2578684443607844e-07 0 4.2579684443607845e-07 0.00021 4.2580684443607846e-07 0 4.2580684443607846e-07 0 4.2581684443607847e-07 0.00021 4.258268444360785e-07 0 4.258268444360785e-07 0 4.258368444360785e-07 0.00021 4.258468444360785e-07 0 4.258468444360785e-07 0 4.258568444360785e-07 0.00021 4.2586684443607853e-07 0 4.259052214286908e-07 0 4.259152214286908e-07 0.00021 4.259252214286908e-07 0 4.2600670966382307e-07 0 4.260167096638231e-07 0.00021 4.260267096638231e-07 0 4.260267096638231e-07 0 4.260367096638231e-07 0.00021 4.260467096638231e-07 0 4.2605472558743823e-07 0 4.2606472558743824e-07 0.00021 4.2607472558743825e-07 0 4.2607706946453825e-07 0 4.2608706946453826e-07 0.00021 4.2609706946453827e-07 0 4.2609706946453827e-07 0 4.261070694645383e-07 0.00021 4.261170694645383e-07 0 4.261170694645383e-07 0 4.261270694645383e-07 0.00021 4.261370694645383e-07 0 4.261370694645383e-07 0 4.2614706946453833e-07 0.00021 4.2615706946453834e-07 0 4.2615706946453834e-07 0 4.2616706946453835e-07 0.00021 4.2617706946453836e-07 0 4.2617706946453836e-07 0 4.261870694645384e-07 0.00021 4.261970694645384e-07 0 4.261970694645384e-07 0 4.262070694645384e-07 0.00021 4.262170694645384e-07 0 4.262170694645384e-07 0 4.262270694645384e-07 0.00021 4.2623706946453843e-07 0 4.2630930475382526e-07 0 4.2631930475382527e-07 0.00021 4.263293047538253e-07 0 4.263293047538253e-07 0 4.263393047538253e-07 0.00021 4.263493047538253e-07 0 4.2637833481187544e-07 0 4.2638833481187546e-07 0.00021 4.2639833481187547e-07 0 4.2640746756152047e-07 0 4.264174675615205e-07 0.00021 4.264274675615205e-07 0 4.2649895400694803e-07 0 4.2650895400694804e-07 0.00021 4.2651895400694805e-07 0 4.2658896288876817e-07 0 4.265989628887682e-07 0.00021 4.266089628887682e-07 0 4.266089628887682e-07 0 4.266189628887682e-07 0.00021 4.266289628887682e-07 0 4.266289628887682e-07 0 4.2663896288876823e-07 0.00021 4.2664896288876824e-07 0 4.2664896288876824e-07 0 4.2665896288876825e-07 0.00021 4.2666896288876826e-07 0 4.2666896288876826e-07 0 4.2667896288876827e-07 0.00021 4.266889628887683e-07 0 4.2669156259491605e-07 0 4.2670156259491606e-07 0.00021 4.2671156259491607e-07 0 4.2671156259491607e-07 0 4.267215625949161e-07 0.00021 4.267315625949161e-07 0 4.267325868269083e-07 0 4.267425868269083e-07 0.00021 4.2675258682690833e-07 0 4.2675258682690833e-07 0 4.2676258682690835e-07 0.00021 4.2677258682690836e-07 0 4.2677258682690836e-07 0 4.2678258682690837e-07 0.00021 4.267925868269084e-07 0 4.267925868269084e-07 0 4.268025868269084e-07 0.00021 4.268125868269084e-07 0 4.268125868269084e-07 0 4.268225868269084e-07 0.00021 4.268325868269084e-07 0 4.268325868269084e-07 0 4.2684258682690844e-07 0.00021 4.2685258682690845e-07 0 4.2685258682690845e-07 0 4.2686258682690846e-07 0.00021 4.2687258682690847e-07 0 4.2687258682690847e-07 0 4.268825868269085e-07 0.00021 4.268925868269085e-07 0 4.268925868269085e-07 0 4.269025868269085e-07 0.00021 4.269125868269085e-07 0 4.269125868269085e-07 0 4.2692258682690853e-07 0.00021 4.2693258682690854e-07 0 4.2693258682690854e-07 0 4.2694258682690855e-07 0.00021 4.2695258682690856e-07 0 4.2695258682690856e-07 0 4.2696258682690857e-07 0.00021 4.269725868269086e-07 0 4.269725868269086e-07 0 4.269825868269086e-07 0.00021 4.269925868269086e-07 0 4.269925868269086e-07 0 4.270025868269086e-07 0.00021 4.2701258682690863e-07 0 4.2701258682690863e-07 0 4.2702258682690864e-07 0.00021 4.2703258682690865e-07 0 4.2703258682690865e-07 0 4.2704258682690866e-07 0.00021 4.270525868269087e-07 0 4.270525868269087e-07 0 4.270625868269087e-07 0.00021 4.270725868269087e-07 0 4.270725868269087e-07 0 4.270825868269087e-07 0.00021 4.270925868269087e-07 0 4.270925868269087e-07 0 4.2710258682690873e-07 0.00021 4.2711258682690874e-07 0 4.2711258682690874e-07 0 4.2712258682690875e-07 0.00021 4.2713258682690877e-07 0 4.271575056654887e-07 0 4.2716750566548873e-07 0.00021 4.2717750566548874e-07 0 4.272014201551907e-07 0 4.272114201551907e-07 0.00021 4.2722142015519073e-07 0 4.273336005177817e-07 0 4.273436005177817e-07 0.00021 4.273536005177817e-07 0 4.2738038910453444e-07 0 4.2739038910453445e-07 0.00021 4.2740038910453446e-07 0 4.274335616005233e-07 0 4.274435616005233e-07 0.00021 4.274535616005233e-07 0 4.274535616005233e-07 0 4.274635616005233e-07 0.00021 4.2747356160052333e-07 0 4.274744445772773e-07 0 4.274844445772773e-07 0.00021 4.274944445772773e-07 0 4.2755522203557044e-07 0 4.2756522203557045e-07 0.00021 4.2757522203557046e-07 0 4.2757522203557046e-07 0 4.2758522203557047e-07 0.00021 4.275952220355705e-07 0 4.275952220355705e-07 0 4.276052220355705e-07 0.00021 4.276152220355705e-07 0 4.276152220355705e-07 0 4.276252220355705e-07 0.00021 4.2763522203557053e-07 0 4.2763522203557053e-07 0 4.2764522203557054e-07 0.00021 4.2765522203557055e-07 0 4.2767627134442525e-07 0 4.2768627134442526e-07 0.00021 4.2769627134442527e-07 0 4.2769627134442527e-07 0 4.277062713444253e-07 0.00021 4.277162713444253e-07 0 4.277502679076162e-07 0 4.277602679076162e-07 0.00021 4.277702679076162e-07 0 4.277734192826285e-07 0 4.2778341928262853e-07 0.00021 4.2779341928262854e-07 0 4.2788621287024273e-07 0 4.2789621287024275e-07 0.00021 4.2790621287024276e-07 0 4.2790621287024276e-07 0 4.2791621287024277e-07 0.00021 4.279262128702428e-07 0 4.2792624553629693e-07 0 4.2793624553629694e-07 0.00021 4.2794624553629695e-07 0 4.2794624553629695e-07 0 4.2795624553629696e-07 0.00021 4.27966245536297e-07 0 4.279799576860042e-07 0 4.279899576860042e-07 0.00021 4.279999576860042e-07 0 4.279999576860042e-07 0 4.2800995768600424e-07 0.00021 4.2801995768600425e-07 0 4.280407976776036e-07 0 4.280507976776036e-07 0.00021 4.280607976776036e-07 0 4.281202128369062e-07 0 4.2813021283690623e-07 0.00021 4.2814021283690624e-07 0 4.281507608831943e-07 0 4.281607608831943e-07 0.00021 4.281707608831943e-07 0 4.281707608831943e-07 0 4.2818076088319434e-07 0.00021 4.2819076088319435e-07 0 4.2824963366199143e-07 0 4.2825963366199144e-07 0.00021 4.2826963366199145e-07 0 4.2826963366199145e-07 0 4.2827963366199147e-07 0.00021 4.282896336619915e-07 0 4.283208624288282e-07 0 4.283308624288282e-07 0.00021 4.283408624288282e-07 0 4.283408624288282e-07 0 4.283508624288282e-07 0.00021 4.283608624288282e-07 0 4.283608624288282e-07 0 4.2837086242882824e-07 0.00021 4.2838086242882825e-07 0 4.284324006911307e-07 0 4.284424006911307e-07 0.00021 4.2845240069113074e-07 0 4.2845240069113074e-07 0 4.2846240069113075e-07 0.00021 4.2847240069113076e-07 0 4.284829761762225e-07 0 4.284929761762225e-07 0.00021 4.285029761762225e-07 0 4.2851250004218725e-07 0 4.2852250004218726e-07 0.00021 4.2853250004218727e-07 0 4.2853455008525283e-07 0 4.2854455008525285e-07 0.00021 4.2855455008525286e-07 0 4.28610689680992e-07 0 4.2862068968099204e-07 0.00021 4.2863068968099205e-07 0 4.286437663313034e-07 0 4.286537663313034e-07 0.00021 4.286637663313034e-07 0 4.286637663313034e-07 0 4.2867376633130343e-07 0.00021 4.2868376633130344e-07 0 4.2868376633130344e-07 0 4.2869376633130345e-07 0.00021 4.2870376633130346e-07 0 4.2871152725571915e-07 0 4.2872152725571916e-07 0.00021 4.287315272557192e-07 0 4.287315272557192e-07 0 4.287415272557192e-07 0.00021 4.287515272557192e-07 0 4.287515272557192e-07 0 4.287615272557192e-07 0.00021 4.287715272557192e-07 0 4.287715272557192e-07 0 4.2878152725571923e-07 0.00021 4.2879152725571924e-07 0 4.2879152725571924e-07 0 4.2880152725571926e-07 0.00021 4.2881152725571927e-07 0 4.2881152725571927e-07 0 4.288215272557193e-07 0.00021 4.288315272557193e-07 0 4.288315272557193e-07 0 4.288415272557193e-07 0.00021 4.288515272557193e-07 0 4.288515272557193e-07 0 4.288615272557193e-07 0.00021 4.2887152725571933e-07 0 4.2890899376816226e-07 0 4.289189937681623e-07 0.00021 4.289289937681623e-07 0 4.289384722308613e-07 0 4.289484722308613e-07 0.00021 4.2895847223086133e-07 0 4.2895847223086133e-07 0 4.2896847223086134e-07 0.00021 4.2897847223086135e-07 0 4.2897847223086135e-07 0 4.2898847223086137e-07 0.00021 4.289984722308614e-07 0 4.289984722308614e-07 0 4.290084722308614e-07 0.00021 4.290184722308614e-07 0 4.290684567729734e-07 0 4.290784567729734e-07 0.00021 4.290884567729734e-07 0 4.290988358862374e-07 0 4.291088358862374e-07 0.00021 4.291188358862374e-07 0 4.291188358862374e-07 0 4.2912883588623743e-07 0.00021 4.2913883588623744e-07 0 4.291446368375757e-07 0 4.291546368375757e-07 0.00021 4.291646368375757e-07 0 4.291946796290193e-07 0 4.292046796290193e-07 0.00021 4.292146796290193e-07 0 4.292146796290193e-07 0 4.292246796290193e-07 0.00021 4.2923467962901934e-07 0 4.2923467962901934e-07 0 4.2924467962901935e-07 0.00021 4.2925467962901936e-07 0 4.2925467962901936e-07 0 4.2926467962901937e-07 0.00021 4.292746796290194e-07 0 4.293845461544542e-07 0 4.293945461544542e-07 0.00021 4.2940454615445423e-07 0 4.2941825322505163e-07 0 4.2942825322505164e-07 0.00021 4.2943825322505165e-07 0 4.2943825322505165e-07 0 4.2944825322505166e-07 0.00021 4.294582532250517e-07 0 4.294582532250517e-07 0 4.294682532250517e-07 0.00021 4.294782532250517e-07 0 4.294782532250517e-07 0 4.294882532250517e-07 0.00021 4.294982532250517e-07 0 4.294982532250517e-07 0 4.2950825322505173e-07 0.00021 4.2951825322505174e-07 0 4.2951825322505174e-07 0 4.2952825322505175e-07 0.00021 4.2953825322505177e-07 0 4.295983542212677e-07 0 4.296083542212677e-07 0.00021 4.2961835422126773e-07 0 4.2965409156006994e-07 0 4.2966409156006995e-07 0.00021 4.2967409156006996e-07 0 4.2967409156006996e-07 0 4.2968409156007e-07 0.00021 4.2969409156007e-07 0 4.2969409156007e-07 0 4.2970409156007e-07 0.00021 4.2971409156007e-07 0 4.2971409156007e-07 0 4.2972409156007e-07 0.00021 4.2973409156007003e-07 0 4.298241328883967e-07 0 4.2983413288839673e-07 0.00021 4.2984413288839674e-07 0 4.2990238236115713e-07 0 4.2991238236115714e-07 0.00021 4.2992238236115715e-07 0 4.2997184360176693e-07 0 4.2998184360176694e-07 0.00021 4.2999184360176695e-07 0 4.300178950602493e-07 0 4.3002789506024933e-07 0.00021 4.3003789506024934e-07 0 4.3003789506024934e-07 0 4.3004789506024935e-07 0.00021 4.3005789506024936e-07 0 4.3006220232088453e-07 0 4.3007220232088454e-07 0.00021 4.3008220232088455e-07 0 4.300906071050056e-07 0 4.301006071050056e-07 0.00021 4.301106071050056e-07 0 4.301106071050056e-07 0 4.3012060710500564e-07 0.00021 4.3013060710500565e-07 0 4.3013654294200055e-07 0 4.3014654294200056e-07 0.00021 4.3015654294200057e-07 0 4.3015654294200057e-07 0 4.301665429420006e-07 0.00021 4.301765429420006e-07 0 4.301765429420006e-07 0 4.301865429420006e-07 0.00021 4.301965429420006e-07 0 4.302095963861211e-07 0 4.302195963861211e-07 0.00021 4.302295963861211e-07 0 4.302416789183654e-07 0 4.3025167891836543e-07 0.00021 4.3026167891836544e-07 0 4.303417327420634e-07 0 4.303517327420634e-07 0.00021 4.303617327420634e-07 0 4.303760944311193e-07 0 4.3038609443111933e-07 0.00021 4.3039609443111934e-07 0 4.3039609443111934e-07 0 4.3040609443111936e-07 0.00021 4.3041609443111937e-07 0 4.3041609443111937e-07 0 4.304260944311194e-07 0.00021 4.304360944311194e-07 0 4.304360944311194e-07 0 4.304460944311194e-07 0.00021 4.304560944311194e-07 0 4.304560944311194e-07 0 4.304660944311194e-07 0.00021 4.3047609443111943e-07 0 4.3047609443111943e-07 0 4.3048609443111945e-07 0.00021 4.3049609443111946e-07 0 4.3049609443111946e-07 0 4.3050609443111947e-07 0.00021 4.305160944311195e-07 0 4.305254019205412e-07 0 4.305354019205412e-07 0.00021 4.305454019205412e-07 0 4.306297863109319e-07 0 4.306397863109319e-07 0.00021 4.306497863109319e-07 0 4.306497863109319e-07 0 4.306597863109319e-07 0.00021 4.306697863109319e-07 0 4.306697863109319e-07 0 4.3067978631093193e-07 0.00021 4.3068978631093194e-07 0 4.3075003597694724e-07 0 4.3076003597694726e-07 0.00021 4.3077003597694727e-07 0 4.3077003597694727e-07 0 4.307800359769473e-07 0.00021 4.307900359769473e-07 0 4.307900359769473e-07 0 4.308000359769473e-07 0.00021 4.308100359769473e-07 0 4.308100359769473e-07 0 4.308200359769473e-07 0.00021 4.3083003597694734e-07 0 4.3084404899426525e-07 0 4.3085404899426526e-07 0.00021 4.308640489942653e-07 0 4.3087698070298177e-07 0 4.308869807029818e-07 0.00021 4.308969807029818e-07 0 4.309216665371899e-07 0 4.309316665371899e-07 0.00021 4.309416665371899e-07 0 4.309416665371899e-07 0 4.309516665371899e-07 0.00021 4.3096166653718993e-07 0 4.3096166653718993e-07 0 4.3097166653718995e-07 0.00021 4.3098166653718996e-07 0 4.309846661075587e-07 0 4.309946661075587e-07 0.00021 4.310046661075587e-07 0 4.3116563639697715e-07 0 4.3117563639697716e-07 0.00021 4.3118563639697717e-07 0 4.3130834769986314e-07 0 4.3131834769986316e-07 0.00021 4.3132834769986317e-07 0 4.313827067398533e-07 0 4.313927067398533e-07 0.00021 4.314027067398533e-07 0 4.314027067398533e-07 0 4.314127067398533e-07 0.00021 4.314227067398533e-07 0 4.314692696743324e-07 0 4.314792696743324e-07 0.00021 4.314892696743324e-07 0 4.3150468811817023e-07 0 4.3151468811817024e-07 0.00021 4.3152468811817026e-07 0 4.315255916538192e-07 0 4.3153559165381923e-07 0.00021 4.3154559165381924e-07 0 4.3154559165381924e-07 0 4.3155559165381925e-07 0.00021 4.3156559165381927e-07 0 4.3156559165381927e-07 0 4.315755916538193e-07 0.00021 4.315855916538193e-07 0 4.315855916538193e-07 0 4.315955916538193e-07 0.00021 4.316055916538193e-07 0 4.316482716899653e-07 0 4.316582716899653e-07 0.00021 4.3166827168996533e-07 0 4.31698011099254e-07 0 4.3170801109925403e-07 0.00021 4.3171801109925404e-07 0 4.3171801109925404e-07 0 4.3172801109925405e-07 0.00021 4.3173801109925406e-07 0 4.3173801109925406e-07 0 4.3174801109925407e-07 0.00021 4.317580110992541e-07 0 4.317580110992541e-07 0 4.317680110992541e-07 0.00021 4.317780110992541e-07 0 4.317780110992541e-07 0 4.317880110992541e-07 0.00021 4.3179801109925413e-07 0 4.3179801109925413e-07 0 4.3180801109925414e-07 0.00021 4.3181801109925415e-07 0 4.3181801109925415e-07 0 4.3182801109925416e-07 0.00021 4.318380110992542e-07 0 4.31848084084728e-07 0 4.31858084084728e-07 0.00021 4.31868084084728e-07 0 4.318880118035609e-07 0 4.318980118035609e-07 0.00021 4.3190801180356093e-07 0 4.3197395998849786e-07 0 4.319839599884979e-07 0.00021 4.319939599884979e-07 0 4.320030918603722e-07 0 4.320130918603722e-07 0.00021 4.320230918603722e-07 0 4.320230918603722e-07 0 4.320330918603722e-07 0.00021 4.320430918603722e-07 0 4.3206119807667223e-07 0 4.3207119807667224e-07 0.00021 4.3208119807667225e-07 0 4.3208119807667225e-07 0 4.3209119807667226e-07 0.00021 4.321011980766723e-07 0 4.3216812199937606e-07 0 4.3217812199937607e-07 0.00021 4.321881219993761e-07 0 4.322004460549046e-07 0 4.3221044605490463e-07 0.00021 4.3222044605490464e-07 0 4.3222044605490464e-07 0 4.3223044605490465e-07 0.00021 4.3224044605490466e-07 0 4.3224044605490466e-07 0 4.322504460549047e-07 0.00021 4.322604460549047e-07 0 4.322604460549047e-07 0 4.322704460549047e-07 0.00021 4.322804460549047e-07 0 4.322804460549047e-07 0 4.322904460549047e-07 0.00021 4.3230044605490473e-07 0 4.3230044605490473e-07 0 4.3231044605490474e-07 0.00021 4.3232044605490475e-07 0 4.3232044605490475e-07 0 4.3233044605490477e-07 0.00021 4.323404460549048e-07 0 4.3234201277728594e-07 0 4.3235201277728595e-07 0.00021 4.3236201277728596e-07 0 4.3236201277728596e-07 0 4.3237201277728597e-07 0.00021 4.32382012777286e-07 0 4.323852247587751e-07 0 4.323952247587751e-07 0.00021 4.324052247587751e-07 0 4.324052247587751e-07 0 4.324152247587751e-07 0.00021 4.3242522475877513e-07 0 4.3242522475877513e-07 0 4.3243522475877514e-07 0.00021 4.3244522475877516e-07 0 4.3244522475877516e-07 0 4.3245522475877517e-07 0.00021 4.324652247587752e-07 0 4.324652247587752e-07 0 4.324752247587752e-07 0.00021 4.324852247587752e-07 0 4.325069493466176e-07 0 4.325169493466176e-07 0.00021 4.325269493466176e-07 0 4.325269493466176e-07 0 4.325369493466176e-07 0.00021 4.325469493466176e-07 0 4.325469493466176e-07 0 4.3255694934661763e-07 0.00021 4.3256694934661765e-07 0 4.3256694934661765e-07 0 4.3257694934661766e-07 0.00021 4.3258694934661767e-07 0 4.326153245855068e-07 0 4.326253245855068e-07 0.00021 4.3263532458550683e-07 0 4.326425308791589e-07 0 4.326525308791589e-07 0.00021 4.326625308791589e-07 0 4.326625308791589e-07 0 4.3267253087915894e-07 0.00021 4.3268253087915895e-07 0 4.3268253087915895e-07 0 4.3269253087915896e-07 0.00021 4.3270253087915897e-07 0 4.327621771382946e-07 0 4.3277217713829463e-07 0.00021 4.3278217713829464e-07 0 4.328190263981134e-07 0 4.3282902639811343e-07 0.00021 4.3283902639811344e-07 0 4.328448846897509e-07 0 4.328548846897509e-07 0.00021 4.328648846897509e-07 0 4.328678458116461e-07 0 4.328778458116461e-07 0.00021 4.328878458116461e-07 0 4.328878458116461e-07 0 4.328978458116461e-07 0.00021 4.3290784581164613e-07 0 4.3290960493694875e-07 0 4.3291960493694876e-07 0.00021 4.3292960493694877e-07 0 4.3292960493694877e-07 0 4.329396049369488e-07 0.00021 4.329496049369488e-07 0 4.3297982543102574e-07 0 4.3298982543102575e-07 0.00021 4.3299982543102576e-07 0 4.3299982543102576e-07 0 4.330098254310258e-07 0.00021 4.330198254310258e-07 0 4.330198254310258e-07 0 4.330298254310258e-07 0.00021 4.330398254310258e-07 0 4.330398254310258e-07 0 4.330498254310258e-07 0.00021 4.3305982543102583e-07 0 4.3307555207218094e-07 0 4.3308555207218095e-07 0.00021 4.3309555207218096e-07 0 4.3309555207218096e-07 0 4.33105552072181e-07 0.00021 4.33115552072181e-07 0 4.331229042787235e-07 0 4.331329042787235e-07 0.00021 4.331429042787235e-07 0 4.331429042787235e-07 0 4.3315290427872353e-07 0.00021 4.3316290427872354e-07 0 4.3317450028114487e-07 0 4.331845002811449e-07 0.00021 4.331945002811449e-07 0 4.331945002811449e-07 0 4.332045002811449e-07 0.00021 4.332145002811449e-07 0 4.332760263921166e-07 0 4.332860263921166e-07 0.00021 4.332960263921166e-07 0 4.332960263921166e-07 0 4.3330602639211664e-07 0.00021 4.3331602639211665e-07 0 4.333170869856104e-07 0 4.333270869856104e-07 0.00021 4.333370869856104e-07 0 4.3333859223523944e-07 0 4.3334859223523945e-07 0.00021 4.3335859223523946e-07 0 4.3335859223523946e-07 0 4.3336859223523947e-07 0.00021 4.333785922352395e-07 0 4.334192121207745e-07 0 4.334292121207745e-07 0.00021 4.334392121207745e-07 0 4.334392121207745e-07 0 4.334492121207745e-07 0.00021 4.3345921212077453e-07 0 4.3345921212077453e-07 0 4.3346921212077454e-07 0.00021 4.3347921212077455e-07 0 4.336486283507896e-07 0 4.336586283507896e-07 0.00021 4.3366862835078963e-07 0 4.3368419284190344e-07 0 4.3369419284190345e-07 0.00021 4.3370419284190346e-07 0 4.3370419284190346e-07 0 4.3371419284190347e-07 0.00021 4.337241928419035e-07 0 4.3380601209869414e-07 0 4.3381601209869415e-07 0.00021 4.3382601209869416e-07 0 4.3382601209869416e-07 0 4.3383601209869417e-07 0.00021 4.338460120986942e-07 0 4.3385593348274765e-07 0 4.3386593348274766e-07 0.00021 4.3387593348274767e-07 0 4.3387593348274767e-07 0 4.338859334827477e-07 0.00021 4.338959334827477e-07 0 4.339257161340988e-07 0 4.339357161340988e-07 0.00021 4.3394571613409883e-07 0 4.3394571613409883e-07 0 4.3395571613409884e-07 0.00021 4.3396571613409885e-07 0 4.3396571613409885e-07 0 4.3397571613409886e-07 0.00021 4.339857161340989e-07 0 4.339857161340989e-07 0 4.339957161340989e-07 0.00021 4.340057161340989e-07 0 4.340057161340989e-07 0 4.340157161340989e-07 0.00021 4.340257161340989e-07 0 4.340257161340989e-07 0 4.3403571613409893e-07 0.00021 4.3404571613409894e-07 0 4.3404571613409894e-07 0 4.3405571613409896e-07 0.00021 4.3406571613409897e-07 0 4.3406571613409897e-07 0 4.34075716134099e-07 0.00021 4.34085716134099e-07 0 4.34085716134099e-07 0 4.34095716134099e-07 0.00021 4.34105716134099e-07 0 4.34105716134099e-07 0 4.34115716134099e-07 0.00021 4.3412571613409903e-07 0 4.3412571613409903e-07 0 4.3413571613409905e-07 0.00021 4.3414571613409906e-07 0 4.3414571613409906e-07 0 4.3415571613409907e-07 0.00021 4.341657161340991e-07 0 4.341657161340991e-07 0 4.341757161340991e-07 0.00021 4.341857161340991e-07 0 4.341857161340991e-07 0 4.341957161340991e-07 0.00021 4.342057161340991e-07 0 4.342057161340991e-07 0 4.3421571613409914e-07 0.00021 4.3422571613409915e-07 0 4.3422571613409915e-07 0 4.3423571613409916e-07 0.00021 4.3424571613409917e-07 0 4.3424571613409917e-07 0 4.342557161340992e-07 0.00021 4.342657161340992e-07 0 4.342657161340992e-07 0 4.342757161340992e-07 0.00021 4.342857161340992e-07 0 4.342857161340992e-07 0 4.3429571613409923e-07 0.00021 4.3430571613409924e-07 0 4.3430571613409924e-07 0 4.3431571613409925e-07 0.00021 4.3432571613409926e-07 0 4.3432571613409926e-07 0 4.3433571613409927e-07 0.00021 4.343457161340993e-07 0 4.343457161340993e-07 0 4.343557161340993e-07 0.00021 4.343657161340993e-07 0 4.343657161340993e-07 0 4.343757161340993e-07 0.00021 4.3438571613409933e-07 0 4.3438571613409933e-07 0 4.3439571613409934e-07 0.00021 4.3440571613409935e-07 0 4.3440571613409935e-07 0 4.3441571613409936e-07 0.00021 4.344257161340994e-07 0 4.344257161340994e-07 0 4.344357161340994e-07 0.00021 4.344457161340994e-07 0 4.344737722262045e-07 0 4.344837722262045e-07 0.00021 4.3449377222620454e-07 0 4.345012799651545e-07 0 4.345112799651545e-07 0.00021 4.3452127996515453e-07 0 4.3452127996515453e-07 0 4.3453127996515455e-07 0.00021 4.3454127996515456e-07 0 4.345471829700105e-07 0 4.3455718297001053e-07 0.00021 4.3456718297001054e-07 0 4.3456745297459095e-07 0 4.3457745297459096e-07 0.00021 4.3458745297459097e-07 0 4.3458745297459097e-07 0 4.34597452974591e-07 0.00021 4.34607452974591e-07 0 4.34607452974591e-07 0 4.34617452974591e-07 0.00021 4.34627452974591e-07 0 4.34627452974591e-07 0 4.3463745297459103e-07 0.00021 4.3464745297459104e-07 0 4.3464745297459104e-07 0 4.3465745297459105e-07 0.00021 4.3466745297459106e-07 0 4.346676147580934e-07 0 4.3467761475809343e-07 0.00021 4.3468761475809344e-07 0 4.3468761475809344e-07 0 4.3469761475809345e-07 0.00021 4.3470761475809346e-07 0 4.347107652299774e-07 0 4.347207652299774e-07 0.00021 4.3473076522997744e-07 0 4.3473076522997744e-07 0 4.3474076522997745e-07 0.00021 4.3475076522997746e-07 0 4.3483074338973355e-07 0 4.3484074338973356e-07 0.00021 4.3485074338973357e-07 0 4.3485074338973357e-07 0 4.348607433897336e-07 0.00021 4.348707433897336e-07 0 4.3504254707550074e-07 0 4.3505254707550075e-07 0.00021 4.3506254707550077e-07 0 4.3507448646986597e-07 0 4.35084486469866e-07 0.00021 4.35094486469866e-07 0 4.351722839953109e-07 0 4.351822839953109e-07 0.00021 4.351922839953109e-07 0 4.352095992448684e-07 0 4.352195992448684e-07 0.00021 4.352295992448684e-07 0 4.352308217437502e-07 0 4.3524082174375023e-07 0.00021 4.3525082174375025e-07 0 4.353407526204364e-07 0 4.353507526204364e-07 0.00021 4.353607526204364e-07 0 4.353607526204364e-07 0 4.3537075262043643e-07 0.00021 4.3538075262043644e-07 0 4.3538075262043644e-07 0 4.3539075262043645e-07 0.00021 4.3540075262043646e-07 0 4.3542680836023643e-07 0 4.3543680836023644e-07 0.00021 4.3544680836023646e-07 0 4.3544680836023646e-07 0 4.3545680836023647e-07 0.00021 4.354668083602365e-07 0 4.354668083602365e-07 0 4.354768083602365e-07 0.00021 4.354868083602365e-07 0 4.3555586387096506e-07 0 4.3556586387096507e-07 0.00021 4.355758638709651e-07 0 4.355758638709651e-07 0 4.355858638709651e-07 0.00021 4.355958638709651e-07 0 4.3562882513676286e-07 0 4.3563882513676287e-07 0.00021 4.356488251367629e-07 0 4.35687093624814e-07 0 4.35697093624814e-07 0.00021 4.3570709362481403e-07 0 4.3570709362481403e-07 0 4.3571709362481404e-07 0.00021 4.3572709362481405e-07 0 4.3576829391346976e-07 0 4.3577829391346977e-07 0.00021 4.357882939134698e-07 0 4.357916186763411e-07 0 4.358016186763411e-07 0.00021 4.358116186763411e-07 0 4.358291233787953e-07 0 4.358391233787953e-07 0.00021 4.3584912337879533e-07 0 4.358579200829666e-07 0 4.3586792008296664e-07 0.00021 4.3587792008296665e-07 0 4.359409053272743e-07 0 4.359509053272743e-07 0.00021 4.359609053272743e-07 0 4.359609053272743e-07 0 4.359709053272743e-07 0.00021 4.3598090532727433e-07 0 4.3598090532727433e-07 0 4.3599090532727434e-07 0.00021 4.3600090532727435e-07 0 4.3600090532727435e-07 0 4.3601090532727437e-07 0.00021 4.360209053272744e-07 0 4.360209053272744e-07 0 4.360309053272744e-07 0.00021 4.360409053272744e-07 0 4.360409053272744e-07 0 4.360509053272744e-07 0.00021 4.360609053272744e-07 0 4.3606887311008744e-07 0 4.3607887311008746e-07 0.00021 4.3608887311008747e-07 0 4.3608887311008747e-07 0 4.360988731100875e-07 0.00021 4.361088731100875e-07 0 4.361453783839037e-07 0 4.3615537838390373e-07 0.00021 4.3616537838390374e-07 0 4.361819469923026e-07 0 4.361919469923026e-07 0.00021 4.362019469923026e-07 0 4.362019469923026e-07 0 4.362119469923026e-07 0.00021 4.3622194699230263e-07 0 4.3622194699230263e-07 0 4.3623194699230265e-07 0.00021 4.3624194699230266e-07 0 4.3624194699230266e-07 0 4.3625194699230267e-07 0.00021 4.362619469923027e-07 0 4.362619469923027e-07 0 4.362719469923027e-07 0.00021 4.362819469923027e-07 0 4.362819469923027e-07 0 4.362919469923027e-07 0.00021 4.363019469923027e-07 0 4.363019469923027e-07 0 4.3631194699230274e-07 0.00021 4.3632194699230275e-07 0 4.3632194699230275e-07 0 4.3633194699230276e-07 0.00021 4.3634194699230277e-07 0 4.36390152924012e-07 0 4.3640015292401203e-07 0.00021 4.3641015292401204e-07 0 4.3641015292401204e-07 0 4.3642015292401205e-07 0.00021 4.3643015292401206e-07 0 4.364625231849166e-07 0 4.364725231849166e-07 0.00021 4.364825231849166e-07 0 4.3653110946691045e-07 0 4.3654110946691046e-07 0.00021 4.365511094669105e-07 0 4.3655707450955095e-07 0 4.3656707450955096e-07 0.00021 4.3657707450955097e-07 0 4.3657707450955097e-07 0 4.36587074509551e-07 0.00021 4.36597074509551e-07 0 4.3664446803792186e-07 0 4.3665446803792187e-07 0.00021 4.366644680379219e-07 0 4.366644680379219e-07 0 4.366744680379219e-07 0.00021 4.366844680379219e-07 0 4.366844680379219e-07 0 4.366944680379219e-07 0.00021 4.367044680379219e-07 0 4.367044680379219e-07 0 4.3671446803792194e-07 0.00021 4.3672446803792195e-07 0 4.3672446803792195e-07 0 4.3673446803792196e-07 0.00021 4.3674446803792197e-07 0 4.3674446803792197e-07 0 4.36754468037922e-07 0.00021 4.36764468037922e-07 0 4.36764468037922e-07 0 4.36774468037922e-07 0.00021 4.36784468037922e-07 0 4.36784468037922e-07 0 4.36794468037922e-07 0.00021 4.3680446803792204e-07 0 4.3680446803792204e-07 0 4.3681446803792205e-07 0.00021 4.3682446803792206e-07 0 4.369039337202323e-07 0 4.369139337202323e-07 0.00021 4.369239337202323e-07 0 4.369239337202323e-07 0 4.3693393372023234e-07 0.00021 4.3694393372023235e-07 0 4.3694393372023235e-07 0 4.3695393372023236e-07 0.00021 4.3696393372023237e-07 0 4.3700866215638207e-07 0 4.370186621563821e-07 0.00021 4.370286621563821e-07 0 4.3723122825413557e-07 0 4.372412282541356e-07 0.00021 4.372512282541356e-07 0 4.372512282541356e-07 0 4.372612282541356e-07 0.00021 4.372712282541356e-07 0 4.372712282541356e-07 0 4.3728122825413563e-07 0.00021 4.3729122825413564e-07 0 4.3729790166909847e-07 0 4.373079016690985e-07 0.00021 4.373179016690985e-07 0 4.3743723007868686e-07 0 4.3744723007868687e-07 0.00021 4.374572300786869e-07 0 4.374572300786869e-07 0 4.374672300786869e-07 0.00021 4.374772300786869e-07 0 4.375701101316133e-07 0 4.375801101316133e-07 0.00021 4.375901101316133e-07 0 4.37602283338821e-07 0 4.37612283338821e-07 0.00021 4.37622283338821e-07 0 4.37622283338821e-07 0 4.37632283338821e-07 0.00021 4.3764228333882103e-07 0 4.376470650985672e-07 0 4.376570650985672e-07 0.00021 4.3766706509856723e-07 0 4.3766706509856723e-07 0 4.3767706509856725e-07 0.00021 4.3768706509856726e-07 0 4.377428541733064e-07 0 4.377528541733064e-07 0.00021 4.3776285417330644e-07 0 4.3779256915618743e-07 0 4.3780256915618744e-07 0.00021 4.3781256915618745e-07 0 4.3783487563421057e-07 0 4.378448756342106e-07 0.00021 4.378548756342106e-07 0 4.378548756342106e-07 0 4.378648756342106e-07 0.00021 4.378748756342106e-07 0 4.378748756342106e-07 0 4.3788487563421063e-07 0.00021 4.3789487563421064e-07 0 4.3789487563421064e-07 0 4.3790487563421065e-07 0.00021 4.3791487563421066e-07 0 4.3791487563421066e-07 0 4.379248756342107e-07 0.00021 4.379348756342107e-07 0 4.379348756342107e-07 0 4.379448756342107e-07 0.00021 4.379548756342107e-07 0 4.37974018578321e-07 0 4.3798401857832103e-07 0.00021 4.3799401857832105e-07 0 4.38018304795906e-07 0 4.38028304795906e-07 0.00021 4.38038304795906e-07 0 4.380505712235211e-07 0 4.380605712235211e-07 0.00021 4.380705712235211e-07 0 4.3807797981940743e-07 0 4.3808797981940745e-07 0.00021 4.3809797981940746e-07 0 4.3809797981940746e-07 0 4.3810797981940747e-07 0.00021 4.381179798194075e-07 0 4.381179798194075e-07 0 4.381279798194075e-07 0.00021 4.381379798194075e-07 0 4.381405980368392e-07 0 4.381505980368392e-07 0.00021 4.381605980368392e-07 0 4.381605980368392e-07 0 4.381705980368392e-07 0.00021 4.3818059803683923e-07 0 4.3818059803683923e-07 0 4.3819059803683924e-07 0.00021 4.3820059803683925e-07 0 4.382411738894712e-07 0 4.382511738894712e-07 0.00021 4.3826117388947123e-07 0 4.382845478393703e-07 0 4.3829454783937034e-07 0.00021 4.3830454783937035e-07 0 4.3831296882156455e-07 0 4.3832296882156456e-07 0.00021 4.383329688215646e-07 0 4.383329688215646e-07 0 4.383429688215646e-07 0.00021 4.383529688215646e-07 0 4.383611360090098e-07 0 4.383711360090098e-07 0.00021 4.383811360090098e-07 0 4.383811360090098e-07 0 4.383911360090098e-07 0.00021 4.3840113600900984e-07 0 4.3840113600900984e-07 0 4.3841113600900985e-07 0.00021 4.3842113600900986e-07 0 4.3842113600900986e-07 0 4.3843113600900987e-07 0.00021 4.384411360090099e-07 0 4.384411360090099e-07 0 4.384511360090099e-07 0.00021 4.384611360090099e-07 0 4.384611360090099e-07 0 4.384711360090099e-07 0.00021 4.3848113600900993e-07 0 4.3848113600900993e-07 0 4.3849113600900994e-07 0.00021 4.3850113600900995e-07 0 4.3850113600900995e-07 0 4.3851113600900996e-07 0.00021 4.3852113600900997e-07 0 4.3852113600900997e-07 0 4.3853113600901e-07 0.00021 4.3854113600901e-07 0 4.3854113600901e-07 0 4.3855113600901e-07 0.00021 4.3856113600901e-07 0 4.3856113600901e-07 0 4.3857113600901003e-07 0.00021 4.3858113600901004e-07 0 4.386126970950871e-07 0 4.386226970950871e-07 0.00021 4.386326970950871e-07 0 4.386326970950871e-07 0 4.3864269709508713e-07 0.00021 4.3865269709508714e-07 0 4.3865269709508714e-07 0 4.3866269709508715e-07 0.00021 4.3867269709508716e-07 0 4.3867269709508716e-07 0 4.386826970950872e-07 0.00021 4.386926970950872e-07 0 4.386926970950872e-07 0 4.387026970950872e-07 0.00021 4.387126970950872e-07 0 4.3874770996164183e-07 0 4.3875770996164185e-07 0.00021 4.3876770996164186e-07 0 4.387717910922052e-07 0 4.387817910922052e-07 0.00021 4.387917910922052e-07 0 4.388315848239499e-07 0 4.3884158482394993e-07 0.00021 4.3885158482394994e-07 0 4.388613633384888e-07 0 4.388713633384888e-07 0.00021 4.388813633384888e-07 0 4.3900825423841736e-07 0 4.3901825423841737e-07 0.00021 4.390282542384174e-07 0 4.390282542384174e-07 0 4.390382542384174e-07 0.00021 4.390482542384174e-07 0 4.390482542384174e-07 0 4.390582542384174e-07 0.00021 4.3906825423841743e-07 0 4.391291361062607e-07 0 4.391391361062607e-07 0.00021 4.391491361062607e-07 0 4.391491361062607e-07 0 4.391591361062607e-07 0.00021 4.3916913610626073e-07 0 4.3916913610626073e-07 0 4.3917913610626074e-07 0.00021 4.3918913610626075e-07 0 4.3921224116696417e-07 0 4.392222411669642e-07 0.00021 4.392322411669642e-07 0 4.392460651891209e-07 0 4.392560651891209e-07 0.00021 4.392660651891209e-07 0 4.3931557599087257e-07 0 4.393255759908726e-07 0.00021 4.393355759908726e-07 0 4.393434621572956e-07 0 4.393534621572956e-07 0.00021 4.393634621572956e-07 0 4.393634621572956e-07 0 4.393734621572956e-07 0.00021 4.393834621572956e-07 0 4.393834621572956e-07 0 4.3939346215729564e-07 0.00021 4.3940346215729565e-07 0 4.3940346215729565e-07 0 4.3941346215729566e-07 0.00021 4.3942346215729567e-07 0 4.3942346215729567e-07 0 4.394334621572957e-07 0.00021 4.394434621572957e-07 0 4.3946388144969756e-07 0 4.394738814496976e-07 0.00021 4.394838814496976e-07 0 4.395437552700118e-07 0 4.395537552700118e-07 0.00021 4.3956375527001183e-07 0 4.3956375527001183e-07 0 4.3957375527001184e-07 0.00021 4.3958375527001185e-07 0 4.3959655029502335e-07 0 4.3960655029502336e-07 0.00021 4.3961655029502337e-07 0 4.3961655029502337e-07 0 4.396265502950234e-07 0.00021 4.396365502950234e-07 0 4.396365502950234e-07 0 4.396465502950234e-07 0.00021 4.396565502950234e-07 0 4.396565502950234e-07 0 4.396665502950234e-07 0.00021 4.3967655029502344e-07 0 4.3967655029502344e-07 0 4.3968655029502345e-07 0.00021 4.3969655029502346e-07 0 4.3969655029502346e-07 0 4.3970655029502347e-07 0.00021 4.397165502950235e-07 0 4.397165502950235e-07 0 4.397265502950235e-07 0.00021 4.397365502950235e-07 0 4.397365502950235e-07 0 4.397465502950235e-07 0.00021 4.3975655029502353e-07 0 4.3975655029502353e-07 0 4.3976655029502354e-07 0.00021 4.3977655029502355e-07 0 4.3977655029502355e-07 0 4.3978655029502356e-07 0.00021 4.3979655029502357e-07 0 4.3979655029502357e-07 0 4.398065502950236e-07 0.00021 4.398165502950236e-07 0 4.398165502950236e-07 0 4.398265502950236e-07 0.00021 4.398365502950236e-07 0 4.398365502950236e-07 0 4.3984655029502363e-07 0.00021 4.3985655029502364e-07 0 4.3987625429983697e-07 0 4.39886254299837e-07 0.00021 4.39896254299837e-07 0 4.399726078298223e-07 0 4.3998260782982233e-07 0.00021 4.3999260782982234e-07 0 4.3999260782982234e-07 0 4.4000260782982235e-07 0.00021 4.4001260782982236e-07 0 4.4001260782982236e-07 0 4.400226078298224e-07 0.00021 4.400326078298224e-07 0 4.4005668499149725e-07 0 4.4006668499149726e-07 0.00021 4.4007668499149727e-07 0 4.4007668499149727e-07 0 4.400866849914973e-07 0.00021 4.400966849914973e-07 0 4.401105044551864e-07 0 4.4012050445518643e-07 0.00021 4.4013050445518644e-07 0 4.4017382973350334e-07 0 4.4018382973350336e-07 0.00021 4.4019382973350337e-07 0 4.40244069807885e-07 0 4.40254069807885e-07 0.00021 4.4026406980788503e-07 0 4.402842054280516e-07 0 4.4029420542805163e-07 0.00021 4.4030420542805165e-07 0 4.4031746678790145e-07 0 4.4032746678790146e-07 0.00021 4.403374667879015e-07 0 4.403476916455676e-07 0 4.403576916455676e-07 0.00021 4.403676916455676e-07 0 4.403676916455676e-07 0 4.403776916455676e-07 0.00021 4.403876916455676e-07 0 4.403876916455676e-07 0 4.4039769164556763e-07 0.00021 4.4040769164556764e-07 0 4.4040769164556764e-07 0 4.4041769164556765e-07 0.00021 4.4042769164556767e-07 0 4.4042769164556767e-07 0 4.404376916455677e-07 0.00021 4.404476916455677e-07 0 4.404476916455677e-07 0 4.404576916455677e-07 0.00021 4.404676916455677e-07 0 4.404888742212245e-07 0 4.404988742212245e-07 0.00021 4.4050887422122453e-07 0 4.405179253663433e-07 0 4.405279253663433e-07 0.00021 4.4053792536634333e-07 0 4.4053792536634333e-07 0 4.4054792536634334e-07 0.00021 4.4055792536634335e-07 0 4.4055792536634335e-07 0 4.4056792536634336e-07 0.00021 4.4057792536634337e-07 0 4.4059582529736506e-07 0 4.4060582529736507e-07 0.00021 4.406158252973651e-07 0 4.406537357587311e-07 0 4.406637357587311e-07 0.00021 4.406737357587311e-07 0 4.4068213076362646e-07 0 4.4069213076362647e-07 0.00021 4.407021307636265e-07 0 4.4074892095765e-07 0 4.4075892095765003e-07 0.00021 4.4076892095765005e-07 0 4.4078211960381227e-07 0 4.407921196038123e-07 0.00021 4.408021196038123e-07 0 4.408718771559873e-07 0 4.408818771559873e-07 0.00021 4.408918771559873e-07 0 4.408993501447698e-07 0 4.409093501447698e-07 0.00021 4.409193501447698e-07 0 4.409355163125008e-07 0 4.409455163125008e-07 0.00021 4.4095551631250083e-07 0 4.4096344795592153e-07 0 4.4097344795592154e-07 0.00021 4.4098344795592155e-07 0 4.4100990008309484e-07 0 4.4101990008309485e-07 0.00021 4.4102990008309487e-07 0 4.4104116795313434e-07 0 4.4105116795313435e-07 0.00021 4.4106116795313436e-07 0 4.4117784972711036e-07 0 4.4118784972711037e-07 0.00021 4.411978497271104e-07 0 4.4121396559234486e-07 0 4.4122396559234487e-07 0.00021 4.412339655923449e-07 0 4.412339655923449e-07 0 4.412439655923449e-07 0.00021 4.412539655923449e-07 0 4.412543455366846e-07 0 4.4126434553668464e-07 0.00021 4.4127434553668465e-07 0 4.413734592606012e-07 0 4.4138345926060123e-07 0.00021 4.4139345926060124e-07 0 4.414002371763092e-07 0 4.414102371763092e-07 0.00021 4.414202371763092e-07 0 4.4144674331404145e-07 0 4.4145674331404146e-07 0.00021 4.414667433140415e-07 0 4.4152496137277575e-07 0 4.4153496137277577e-07 0.00021 4.415449613727758e-07 0 4.4154835428569007e-07 0 4.415583542856901e-07 0.00021 4.415683542856901e-07 0 4.416855673199179e-07 0 4.416955673199179e-07 0.00021 4.417055673199179e-07 0 4.417173527006205e-07 0 4.417273527006205e-07 0.00021 4.417373527006205e-07 0 4.417373527006205e-07 0 4.417473527006205e-07 0.00021 4.4175735270062053e-07 0 4.4175735270062053e-07 0 4.4176735270062054e-07 0.00021 4.4177735270062056e-07 0 4.4177735270062056e-07 0 4.4178735270062057e-07 0.00021 4.417973527006206e-07 0 4.417973527006206e-07 0 4.418073527006206e-07 0.00021 4.418173527006206e-07 0 4.4186644997082073e-07 0 4.4187644997082074e-07 0.00021 4.4188644997082076e-07 0 4.4188644997082076e-07 0 4.4189644997082077e-07 0.00021 4.419064499708208e-07 0 4.419064499708208e-07 0 4.419164499708208e-07 0.00021 4.419264499708208e-07 0 4.419264499708208e-07 0 4.419364499708208e-07 0.00021 4.419464499708208e-07 0 4.419464499708208e-07 0 4.4195644997082083e-07 0.00021 4.4196644997082085e-07 0 4.4196644997082085e-07 0 4.4197644997082086e-07 0.00021 4.4198644997082087e-07 0 4.4198644997082087e-07 0 4.419964499708209e-07 0.00021 4.420064499708209e-07 0 4.420064499708209e-07 0 4.420164499708209e-07 0.00021 4.420264499708209e-07 0 4.420264499708209e-07 0 4.420364499708209e-07 0.00021 4.4204644997082094e-07 0 4.4204644997082094e-07 0 4.4205644997082095e-07 0.00021 4.4206644997082096e-07 0 4.4209743386361576e-07 0 4.4210743386361577e-07 0.00021 4.421174338636158e-07 0 4.421751527970051e-07 0 4.421851527970051e-07 0.00021 4.4219515279700514e-07 0 4.4219515279700514e-07 0 4.4220515279700515e-07 0.00021 4.4221515279700516e-07 0 4.4221515279700516e-07 0 4.4222515279700517e-07 0.00021 4.422351527970052e-07 0 4.422351527970052e-07 0 4.422451527970052e-07 0.00021 4.422551527970052e-07 0 4.422551527970052e-07 0 4.422651527970052e-07 0.00021 4.422751527970052e-07 0 4.422751527970052e-07 0 4.4228515279700524e-07 0.00021 4.4229515279700525e-07 0 4.4231387271254996e-07 0 4.4232387271254997e-07 0.00021 4.4233387271255e-07 0 4.4233387271255e-07 0 4.4234387271255e-07 0.00021 4.4235387271255e-07 0 4.4235387271255e-07 0 4.4236387271255e-07 0.00021 4.4237387271255003e-07 0 4.4237387271255003e-07 0 4.4238387271255004e-07 0.00021 4.4239387271255005e-07 0 4.423944792942626e-07 0 4.424044792942626e-07 0.00021 4.4241447929426263e-07 0 4.4243022344563016e-07 0 4.4244022344563017e-07 0.00021 4.424502234456302e-07 0 4.424502234456302e-07 0 4.424602234456302e-07 0.00021 4.424702234456302e-07 0 4.424768756183414e-07 0 4.424868756183414e-07 0.00021 4.424968756183414e-07 0 4.424991563131429e-07 0 4.425091563131429e-07 0.00021 4.425191563131429e-07 0 4.4252961008287904e-07 0 4.4253961008287906e-07 0.00021 4.4254961008287907e-07 0 4.427512519446651e-07 0 4.427612519446651e-07 0.00021 4.427712519446651e-07 0 4.427712519446651e-07 0 4.427812519446651e-07 0.00021 4.4279125194466514e-07 0 4.428477356150731e-07 0 4.428577356150731e-07 0.00021 4.428677356150731e-07 0 4.428677356150731e-07 0 4.4287773561507313e-07 0.00021 4.4288773561507314e-07 0 4.4288773561507314e-07 0 4.4289773561507315e-07 0.00021 4.4290773561507316e-07 0 4.4290773561507316e-07 0 4.429177356150732e-07 0.00021 4.429277356150732e-07 0 4.430203316748258e-07 0 4.430303316748258e-07 0.00021 4.430403316748258e-07 0 4.430403316748258e-07 0 4.430503316748258e-07 0.00021 4.4306033167482584e-07 0 4.4306033167482584e-07 0 4.4307033167482585e-07 0.00021 4.4308033167482586e-07 0 4.430829977666397e-07 0 4.430929977666397e-07 0.00021 4.4310299776663974e-07 0 4.4313482938062026e-07 0 4.4314482938062027e-07 0.00021 4.431548293806203e-07 0 4.431548293806203e-07 0 4.431648293806203e-07 0.00021 4.431748293806203e-07 0 4.431828022116949e-07 0 4.431928022116949e-07 0.00021 4.432028022116949e-07 0 4.432028022116949e-07 0 4.4321280221169493e-07 0.00021 4.4322280221169494e-07 0 4.4322450712386905e-07 0 4.4323450712386906e-07 0.00021 4.432445071238691e-07 0 4.432445071238691e-07 0 4.432545071238691e-07 0.00021 4.432645071238691e-07 0 4.432645071238691e-07 0 4.432745071238691e-07 0.00021 4.432845071238691e-07 0 4.432845071238691e-07 0 4.4329450712386913e-07 0.00021 4.4330450712386914e-07 0 4.4330450712386914e-07 0 4.4331450712386915e-07 0.00021 4.4332450712386916e-07 0 4.4332450712386916e-07 0 4.433345071238692e-07 0.00021 4.433445071238692e-07 0 4.433445071238692e-07 0 4.433545071238692e-07 0.00021 4.433645071238692e-07 0 4.433645071238692e-07 0 4.433745071238692e-07 0.00021 4.4338450712386923e-07 0 4.4338450712386923e-07 0 4.4339450712386924e-07 0.00021 4.4340450712386926e-07 0 4.4340450712386926e-07 0 4.4341450712386927e-07 0.00021 4.434245071238693e-07 0 4.434245071238693e-07 0 4.434345071238693e-07 0.00021 4.434445071238693e-07 0 4.434445071238693e-07 0 4.434545071238693e-07 0.00021 4.434645071238693e-07 0 4.434745646911214e-07 0 4.4348456469112143e-07 0.00021 4.4349456469112144e-07 0 4.4349456469112144e-07 0 4.4350456469112145e-07 0.00021 4.4351456469112146e-07 0 4.4353688286166807e-07 0 4.435468828616681e-07 0.00021 4.435568828616681e-07 0 4.4357921620374697e-07 0 4.43589216203747e-07 0.00021 4.43599216203747e-07 0 4.43599216203747e-07 0 4.43609216203747e-07 0.00021 4.43619216203747e-07 0 4.43619216203747e-07 0 4.43629216203747e-07 0.00021 4.4363921620374703e-07 0 4.4363921620374703e-07 0 4.4364921620374705e-07 0.00021 4.4365921620374706e-07 0 4.436845872240054e-07 0 4.436945872240054e-07 0.00021 4.4370458722400543e-07 0 4.4370458722400543e-07 0 4.4371458722400544e-07 0.00021 4.4372458722400546e-07 0 4.4372458722400546e-07 0 4.4373458722400547e-07 0.00021 4.437445872240055e-07 0 4.437445872240055e-07 0 4.437545872240055e-07 0.00021 4.437645872240055e-07 0 4.437645872240055e-07 0 4.437745872240055e-07 0.00021 4.437845872240055e-07 0 4.437934418145065e-07 0 4.438034418145065e-07 0.00021 4.438134418145065e-07 0 4.438303033527951e-07 0 4.438403033527951e-07 0.00021 4.4385030335279513e-07 0 4.4385030335279513e-07 0 4.4386030335279514e-07 0.00021 4.4387030335279516e-07 0 4.4387030335279516e-07 0 4.4388030335279517e-07 0.00021 4.438903033527952e-07 0 4.4397660674164654e-07 0 4.4398660674164655e-07 0.00021 4.4399660674164657e-07 0 4.440014754310045e-07 0 4.4401147543100453e-07 0.00021 4.4402147543100454e-07 0 4.4405014595541595e-07 0 4.4406014595541596e-07 0.00021 4.44070145955416e-07 0 4.44070145955416e-07 0 4.44080145955416e-07 0.00021 4.44090145955416e-07 0 4.4411485072767466e-07 0 4.441248507276747e-07 0.00021 4.441348507276747e-07 0 4.4416215587776416e-07 0 4.4417215587776417e-07 0.00021 4.441821558777642e-07 0 4.441821558777642e-07 0 4.441921558777642e-07 0.00021 4.442021558777642e-07 0 4.442021558777642e-07 0 4.442121558777642e-07 0.00021 4.4422215587776423e-07 0 4.4429118031223033e-07 0 4.4430118031223034e-07 0.00021 4.4431118031223035e-07 0 4.4431118031223035e-07 0 4.4432118031223036e-07 0.00021 4.443311803122304e-07 0 4.443311803122304e-07 0 4.443411803122304e-07 0.00021 4.443511803122304e-07 0 4.443511803122304e-07 0 4.443611803122304e-07 0.00021 4.443711803122304e-07 0 4.4444872761859714e-07 0 4.4445872761859715e-07 0.00021 4.4446872761859716e-07 0 4.4454320677681383e-07 0 4.4455320677681384e-07 0.00021 4.4456320677681385e-07 0 4.445662221560391e-07 0 4.445762221560391e-07 0.00021 4.4458622215603913e-07 0 4.4458622215603913e-07 0 4.4459622215603914e-07 0.00021 4.4460622215603915e-07 0 4.4460622215603915e-07 0 4.4461622215603917e-07 0.00021 4.446262221560392e-07 0 4.4468842303815464e-07 0 4.4469842303815465e-07 0.00021 4.4470842303815467e-07 0 4.4470842303815467e-07 0 4.447184230381547e-07 0.00021 4.447284230381547e-07 0 4.447284230381547e-07 0 4.447384230381547e-07 0.00021 4.447484230381547e-07 0 4.447484230381547e-07 0 4.447584230381547e-07 0.00021 4.4476842303815473e-07 0 4.4476842303815473e-07 0 4.4477842303815474e-07 0.00021 4.4478842303815476e-07 0 4.4478842303815476e-07 0 4.4479842303815477e-07 0.00021 4.448084230381548e-07 0 4.448084230381548e-07 0 4.448184230381548e-07 0.00021 4.448284230381548e-07 0 4.448284230381548e-07 0 4.448384230381548e-07 0.00021 4.448484230381548e-07 0 4.448484230381548e-07 0 4.4485842303815484e-07 0.00021 4.4486842303815485e-07 0 4.4487521676219477e-07 0 4.448852167621948e-07 0.00021 4.448952167621948e-07 0 4.448952167621948e-07 0 4.449052167621948e-07 0.00021 4.449152167621948e-07 0 4.449152167621948e-07 0 4.4492521676219483e-07 0.00021 4.4493521676219484e-07 0 4.4493521676219484e-07 0 4.4494521676219485e-07 0.00021 4.4495521676219486e-07 0 4.4495521676219486e-07 0 4.4496521676219487e-07 0.00021 4.449752167621949e-07 0 4.449752167621949e-07 0 4.449852167621949e-07 0.00021 4.449952167621949e-07 0 4.4501184468142737e-07 0 4.450218446814274e-07 0.00021 4.450318446814274e-07 0 4.450823095791222e-07 0 4.4509230957912223e-07 0.00021 4.4510230957912224e-07 0 4.4510230957912224e-07 0 4.4511230957912225e-07 0.00021 4.4512230957912227e-07 0 4.451303776241103e-07 0 4.451403776241103e-07 0.00021 4.451503776241103e-07 0 4.451503776241103e-07 0 4.4516037762411033e-07 0.00021 4.4517037762411034e-07 0 4.4517543994892957e-07 0 4.451854399489296e-07 0.00021 4.451954399489296e-07 0 4.451954399489296e-07 0 4.452054399489296e-07 0.00021 4.452154399489296e-07 0 4.452154399489296e-07 0 4.4522543994892963e-07 0.00021 4.4523543994892964e-07 0 4.4523939093649667e-07 0 4.452493909364967e-07 0.00021 4.452593909364967e-07 0 4.452887473929366e-07 0 4.4529874739293663e-07 0.00021 4.4530874739293664e-07 0 4.453416531389128e-07 0 4.4535165313891284e-07 0.00021 4.4536165313891285e-07 0 4.4536165313891285e-07 0 4.4537165313891286e-07 0.00021 4.4538165313891287e-07 0 4.4546195458628514e-07 0 4.4547195458628516e-07 0.00021 4.4548195458628517e-07 0 4.45488154883793e-07 0 4.45498154883793e-07 0.00021 4.45508154883793e-07 0 4.45525993899989e-07 0 4.45535993899989e-07 0.00021 4.45545993899989e-07 0 4.45545993899989e-07 0 4.45555993899989e-07 0.00021 4.4556599389998903e-07 0 4.4556599389998903e-07 0 4.4557599389998904e-07 0.00021 4.4558599389998905e-07 0 4.4558599389998905e-07 0 4.4559599389998907e-07 0.00021 4.456059938999891e-07 0 4.456059938999891e-07 0 4.456159938999891e-07 0.00021 4.456259938999891e-07 0 4.456259938999891e-07 0 4.456359938999891e-07 0.00021 4.456459938999891e-07 0 4.456498724697675e-07 0 4.4565987246976754e-07 0.00021 4.4566987246976755e-07 0 4.4566987246976755e-07 0 4.4567987246976756e-07 0.00021 4.4568987246976757e-07 0 4.4568987246976757e-07 0 4.456998724697676e-07 0.00021 4.457098724697676e-07 0 4.4571884612353514e-07 0 4.4572884612353515e-07 0.00021 4.4573884612353517e-07 0 4.4573884612353517e-07 0 4.457488461235352e-07 0.00021 4.457588461235352e-07 0 4.457588461235352e-07 0 4.457688461235352e-07 0.00021 4.457788461235352e-07 0 4.457788461235352e-07 0 4.457888461235352e-07 0.00021 4.4579884612353523e-07 0 4.4579884612353523e-07 0 4.4580884612353524e-07 0.00021 4.4581884612353526e-07 0 4.4581884612353526e-07 0 4.4582884612353527e-07 0.00021 4.458388461235353e-07 0 4.458388461235353e-07 0 4.458488461235353e-07 0.00021 4.458588461235353e-07 0 4.458588461235353e-07 0 4.458688461235353e-07 0.00021 4.458788461235353e-07 0 4.4588570814769266e-07 0 4.4589570814769267e-07 0.00021 4.459057081476927e-07 0 4.4593281405509945e-07 0 4.4594281405509947e-07 0.00021 4.459528140550995e-07 0 4.4595717037045024e-07 0 4.4596717037045025e-07 0.00021 4.4597717037045026e-07 0 4.459876508682565e-07 0 4.459976508682565e-07 0.00021 4.4600765086825653e-07 0 4.4600765086825653e-07 0 4.4601765086825654e-07 0.00021 4.4602765086825655e-07 0 4.4605901800929184e-07 0 4.4606901800929185e-07 0.00021 4.4607901800929186e-07 0 4.4607901800929186e-07 0 4.460890180092919e-07 0.00021 4.460990180092919e-07 0 4.460990180092919e-07 0 4.461090180092919e-07 0.00021 4.461190180092919e-07 0 4.461190180092919e-07 0 4.461290180092919e-07 0.00021 4.4613901800929193e-07 0 4.4613901800929193e-07 0 4.4614901800929194e-07 0.00021 4.4615901800929196e-07 0 4.4615901800929196e-07 0 4.4616901800929197e-07 0.00021 4.46179018009292e-07 0 4.462294395789293e-07 0 4.462394395789293e-07 0.00021 4.4624943957892933e-07 0 4.4624943957892933e-07 0 4.4625943957892934e-07 0.00021 4.4626943957892935e-07 0 4.462767039893744e-07 0 4.462867039893744e-07 0.00021 4.462967039893744e-07 0 4.463324283838222e-07 0 4.463424283838222e-07 0.00021 4.463524283838222e-07 0 4.4635433645042775e-07 0 4.4636433645042776e-07 0.00021 4.4637433645042777e-07 0 4.4638651276778594e-07 0 4.4639651276778595e-07 0.00021 4.4640651276778596e-07 0 4.4640651276778596e-07 0 4.4641651276778597e-07 0.00021 4.46426512767786e-07 0 4.46426512767786e-07 0 4.46436512767786e-07 0.00021 4.46446512767786e-07 0 4.464664311502264e-07 0 4.464764311502264e-07 0.00021 4.464864311502264e-07 0 4.4649557097529185e-07 0 4.4650557097529186e-07 0.00021 4.4651557097529187e-07 0 4.4651557097529187e-07 0 4.465255709752919e-07 0.00021 4.465355709752919e-07 0 4.465355709752919e-07 0 4.465455709752919e-07 0.00021 4.465555709752919e-07 0 4.465555709752919e-07 0 4.465655709752919e-07 0.00021 4.4657557097529194e-07 0 4.4657557097529194e-07 0 4.4658557097529195e-07 0.00021 4.4659557097529196e-07 0 4.4659557097529196e-07 0 4.4660557097529197e-07 0.00021 4.46615570975292e-07 0 4.46615570975292e-07 0 4.46625570975292e-07 0.00021 4.46635570975292e-07 0 4.46635570975292e-07 0 4.46645570975292e-07 0.00021 4.4665557097529203e-07 0 4.4665557097529203e-07 0 4.4666557097529204e-07 0.00021 4.4667557097529205e-07 0 4.4667557097529205e-07 0 4.4668557097529206e-07 0.00021 4.4669557097529207e-07 0 4.467306228713225e-07 0 4.467406228713225e-07 0.00021 4.467506228713225e-07 0 4.467506228713225e-07 0 4.467606228713225e-07 0.00021 4.467706228713225e-07 0 4.467706228713225e-07 0 4.4678062287132253e-07 0.00021 4.4679062287132254e-07 0 4.4679062287132254e-07 0 4.4680062287132255e-07 0.00021 4.4681062287132257e-07 0 4.468149534436279e-07 0 4.468249534436279e-07 0.00021 4.468349534436279e-07 0 4.468793472035526e-07 0 4.468893472035526e-07 0.00021 4.4689934720355263e-07 0 4.4691821859935673e-07 0 4.4692821859935674e-07 0.00021 4.4693821859935675e-07 0 4.4693821859935675e-07 0 4.4694821859935676e-07 0.00021 4.469582185993568e-07 0 4.469582185993568e-07 0 4.469682185993568e-07 0.00021 4.469782185993568e-07 0 4.469782185993568e-07 0 4.469882185993568e-07 0.00021 4.469982185993568e-07 0 4.4700529756270163e-07 0 4.4701529756270164e-07 0.00021 4.4702529756270166e-07 0 4.4702529756270166e-07 0 4.4703529756270167e-07 0.00021 4.470452975627017e-07 0 4.470452975627017e-07 0 4.470552975627017e-07 0.00021 4.470652975627017e-07 0 4.470652975627017e-07 0 4.470752975627017e-07 0.00021 4.470852975627017e-07 0 4.470852975627017e-07 0 4.4709529756270173e-07 0.00021 4.4710529756270175e-07 0 4.4710529756270175e-07 0 4.4711529756270176e-07 0.00021 4.4712529756270177e-07 0 4.4712529756270177e-07 0 4.471352975627018e-07 0.00021 4.471452975627018e-07 0 4.471452975627018e-07 0 4.471552975627018e-07 0.00021 4.471652975627018e-07 0 4.471652975627018e-07 0 4.471752975627018e-07 0.00021 4.4718529756270184e-07 0 4.472004256576745e-07 0 4.472104256576745e-07 0.00021 4.472204256576745e-07 0 4.4732938117648673e-07 0 4.4733938117648674e-07 0.00021 4.4734938117648675e-07 0 4.473933182763414e-07 0 4.474033182763414e-07 0.00021 4.474133182763414e-07 0 4.47422923937102e-07 0 4.4743292393710203e-07 0.00021 4.4744292393710204e-07 0 4.4744292393710204e-07 0 4.4745292393710205e-07 0.00021 4.4746292393710206e-07 0 4.4748789543639374e-07 0 4.4749789543639375e-07 0.00021 4.4750789543639376e-07 0 4.4754855131247055e-07 0 4.4755855131247056e-07 0.00021 4.475685513124706e-07 0 4.475685513124706e-07 0 4.475785513124706e-07 0.00021 4.475885513124706e-07 0 4.4763742993589787e-07 0 4.476474299358979e-07 0.00021 4.476574299358979e-07 0 4.476617527731345e-07 0 4.476717527731345e-07 0.00021 4.476817527731345e-07 0 4.476817527731345e-07 0 4.476917527731345e-07 0.00021 4.4770175277313453e-07 0 4.4770175277313453e-07 0 4.4771175277313454e-07 0.00021 4.4772175277313455e-07 0 4.4772175277313455e-07 0 4.4773175277313457e-07 0.00021 4.477417527731346e-07 0 4.477417527731346e-07 0 4.477517527731346e-07 0.00021 4.477617527731346e-07 0 4.477617527731346e-07 0 4.477717527731346e-07 0.00021 4.477817527731346e-07 0 4.477817527731346e-07 0 4.4779175277313463e-07 0.00021 4.4780175277313465e-07 0 4.4780175277313465e-07 0 4.4781175277313466e-07 0.00021 4.4782175277313467e-07 0 4.4782175277313467e-07 0 4.478317527731347e-07 0.00021 4.478417527731347e-07 0 4.478417527731347e-07 0 4.478517527731347e-07 0.00021 4.478617527731347e-07 0 4.478617527731347e-07 0 4.478717527731347e-07 0.00021 4.4788175277313474e-07 0 4.4788175277313474e-07 0 4.4789175277313475e-07 0.00021 4.4790175277313476e-07 0 4.4790175277313476e-07 0 4.4791175277313477e-07 0.00021 4.479217527731348e-07 0 4.479217527731348e-07 0 4.479317527731348e-07 0.00021 4.479417527731348e-07 0 4.479417527731348e-07 0 4.479517527731348e-07 0.00021 4.4796175277313483e-07 0 4.4796175277313483e-07 0 4.4797175277313484e-07 0.00021 4.4798175277313485e-07 0 4.4798175277313485e-07 0 4.4799175277313486e-07 0.00021 4.4800175277313487e-07 0 4.4800175277313487e-07 0 4.480117527731349e-07 0.00021 4.480217527731349e-07 0 4.480217527731349e-07 0 4.480317527731349e-07 0.00021 4.480417527731349e-07 0 4.480417527731349e-07 0 4.4805175277313493e-07 0.00021 4.4806175277313494e-07 0 4.4806175277313494e-07 0 4.4807175277313495e-07 0.00021 4.4808175277313496e-07 0 4.4808175277313496e-07 0 4.48091752773135e-07 0.00021 4.48101752773135e-07 0 4.48101752773135e-07 0 4.48111752773135e-07 0.00021 4.48121752773135e-07 0 4.48121752773135e-07 0 4.48131752773135e-07 0.00021 4.4814175277313503e-07 0 4.4814175277313503e-07 0 4.4815175277313504e-07 0.00021 4.4816175277313505e-07 0 4.4816175277313505e-07 0 4.4817175277313506e-07 0.00021 4.481817527731351e-07 0 4.481817527731351e-07 0 4.481917527731351e-07 0.00021 4.482017527731351e-07 0 4.482197484356549e-07 0 4.482297484356549e-07 0.00021 4.482397484356549e-07 0 4.482397484356549e-07 0 4.482497484356549e-07 0.00021 4.4825974843565494e-07 0 4.4825974843565494e-07 0 4.4826974843565495e-07 0.00021 4.4827974843565496e-07 0 4.4830228583292047e-07 0 4.483122858329205e-07 0.00021 4.483222858329205e-07 0 4.483222858329205e-07 0 4.483322858329205e-07 0.00021 4.483422858329205e-07 0 4.4835250169260686e-07 0 4.4836250169260687e-07 0.00021 4.483725016926069e-07 0 4.483725016926069e-07 0 4.483825016926069e-07 0.00021 4.483925016926069e-07 0 4.483925016926069e-07 0 4.484025016926069e-07 0.00021 4.484125016926069e-07 0 4.484125016926069e-07 0 4.4842250169260694e-07 0.00021 4.4843250169260695e-07 0 4.484709758901367e-07 0 4.484809758901367e-07 0.00021 4.484909758901367e-07 0 4.484909758901367e-07 0 4.485009758901367e-07 0.00021 4.4851097589013673e-07 0 4.485598814568654e-07 0 4.485698814568654e-07 0.00021 4.4857988145686543e-07 0 4.4857988145686543e-07 0 4.4858988145686545e-07 0.00021 4.4859988145686546e-07 0 4.4859988145686546e-07 0 4.4860988145686547e-07 0.00021 4.486198814568655e-07 0 4.486198814568655e-07 0 4.486298814568655e-07 0.00021 4.486398814568655e-07 0 4.486398814568655e-07 0 4.486498814568655e-07 0.00021 4.486598814568655e-07 0 4.486598814568655e-07 0 4.4866988145686554e-07 0.00021 4.4867988145686555e-07 0 4.487486249808988e-07 0 4.487586249808988e-07 0.00021 4.4876862498089883e-07 0 4.4876862498089883e-07 0 4.4877862498089884e-07 0.00021 4.4878862498089885e-07 0 4.4878862498089885e-07 0 4.4879862498089886e-07 0.00021 4.4880862498089887e-07 0 4.489003017272175e-07 0 4.4891030172721754e-07 0.00021 4.4892030172721755e-07 0 4.4892030172721755e-07 0 4.4893030172721756e-07 0.00021 4.4894030172721757e-07 0 4.489411330817976e-07 0 4.489511330817976e-07 0.00021 4.489611330817976e-07 0 4.489611330817976e-07 0 4.489711330817976e-07 0.00021 4.489811330817976e-07 0 4.4901747060344296e-07 0 4.4902747060344297e-07 0.00021 4.49037470603443e-07 0 4.490476948411519e-07 0 4.490576948411519e-07 0.00021 4.4906769484115193e-07 0 4.4906769484115193e-07 0 4.4907769484115194e-07 0.00021 4.4908769484115195e-07 0 4.4908769484115195e-07 0 4.4909769484115196e-07 0.00021 4.4910769484115197e-07 0 4.4910769484115197e-07 0 4.49117694841152e-07 0.00021 4.49127694841152e-07 0 4.49127694841152e-07 0 4.49137694841152e-07 0.00021 4.49147694841152e-07 0 4.49147694841152e-07 0 4.4915769484115203e-07 0.00021 4.4916769484115204e-07 0 4.4916769484115204e-07 0 4.4917769484115205e-07 0.00021 4.4918769484115206e-07 0 4.4924096783952694e-07 0 4.4925096783952695e-07 0.00021 4.4926096783952697e-07 0 4.4928534420263074e-07 0 4.4929534420263075e-07 0.00021 4.4930534420263076e-07 0 4.493072913153277e-07 0 4.4931729131532773e-07 0.00021 4.4932729131532774e-07 0 4.4932729131532774e-07 0 4.4933729131532775e-07 0.00021 4.4934729131532776e-07 0 4.493528086529839e-07 0 4.493628086529839e-07 0.00021 4.493728086529839e-07 0 4.493728086529839e-07 0 4.4938280865298393e-07 0.00021 4.4939280865298394e-07 0 4.4940216391176003e-07 0 4.4941216391176004e-07 0.00021 4.4942216391176005e-07 0 4.4950570246072407e-07 0 4.495157024607241e-07 0.00021 4.495257024607241e-07 0 4.495257024607241e-07 0 4.495357024607241e-07 0.00021 4.495457024607241e-07 0 4.4966721476606653e-07 0 4.4967721476606654e-07 0.00021 4.4968721476606655e-07 0 4.4968721476606655e-07 0 4.4969721476606657e-07 0.00021 4.497072147660666e-07 0 4.497339186261862e-07 0 4.4974391862618623e-07 0.00021 4.4975391862618624e-07 0 4.4975391862618624e-07 0 4.4976391862618626e-07 0.00021 4.4977391862618627e-07 0 4.4977391862618627e-07 0 4.497839186261863e-07 0.00021 4.497939186261863e-07 0 4.497939186261863e-07 0 4.498039186261863e-07 0.00021 4.498139186261863e-07 0 4.498200550304162e-07 0 4.498300550304162e-07 0.00021 4.498400550304162e-07 0 4.4991734945917885e-07 0 4.4992734945917886e-07 0.00021 4.4993734945917887e-07 0 4.4995663954706435e-07 0 4.4996663954706436e-07 0.00021 4.499766395470644e-07 0 4.499766395470644e-07 0 4.499866395470644e-07 0.00021 4.499966395470644e-07 0 4.499966395470644e-07 0 4.500066395470644e-07 0.00021 4.500166395470644e-07 0 4.5001904264254566e-07 0 4.500290426425457e-07 0.00021 4.500390426425457e-07 0 4.500568643784482e-07 0 4.500668643784482e-07 0.00021 4.500768643784482e-07 0 4.5008149655368944e-07 0 4.5009149655368945e-07 0.00021 4.5010149655368946e-07 0 4.5016286385378116e-07 0 4.501728638537812e-07 0.00021 4.501828638537812e-07 0 4.501828638537812e-07 0 4.501928638537812e-07 0.00021 4.502028638537812e-07 0 4.502028638537812e-07 0 4.502128638537812e-07 0.00021 4.5022286385378123e-07 0 4.5022286385378123e-07 0 4.5023286385378124e-07 0.00021 4.5024286385378126e-07 0 4.5024286385378126e-07 0 4.5025286385378127e-07 0.00021 4.502628638537813e-07 0 4.5026867676859244e-07 0 4.5027867676859245e-07 0.00021 4.5028867676859246e-07 0 4.50332817507654e-07 0 4.50342817507654e-07 0.00021 4.50352817507654e-07 0 4.50352817507654e-07 0 4.50362817507654e-07 0.00021 4.5037281750765403e-07 0 4.5037281750765403e-07 0 4.5038281750765404e-07 0.00021 4.5039281750765406e-07 0 4.5042466100345547e-07 0 4.504346610034555e-07 0.00021 4.504446610034555e-07 0 4.504446610034555e-07 0 4.504546610034555e-07 0.00021 4.504646610034555e-07 0 4.504646610034555e-07 0 4.5047466100345553e-07 0.00021 4.5048466100345554e-07 0 4.5049112025104224e-07 0 4.5050112025104225e-07 0.00021 4.5051112025104226e-07 0 4.5051725749899403e-07 0 4.5052725749899405e-07 0.00021 4.5053725749899406e-07 0 4.5053725749899406e-07 0 4.5054725749899407e-07 0.00021 4.505572574989941e-07 0 4.506118910815183e-07 0 4.506218910815183e-07 0.00021 4.5063189108151833e-07 0 4.506553574974024e-07 0 4.506653574974024e-07 0.00021 4.506753574974024e-07 0 4.506753574974024e-07 0 4.5068535749740243e-07 0.00021 4.5069535749740244e-07 0 4.507200923977617e-07 0 4.507300923977617e-07 0.00021 4.5074009239776174e-07 0 4.5074009239776174e-07 0 4.5075009239776175e-07 0.00021 4.5076009239776176e-07 0 4.5077132250433695e-07 0 4.5078132250433696e-07 0.00021 4.50791322504337e-07 0 4.50791322504337e-07 0 4.50801322504337e-07 0.00021 4.50811322504337e-07 0 4.50811322504337e-07 0 4.50821322504337e-07 0.00021 4.50831322504337e-07 0 4.50831322504337e-07 0 4.5084132250433703e-07 0.00021 4.5085132250433704e-07 0 4.5085132250433704e-07 0 4.5086132250433706e-07 0.00021 4.5087132250433707e-07 0 4.5087132250433707e-07 0 4.508813225043371e-07 0.00021 4.508913225043371e-07 0 4.508913225043371e-07 0 4.509013225043371e-07 0.00021 4.509113225043371e-07 0 4.509113225043371e-07 0 4.509213225043371e-07 0.00021 4.5093132250433713e-07 0 4.5093132250433713e-07 0 4.5094132250433715e-07 0.00021 4.5095132250433716e-07 0 4.509625374985968e-07 0 4.509725374985968e-07 0.00021 4.509825374985968e-07 0 4.510545406093192e-07 0 4.510645406093192e-07 0.00021 4.510745406093192e-07 0 4.510745406093192e-07 0 4.5108454060931923e-07 0.00021 4.5109454060931924e-07 0 4.5109454060931924e-07 0 4.5110454060931925e-07 0.00021 4.5111454060931926e-07 0 4.5111454060931926e-07 0 4.511245406093193e-07 0.00021 4.511345406093193e-07 0 4.5113956990286166e-07 0 4.5114956990286167e-07 0.00021 4.511595699028617e-07 0 4.511757755416682e-07 0 4.5118577554166823e-07 0.00021 4.5119577554166824e-07 0 4.5122918326296445e-07 0 4.5123918326296446e-07 0.00021 4.5124918326296447e-07 0 4.5125208846595846e-07 0 4.5126208846595847e-07 0.00021 4.512720884659585e-07 0 4.5128813986418297e-07 0 4.51298139864183e-07 0.00021 4.51308139864183e-07 0 4.5132645044557776e-07 0 4.5133645044557777e-07 0.00021 4.513464504455778e-07 0 4.513470800413482e-07 0 4.513570800413482e-07 0.00021 4.513670800413482e-07 0 4.5136725394796326e-07 0 4.5137725394796327e-07 0.00021 4.513872539479633e-07 0 4.513895481745411e-07 0 4.513995481745411e-07 0.00021 4.5140954817454114e-07 0 4.5148336494394854e-07 0 4.5149336494394855e-07 0.00021 4.5150336494394856e-07 0 4.515815595413944e-07 0 4.515915595413944e-07 0.00021 4.5160155954139443e-07 0 4.5160155954139443e-07 0 4.5161155954139445e-07 0.00021 4.5162155954139446e-07 0 4.5162155954139446e-07 0 4.5163155954139447e-07 0.00021 4.516415595413945e-07 0 4.516415595413945e-07 0 4.516515595413945e-07 0.00021 4.516615595413945e-07 0 4.516615595413945e-07 0 4.516715595413945e-07 0.00021 4.516815595413945e-07 0 4.5173863414939164e-07 0 4.5174863414939165e-07 0.00021 4.5175863414939166e-07 0 4.5175863414939166e-07 0 4.5176863414939167e-07 0.00021 4.517786341493917e-07 0 4.517816919671691e-07 0 4.517916919671691e-07 0.00021 4.518016919671691e-07 0 4.518847797069751e-07 0 4.518947797069751e-07 0.00021 4.5190477970697514e-07 0 4.5194923521467446e-07 0 4.519592352146745e-07 0.00021 4.519692352146745e-07 0 4.5201565178030136e-07 0 4.5202565178030137e-07 0.00021 4.520356517803014e-07 0 4.5204444754975027e-07 0 4.520544475497503e-07 0.00021 4.520644475497503e-07 0 4.520644475497503e-07 0 4.520744475497503e-07 0.00021 4.520844475497503e-07 0 4.5211128133699214e-07 0 4.5212128133699215e-07 0.00021 4.5213128133699216e-07 0 4.522243301727107e-07 0 4.522343301727107e-07 0.00021 4.522443301727107e-07 0 4.522443301727107e-07 0 4.5225433017271073e-07 0.00021 4.5226433017271074e-07 0 4.5226433017271074e-07 0 4.5227433017271076e-07 0.00021 4.5228433017271077e-07 0 4.5228433017271077e-07 0 4.522943301727108e-07 0.00021 4.523043301727108e-07 0 4.523043301727108e-07 0 4.523143301727108e-07 0.00021 4.523243301727108e-07 0 4.523243301727108e-07 0 4.523343301727108e-07 0.00021 4.5234433017271084e-07 0 4.523614171341197e-07 0 4.523714171341197e-07 0.00021 4.523814171341197e-07 0 4.524155765043485e-07 0 4.524255765043485e-07 0.00021 4.524355765043485e-07 0 4.524671740017544e-07 0 4.524771740017544e-07 0.00021 4.5248717400175443e-07 0 4.5248785500452633e-07 0 4.5249785500452634e-07 0.00021 4.5250785500452635e-07 0 4.5250785500452635e-07 0 4.5251785500452636e-07 0.00021 4.525278550045264e-07 0 4.525611023667465e-07 0 4.5257110236674653e-07 0.00021 4.5258110236674655e-07 0 4.5262695943291296e-07 0 4.5263695943291297e-07 0.00021 4.52646959432913e-07 0 4.52646959432913e-07 0 4.52656959432913e-07 0.00021 4.52666959432913e-07 0 4.526854782203672e-07 0 4.526954782203672e-07 0.00021 4.527054782203672e-07 0 4.527185901080231e-07 0 4.527285901080231e-07 0.00021 4.527385901080231e-07 0 4.527385901080231e-07 0 4.527485901080231e-07 0.00021 4.527585901080231e-07 0 4.528132928627558e-07 0 4.528232928627558e-07 0.00021 4.5283329286275583e-07 0 4.528709228507495e-07 0 4.528809228507495e-07 0.00021 4.528909228507495e-07 0 4.529406902685369e-07 0 4.529506902685369e-07 0.00021 4.5296069026853694e-07 0 4.5298636588370485e-07 0 4.5299636588370486e-07 0.00021 4.5300636588370487e-07 0 4.530240610427131e-07 0 4.530340610427131e-07 0.00021 4.530440610427131e-07 0 4.530728333915581e-07 0 4.530828333915581e-07 0.00021 4.5309283339155813e-07 0 4.531048948213058e-07 0 4.5311489482130583e-07 0.00021 4.5312489482130585e-07 0 4.5315953966792644e-07 0 4.5316953966792645e-07 0.00021 4.5317953966792646e-07 0 4.5317953966792646e-07 0 4.5318953966792647e-07 0.00021 4.531995396679265e-07 0 4.532230895788026e-07 0 4.532330895788026e-07 0.00021 4.5324308957880264e-07 0 4.5324308957880264e-07 0 4.5325308957880265e-07 0.00021 4.5326308957880266e-07 0 4.532838366301931e-07 0 4.532938366301931e-07 0.00021 4.533038366301931e-07 0 4.5335457132075e-07 0 4.5336457132075003e-07 0.00021 4.5337457132075004e-07 0 4.534641450098438e-07 0 4.534741450098438e-07 0.00021 4.534841450098438e-07 0 4.5351631641220067e-07 0 4.535263164122007e-07 0.00021 4.535363164122007e-07 0 4.5354103018213787e-07 0 4.535510301821379e-07 0.00021 4.535610301821379e-07 0 4.535610301821379e-07 0 4.535710301821379e-07 0.00021 4.535810301821379e-07 0 4.535810301821379e-07 0 4.535910301821379e-07 0.00021 4.5360103018213793e-07 0 4.5360103018213793e-07 0 4.5361103018213795e-07 0.00021 4.5362103018213796e-07 0 4.5362103018213796e-07 0 4.5363103018213797e-07 0.00021 4.53641030182138e-07 0 4.5365295847201565e-07 0 4.5366295847201566e-07 0.00021 4.5367295847201567e-07 0 4.5367295847201567e-07 0 4.536829584720157e-07 0.00021 4.536929584720157e-07 0 4.536929584720157e-07 0 4.537029584720157e-07 0.00021 4.537129584720157e-07 0 4.537129584720157e-07 0 4.537229584720157e-07 0.00021 4.5373295847201574e-07 0 4.537403289501119e-07 0 4.537503289501119e-07 0.00021 4.537603289501119e-07 0 4.537603289501119e-07 0 4.537703289501119e-07 0.00021 4.5378032895011194e-07 0 4.5378032895011194e-07 0 4.5379032895011195e-07 0.00021 4.5380032895011196e-07 0 4.5380032895011196e-07 0 4.5381032895011197e-07 0.00021 4.53820328950112e-07 0 4.53820328950112e-07 0 4.53830328950112e-07 0.00021 4.53840328950112e-07 0 4.53840328950112e-07 0 4.53850328950112e-07 0.00021 4.5386032895011203e-07 0 4.5390283621999095e-07 0 4.5391283621999096e-07 0.00021 4.5392283621999097e-07 0 4.5394620518455356e-07 0 4.5395620518455357e-07 0.00021 4.539662051845536e-07 0 4.540287917748039e-07 0 4.540387917748039e-07 0.00021 4.5404879177480393e-07 0 4.54100095579229e-07 0 4.5411009557922904e-07 0.00021 4.5412009557922905e-07 0 4.541448863012805e-07 0 4.5415488630128053e-07 0.00021 4.5416488630128054e-07 0 4.5416488630128054e-07 0 4.5417488630128055e-07 0.00021 4.5418488630128056e-07 0 4.5418488630128056e-07 0 4.541948863012806e-07 0.00021 4.542048863012806e-07 0 4.543016594742835e-07 0 4.5431165947428353e-07 0.00021 4.5432165947428354e-07 0 4.5433141690034173e-07 0 4.5434141690034174e-07 0.00021 4.5435141690034175e-07 0 4.5442386738177036e-07 0 4.544338673817704e-07 0.00021 4.544438673817704e-07 0 4.544438673817704e-07 0 4.544538673817704e-07 0.00021 4.544638673817704e-07 0 4.544638673817704e-07 0 4.544738673817704e-07 0.00021 4.5448386738177043e-07 0 4.5448386738177043e-07 0 4.5449386738177044e-07 0.00021 4.5450386738177045e-07 0 4.5450386738177045e-07 0 4.5451386738177046e-07 0.00021 4.545238673817705e-07 0 4.545238673817705e-07 0 4.545338673817705e-07 0.00021 4.545438673817705e-07 0 4.545438673817705e-07 0 4.545538673817705e-07 0.00021 4.545638673817705e-07 0 4.545638673817705e-07 0 4.5457386738177053e-07 0.00021 4.5458386738177054e-07 0 4.546132732610703e-07 0 4.546232732610703e-07 0.00021 4.5463327326107033e-07 0 4.5465807535459894e-07 0 4.5466807535459895e-07 0.00021 4.5467807535459896e-07 0 4.547511473024952e-07 0 4.547611473024952e-07 0.00021 4.5477114730249523e-07 0 4.5477114730249523e-07 0 4.5478114730249524e-07 0.00021 4.5479114730249525e-07 0 4.5479114730249525e-07 0 4.5480114730249527e-07 0.00021 4.548111473024953e-07 0 4.5485914101851587e-07 0 4.548691410185159e-07 0.00021 4.548791410185159e-07 0 4.549269147211402e-07 0 4.549369147211402e-07 0.00021 4.549469147211402e-07 0 4.549983917145483e-07 0 4.550083917145483e-07 0.00021 4.550183917145483e-07 0 4.5505386098764313e-07 0 4.5506386098764314e-07 0.00021 4.5507386098764315e-07 0 4.5511698644064617e-07 0 4.551269864406462e-07 0.00021 4.551369864406462e-07 0 4.5514488593704706e-07 0 4.5515488593704707e-07 0.00021 4.551648859370471e-07 0 4.551648859370471e-07 0 4.551748859370471e-07 0.00021 4.551848859370471e-07 0 4.551848859370471e-07 0 4.551948859370471e-07 0.00021 4.552048859370471e-07 0 4.552068539061137e-07 0 4.552168539061137e-07 0.00021 4.552268539061137e-07 0 4.5528110714449305e-07 0 4.5529110714449306e-07 0.00021 4.553011071444931e-07 0 4.553011071444931e-07 0 4.553111071444931e-07 0.00021 4.553211071444931e-07 0 4.553465768221482e-07 0 4.553565768221482e-07 0.00021 4.5536657682214823e-07 0 4.5536657682214823e-07 0 4.5537657682214824e-07 0.00021 4.5538657682214825e-07 0 4.5538657682214825e-07 0 4.5539657682214827e-07 0.00021 4.554065768221483e-07 0 4.554065768221483e-07 0 4.554165768221483e-07 0.00021 4.554265768221483e-07 0 4.554265768221483e-07 0 4.554365768221483e-07 0.00021 4.554465768221483e-07 0 4.554465768221483e-07 0 4.5545657682214833e-07 0.00021 4.5546657682214835e-07 0 4.5546657682214835e-07 0 4.5547657682214836e-07 0.00021 4.5548657682214837e-07 0 4.5548657682214837e-07 0 4.554965768221484e-07 0.00021 4.555065768221484e-07 0 4.555065768221484e-07 0 4.555165768221484e-07 0.00021 4.555265768221484e-07 0 4.555265768221484e-07 0 4.555365768221484e-07 0.00021 4.5554657682214844e-07 0 4.555694557358987e-07 0 4.555794557358987e-07 0.00021 4.5558945573589873e-07 0 4.556308482688302e-07 0 4.5564084826883023e-07 0.00021 4.5565084826883024e-07 0 4.5572647929618726e-07 0 4.5573647929618727e-07 0.00021 4.557464792961873e-07 0 4.557749011522251e-07 0 4.557849011522251e-07 0.00021 4.5579490115222513e-07 0 4.5579490115222513e-07 0 4.5580490115222514e-07 0.00021 4.5581490115222516e-07 0 4.558411561957252e-07 0 4.5585115619572523e-07 0.00021 4.5586115619572524e-07 0 4.5586115619572524e-07 0 4.5587115619572526e-07 0.00021 4.5588115619572527e-07 0 4.5601083594612217e-07 0 4.560208359461222e-07 0.00021 4.560308359461222e-07 0 4.5603583538091085e-07 0 4.5604583538091087e-07 0.00021 4.560558353809109e-07 0 4.560558353809109e-07 0 4.560658353809109e-07 0.00021 4.560758353809109e-07 0 4.5613534325319085e-07 0 4.5614534325319087e-07 0.00021 4.561553432531909e-07 0 4.561553432531909e-07 0 4.561653432531909e-07 0.00021 4.561753432531909e-07 0 4.561753432531909e-07 0 4.561853432531909e-07 0.00021 4.561953432531909e-07 0 4.561953432531909e-07 0 4.5620534325319093e-07 0.00021 4.5621534325319095e-07 0 4.5621534325319095e-07 0 4.5622534325319096e-07 0.00021 4.5623534325319097e-07 0 4.5623534325319097e-07 0 4.56245343253191e-07 0.00021 4.56255343253191e-07 0 4.56255343253191e-07 0 4.56265343253191e-07 0.00021 4.56275343253191e-07 0 4.56275343253191e-07 0 4.56285343253191e-07 0.00021 4.5629534325319104e-07 0 4.5629534325319104e-07 0 4.5630534325319105e-07 0.00021 4.5631534325319106e-07 0 4.5631534325319106e-07 0 4.5632534325319107e-07 0.00021 4.563353432531911e-07 0 4.563353432531911e-07 0 4.563453432531911e-07 0.00021 4.563553432531911e-07 0 4.563553432531911e-07 0 4.563653432531911e-07 0.00021 4.5637534325319113e-07 0 4.5637534325319113e-07 0 4.5638534325319114e-07 0.00021 4.5639534325319115e-07 0 4.564098917292875e-07 0 4.564198917292875e-07 0.00021 4.564298917292875e-07 0 4.564298917292875e-07 0 4.5643989172928754e-07 0.00021 4.5644989172928755e-07 0 4.5644989172928755e-07 0 4.5645989172928756e-07 0.00021 4.5646989172928757e-07 0 4.565077040490276e-07 0 4.565177040490276e-07 0.00021 4.565277040490276e-07 0 4.565277040490276e-07 0 4.565377040490276e-07 0.00021 4.565477040490276e-07 0 4.565477040490276e-07 0 4.5655770404902763e-07 0.00021 4.5656770404902764e-07 0 4.5656770404902764e-07 0 4.5657770404902766e-07 0.00021 4.5658770404902767e-07 0 4.5658770404902767e-07 0 4.565977040490277e-07 0.00021 4.566077040490277e-07 0 4.566653294450618e-07 0 4.566753294450618e-07 0.00021 4.566853294450618e-07 0 4.566853294450618e-07 0 4.566953294450618e-07 0.00021 4.5670532944506183e-07 0 4.5670532944506183e-07 0 4.5671532944506184e-07 0.00021 4.5672532944506185e-07 0 4.5672532944506185e-07 0 4.5673532944506186e-07 0.00021 4.567453294450619e-07 0 4.567453294450619e-07 0 4.567553294450619e-07 0.00021 4.567653294450619e-07 0 4.567653294450619e-07 0 4.567753294450619e-07 0.00021 4.567853294450619e-07 0 4.568043278531621e-07 0 4.5681432785316213e-07 0.00021 4.5682432785316214e-07 0 4.5683355493537787e-07 0 4.568435549353779e-07 0.00021 4.568535549353779e-07 0 4.569102054021303e-07 0 4.569202054021303e-07 0.00021 4.569302054021303e-07 0 4.569302054021303e-07 0 4.5694020540213034e-07 0.00021 4.5695020540213035e-07 0 4.5695020540213035e-07 0 4.5696020540213036e-07 0.00021 4.5697020540213037e-07 0 4.5697020540213037e-07 0 4.569802054021304e-07 0.00021 4.569902054021304e-07 0 4.569902054021304e-07 0 4.570002054021304e-07 0.00021 4.570102054021304e-07 0 4.5710087432955694e-07 0 4.5711087432955695e-07 0.00021 4.5712087432955696e-07 0 4.5712087432955696e-07 0 4.5713087432955697e-07 0.00021 4.57140874329557e-07 0 4.57140874329557e-07 0 4.57150874329557e-07 0.00021 4.57160874329557e-07 0 4.5719739842584727e-07 0 4.572073984258473e-07 0.00021 4.572173984258473e-07 0 4.572173984258473e-07 0 4.572273984258473e-07 0.00021 4.572373984258473e-07 0 4.572373984258473e-07 0 4.5724739842584733e-07 0.00021 4.5725739842584734e-07 0 4.5726572722709157e-07 0 4.572757272270916e-07 0.00021 4.572857272270916e-07 0 4.573266581147328e-07 0 4.5733665811473283e-07 0.00021 4.5734665811473284e-07 0 4.5737831840274026e-07 0 4.5738831840274027e-07 0.00021 4.573983184027403e-07 0 4.573983184027403e-07 0 4.574083184027403e-07 0.00021 4.574183184027403e-07 0 4.5743478160479637e-07 0 4.574447816047964e-07 0.00021 4.574547816047964e-07 0 4.574675474821869e-07 0 4.574775474821869e-07 0.00021 4.574875474821869e-07 0 4.574983721082251e-07 0 4.5750837210822513e-07 0.00021 4.5751837210822514e-07 0 4.575660758618889e-07 0 4.575760758618889e-07 0.00021 4.575860758618889e-07 0 4.575860758618889e-07 0 4.575960758618889e-07 0.00021 4.5760607586188893e-07 0 4.5760607586188893e-07 0 4.5761607586188895e-07 0.00021 4.5762607586188896e-07 0 4.5762607586188896e-07 0 4.5763607586188897e-07 0.00021 4.57646075861889e-07 0 4.57646075861889e-07 0 4.57656075861889e-07 0.00021 4.57666075861889e-07 0 4.57670179740033e-07 0 4.57680179740033e-07 0.00021 4.57690179740033e-07 0 4.576950658059157e-07 0 4.577050658059157e-07 0.00021 4.5771506580591573e-07 0 4.577474384468716e-07 0 4.577574384468716e-07 0.00021 4.5776743844687163e-07 0 4.5776743844687163e-07 0 4.5777743844687164e-07 0.00021 4.5778743844687166e-07 0 4.578023039882275e-07 0 4.578123039882275e-07 0.00021 4.578223039882275e-07 0 4.578223039882275e-07 0 4.578323039882275e-07 0.00021 4.5784230398822753e-07 0 4.5784230398822753e-07 0 4.5785230398822755e-07 0.00021 4.5786230398822756e-07 0 4.5786230398822756e-07 0 4.5787230398822757e-07 0.00021 4.578823039882276e-07 0 4.578870790405434e-07 0 4.5789707904054343e-07 0.00021 4.5790707904054344e-07 0 4.5790707904054344e-07 0 4.5791707904054345e-07 0.00021 4.5792707904054346e-07 0 4.5795216211296683e-07 0 4.5796216211296684e-07 0.00021 4.5797216211296685e-07 0 4.5798422250219815e-07 0 4.5799422250219816e-07 0.00021 4.5800422250219817e-07 0 4.5814150849524414e-07 0 4.5815150849524415e-07 0.00021 4.5816150849524416e-07 0 4.5816150849524416e-07 0 4.5817150849524417e-07 0.00021 4.581815084952442e-07 0 4.5819872779487615e-07 0 4.5820872779487617e-07 0.00021 4.582187277948762e-07 0 4.5821928782171195e-07 0 4.5822928782171196e-07 0.00021 4.5823928782171197e-07 0 4.5840731423737694e-07 0 4.5841731423737696e-07 0.00021 4.5842731423737697e-07 0 4.5842731423737697e-07 0 4.58437314237377e-07 0.00021 4.58447314237377e-07 0 4.5844832554915686e-07 0 4.5845832554915687e-07 0.00021 4.584683255491569e-07 0 4.584683255491569e-07 0 4.584783255491569e-07 0.00021 4.584883255491569e-07 0 4.584883255491569e-07 0 4.584983255491569e-07 0.00021 4.5850832554915693e-07 0 4.5850832554915693e-07 0 4.5851832554915694e-07 0.00021 4.5852832554915695e-07 0 4.5852832554915695e-07 0 4.5853832554915696e-07 0.00021 4.58548325549157e-07 0 4.58548325549157e-07 0 4.58558325549157e-07 0.00021 4.58568325549157e-07 0 4.58568325549157e-07 0 4.58578325549157e-07 0.00021 4.58588325549157e-07 0 4.586646912157052e-07 0 4.586746912157052e-07 0.00021 4.586846912157052e-07 0 4.586846912157052e-07 0 4.586946912157052e-07 0.00021 4.587046912157052e-07 0 4.587046912157052e-07 0 4.5871469121570523e-07 0.00021 4.5872469121570524e-07 0 4.5881499768765394e-07 0 4.5882499768765395e-07 0.00021 4.5883499768765397e-07 0 4.5883499768765397e-07 0 4.58844997687654e-07 0.00021 4.58854997687654e-07 0 4.58854997687654e-07 0 4.58864997687654e-07 0.00021 4.58874997687654e-07 0 4.58874997687654e-07 0 4.58884997687654e-07 0.00021 4.5889499768765403e-07 0 4.5889499768765403e-07 0 4.5890499768765404e-07 0.00021 4.5891499768765406e-07 0 4.5891499768765406e-07 0 4.5892499768765407e-07 0.00021 4.589349976876541e-07 0 4.589349976876541e-07 0 4.589449976876541e-07 0.00021 4.589549976876541e-07 0 4.589549976876541e-07 0 4.589649976876541e-07 0.00021 4.589749976876541e-07 0 4.589749976876541e-07 0 4.5898499768765414e-07 0.00021 4.5899499768765415e-07 0 4.5899499768765415e-07 0 4.5900499768765416e-07 0.00021 4.5901499768765417e-07 0 4.590316931235218e-07 0 4.590416931235218e-07 0.00021 4.5905169312352183e-07 0 4.590812644614883e-07 0 4.590912644614883e-07 0.00021 4.5910126446148833e-07 0 4.5910126446148833e-07 0 4.5911126446148834e-07 0.00021 4.5912126446148836e-07 0 4.5912126446148836e-07 0 4.5913126446148837e-07 0.00021 4.591412644614884e-07 0 4.5916184636860906e-07 0 4.5917184636860907e-07 0.00021 4.591818463686091e-07 0 4.591818463686091e-07 0 4.591918463686091e-07 0.00021 4.592018463686091e-07 0 4.592018463686091e-07 0 4.592118463686091e-07 0.00021 4.5922184636860913e-07 0 4.5922184636860913e-07 0 4.5923184636860914e-07 0.00021 4.5924184636860915e-07 0 4.5927879511082467e-07 0 4.592887951108247e-07 0.00021 4.592987951108247e-07 0 4.592987951108247e-07 0 4.593087951108247e-07 0.00021 4.593187951108247e-07 0 4.593187951108247e-07 0 4.593287951108247e-07 0.00021 4.5933879511082474e-07 0 4.5933879511082474e-07 0 4.5934879511082475e-07 0.00021 4.5935879511082476e-07 0 4.5935879511082476e-07 0 4.5936879511082477e-07 0.00021 4.593787951108248e-07 0 4.5937959093642803e-07 0 4.5938959093642804e-07 0.00021 4.5939959093642806e-07 0 4.5939959093642806e-07 0 4.5940959093642807e-07 0.00021 4.594195909364281e-07 0 4.5942585471968935e-07 0 4.5943585471968936e-07 0.00021 4.594458547196894e-07 0 4.594803984368726e-07 0 4.594903984368726e-07 0.00021 4.595003984368726e-07 0 4.5951247287520345e-07 0 4.5952247287520346e-07 0.00021 4.5953247287520347e-07 0 4.5955256627438515e-07 0 4.5956256627438516e-07 0.00021 4.595725662743852e-07 0 4.596903547667573e-07 0 4.597003547667573e-07 0.00021 4.597103547667573e-07 0 4.597990409561474e-07 0 4.598090409561474e-07 0.00021 4.598190409561474e-07 0 4.5986911820129895e-07 0 4.5987911820129896e-07 0.00021 4.5988911820129897e-07 0 4.5988911820129897e-07 0 4.59899118201299e-07 0.00021 4.59909118201299e-07 0 4.5993150105396813e-07 0 4.5994150105396814e-07 0.00021 4.5995150105396815e-07 0 4.5996014630760377e-07 0 4.599701463076038e-07 0.00021 4.599801463076038e-07 0 4.599918051881673e-07 0 4.6000180518816734e-07 0.00021 4.6001180518816735e-07 0 4.600601320939993e-07 0 4.600701320939993e-07 0.00021 4.600801320939993e-07 0 4.601263915205505e-07 0 4.6013639152055053e-07 0.00021 4.6014639152055054e-07 0 4.6014639152055054e-07 0 4.6015639152055055e-07 0.00021 4.6016639152055056e-07 0 4.6016639152055056e-07 0 4.601763915205506e-07 0.00021 4.601863915205506e-07 0 4.6022398406379373e-07 0 4.6023398406379374e-07 0.00021 4.6024398406379375e-07 0 4.6024398406379375e-07 0 4.6025398406379377e-07 0.00021 4.602639840637938e-07 0 4.602639840637938e-07 0 4.602739840637938e-07 0.00021 4.602839840637938e-07 0 4.602929167019021e-07 0 4.603029167019021e-07 0.00021 4.603129167019021e-07 0 4.603129167019021e-07 0 4.6032291670190214e-07 0.00021 4.6033291670190215e-07 0 4.6036577060817944e-07 0 4.6037577060817946e-07 0.00021 4.6038577060817947e-07 0 4.604465871547964e-07 0 4.604565871547964e-07 0.00021 4.6046658715479644e-07 0 4.60478470871777e-07 0 4.6048847087177703e-07 0.00021 4.6049847087177704e-07 0 4.6051518128684325e-07 0 4.6052518128684326e-07 0.00021 4.6053518128684327e-07 0 4.6053518128684327e-07 0 4.605451812868433e-07 0.00021 4.605551812868433e-07 0 4.6062930275054036e-07 0 4.6063930275054037e-07 0.00021 4.606493027505404e-07 0 4.606493027505404e-07 0 4.606593027505404e-07 0.00021 4.606693027505404e-07 0 4.60684336564776e-07 0 4.6069433656477604e-07 0.00021 4.6070433656477605e-07 0 4.6070433656477605e-07 0 4.6071433656477606e-07 0.00021 4.6072433656477607e-07 0 4.6072433656477607e-07 0 4.607343365647761e-07 0.00021 4.607443365647761e-07 0 4.607461751025863e-07 0 4.6075617510258633e-07 0.00021 4.6076617510258634e-07 0 4.6076617510258634e-07 0 4.6077617510258635e-07 0.00021 4.6078617510258636e-07 0 4.6078617510258636e-07 0 4.607961751025864e-07 0.00021 4.608061751025864e-07 0 4.608061751025864e-07 0 4.608161751025864e-07 0.00021 4.608261751025864e-07 0 4.608261751025864e-07 0 4.608361751025864e-07 0.00021 4.6084617510258643e-07 0 4.6084617510258643e-07 0 4.6085617510258644e-07 0.00021 4.6086617510258646e-07 0 4.608760815285637e-07 0 4.608860815285637e-07 0.00021 4.6089608152856373e-07 0 4.6090708641586753e-07 0 4.6091708641586755e-07 0.00021 4.6092708641586756e-07 0 4.6093990001487734e-07 0 4.6094990001487736e-07 0.00021 4.6095990001487737e-07 0 4.6095990001487737e-07 0 4.609699000148774e-07 0.00021 4.609799000148774e-07 0 4.609799000148774e-07 0 4.609899000148774e-07 0.00021 4.609999000148774e-07 0 4.6100330745696463e-07 0 4.6101330745696464e-07 0.00021 4.6102330745696465e-07 0 4.6102403617628546e-07 0 4.6103403617628547e-07 0.00021 4.610440361762855e-07 0 4.6111050163941913e-07 0 4.6112050163941914e-07 0.00021 4.6113050163941915e-07 0 4.611756565765609e-07 0 4.611856565765609e-07 0.00021 4.611956565765609e-07 0 4.6119766454112326e-07 0 4.612076645411233e-07 0.00021 4.612176645411233e-07 0 4.612176645411233e-07 0 4.612276645411233e-07 0.00021 4.612376645411233e-07 0 4.613101737740561e-07 0 4.6132017377405613e-07 0.00021 4.6133017377405614e-07 0 4.6133017377405614e-07 0 4.6134017377405615e-07 0.00021 4.6135017377405617e-07 0 4.6135017377405617e-07 0 4.613601737740562e-07 0.00021 4.613701737740562e-07 0 4.613701737740562e-07 0 4.613801737740562e-07 0.00021 4.613901737740562e-07 0 4.6141122267132325e-07 0 4.6142122267132327e-07 0.00021 4.614312226713233e-07 0 4.614312226713233e-07 0 4.614412226713233e-07 0.00021 4.614512226713233e-07 0 4.615345502114661e-07 0 4.615445502114661e-07 0.00021 4.615545502114661e-07 0 4.615545502114661e-07 0 4.615645502114661e-07 0.00021 4.6157455021146613e-07 0 4.6157455021146613e-07 0 4.6158455021146614e-07 0.00021 4.6159455021146615e-07 0 4.6159455021146615e-07 0 4.6160455021146616e-07 0.00021 4.6161455021146617e-07 0 4.6161494765815817e-07 0 4.616249476581582e-07 0.00021 4.616349476581582e-07 0 4.6166589511845196e-07 0 4.6167589511845197e-07 0.00021 4.61685895118452e-07 0 4.617106482732317e-07 0 4.617206482732317e-07 0.00021 4.617306482732317e-07 0 4.617306482732317e-07 0 4.6174064827323173e-07 0.00021 4.6175064827323174e-07 0 4.618218467091586e-07 0 4.618318467091586e-07 0.00021 4.618418467091586e-07 0 4.618418467091586e-07 0 4.6185184670915864e-07 0.00021 4.6186184670915865e-07 0 4.6186184670915865e-07 0 4.6187184670915866e-07 0.00021 4.6188184670915867e-07 0 4.618849207887602e-07 0 4.618949207887602e-07 0.00021 4.6190492078876024e-07 0 4.6192991924779894e-07 0 4.6193991924779895e-07 0.00021 4.6194991924779896e-07 0 4.619579694915846e-07 0 4.619679694915846e-07 0.00021 4.619779694915846e-07 0 4.619779694915846e-07 0 4.6198796949158464e-07 0.00021 4.6199796949158465e-07 0 4.6199796949158465e-07 0 4.6200796949158466e-07 0.00021 4.6201796949158467e-07 0 4.620249523176745e-07 0 4.620349523176745e-07 0.00021 4.620449523176745e-07 0 4.6207343841816983e-07 0 4.6208343841816984e-07 0.00021 4.6209343841816985e-07 0 4.6216315131974276e-07 0 4.6217315131974277e-07 0.00021 4.621831513197428e-07 0 4.621831513197428e-07 0 4.621931513197428e-07 0.00021 4.622031513197428e-07 0 4.622031513197428e-07 0 4.622131513197428e-07 0.00021 4.6222315131974283e-07 0 4.6228184254292524e-07 0 4.6229184254292525e-07 0.00021 4.6230184254292526e-07 0 4.623421227275415e-07 0 4.623521227275415e-07 0.00021 4.623621227275415e-07 0 4.6236377159238614e-07 0 4.6237377159238615e-07 0.00021 4.6238377159238616e-07 0 4.6239354587047807e-07 0 4.624035458704781e-07 0.00021 4.624135458704781e-07 0 4.624333721042781e-07 0 4.6244337210427813e-07 0.00021 4.6245337210427814e-07 0 4.6245337210427814e-07 0 4.6246337210427815e-07 0.00021 4.6247337210427816e-07 0 4.6249318615897916e-07 0 4.6250318615897917e-07 0.00021 4.625131861589792e-07 0 4.625131861589792e-07 0 4.625231861589792e-07 0.00021 4.625331861589792e-07 0 4.625331861589792e-07 0 4.625431861589792e-07 0.00021 4.6255318615897923e-07 0 4.626019877007548e-07 0 4.626119877007548e-07 0.00021 4.626219877007548e-07 0 4.626246737024065e-07 0 4.6263467370240654e-07 0.00021 4.6264467370240655e-07 0 4.626563570575027e-07 0 4.626663570575027e-07 0.00021 4.626763570575027e-07 0 4.6271550490514147e-07 0 4.627255049051415e-07 0.00021 4.627355049051415e-07 0 4.627355049051415e-07 0 4.627455049051415e-07 0.00021 4.627555049051415e-07 0 4.627631503825267e-07 0 4.627731503825267e-07 0.00021 4.627831503825267e-07 0 4.6287378977219875e-07 0 4.6288378977219876e-07 0.00021 4.6289378977219877e-07 0 4.6289395636641125e-07 0 4.6290395636641126e-07 0.00021 4.6291395636641127e-07 0 4.6291869366351753e-07 0 4.6292869366351754e-07 0.00021 4.6293869366351755e-07 0 4.6293869366351755e-07 0 4.6294869366351756e-07 0.00021 4.629586936635176e-07 0 4.630068697616767e-07 0 4.630168697616767e-07 0.00021 4.630268697616767e-07 0 4.631563740515423e-07 0 4.631663740515423e-07 0.00021 4.631763740515423e-07 0 4.631821409992821e-07 0 4.6319214099928213e-07 0.00021 4.6320214099928214e-07 0 4.632292427610186e-07 0 4.632392427610186e-07 0.00021 4.6324924276101863e-07 0 4.633108896670538e-07 0 4.633208896670538e-07 0.00021 4.633308896670538e-07 0 4.633308896670538e-07 0 4.633408896670538e-07 0.00021 4.633508896670538e-07 0 4.633508896670538e-07 0 4.6336088966705383e-07 0.00021 4.6337088966705385e-07 0 4.6337088966705385e-07 0 4.6338088966705386e-07 0.00021 4.6339088966705387e-07 0 4.6343375615202466e-07 0 4.6344375615202467e-07 0.00021 4.634537561520247e-07 0 4.634537561520247e-07 0 4.634637561520247e-07 0.00021 4.634737561520247e-07 0 4.634737561520247e-07 0 4.634837561520247e-07 0.00021 4.6349375615202473e-07 0 4.634959933437868e-07 0 4.635059933437868e-07 0.00021 4.6351599334378683e-07 0 4.6351599334378683e-07 0 4.6352599334378684e-07 0.00021 4.6353599334378685e-07 0 4.6361350144900126e-07 0 4.6362350144900127e-07 0.00021 4.636335014490013e-07 0 4.6368289773006644e-07 0 4.6369289773006645e-07 0.00021 4.6370289773006646e-07 0 4.637319635927171e-07 0 4.637419635927171e-07 0.00021 4.637519635927171e-07 0 4.6377025734759517e-07 0 4.637802573475952e-07 0.00021 4.637902573475952e-07 0 4.6384317371436453e-07 0 4.6385317371436454e-07 0.00021 4.6386317371436455e-07 0 4.6386317371436455e-07 0 4.6387317371436457e-07 0.00021 4.638831737143646e-07 0 4.638831737143646e-07 0 4.638931737143646e-07 0.00021 4.639031737143646e-07 0 4.6391947463486616e-07 0 4.6392947463486617e-07 0.00021 4.639394746348662e-07 0 4.639563518910761e-07 0 4.639663518910761e-07 0.00021 4.639763518910761e-07 0 4.639763518910761e-07 0 4.6398635189107613e-07 0.00021 4.6399635189107614e-07 0 4.640204611770397e-07 0 4.640304611770397e-07 0.00021 4.6404046117703973e-07 0 4.6404046117703973e-07 0 4.6405046117703974e-07 0.00021 4.6406046117703975e-07 0 4.6406046117703975e-07 0 4.6407046117703976e-07 0.00021 4.640804611770398e-07 0 4.640804611770398e-07 0 4.640904611770398e-07 0.00021 4.641004611770398e-07 0 4.641004611770398e-07 0 4.641104611770398e-07 0.00021 4.641204611770398e-07 0 4.641204611770398e-07 0 4.6413046117703983e-07 0.00021 4.6414046117703984e-07 0 4.6414046117703984e-07 0 4.6415046117703985e-07 0.00021 4.6416046117703987e-07 0 4.6416046117703987e-07 0 4.641704611770399e-07 0.00021 4.641804611770399e-07 0 4.641992328101264e-07 0 4.642092328101264e-07 0.00021 4.6421923281012643e-07 0 4.6421923281012643e-07 0 4.6422923281012644e-07 0.00021 4.6423923281012645e-07 0 4.6423923281012645e-07 0 4.6424923281012646e-07 0.00021 4.642592328101265e-07 0 4.642592328101265e-07 0 4.642692328101265e-07 0.00021 4.642792328101265e-07 0 4.643121931606379e-07 0 4.643221931606379e-07 0.00021 4.6433219316063794e-07 0 4.6433219316063794e-07 0 4.6434219316063795e-07 0.00021 4.6435219316063796e-07 0 4.6435219316063796e-07 0 4.6436219316063797e-07 0.00021 4.64372193160638e-07 0 4.6439599186701934e-07 0 4.6440599186701935e-07 0.00021 4.6441599186701937e-07 0 4.6441599186701937e-07 0 4.644259918670194e-07 0.00021 4.644359918670194e-07 0 4.6445788855467056e-07 0 4.6446788855467057e-07 0.00021 4.644778885546706e-07 0 4.6452569376466067e-07 0 4.645356937646607e-07 0.00021 4.645456937646607e-07 0 4.645529993032969e-07 0 4.6456299930329693e-07 0.00021 4.6457299930329694e-07 0 4.6457299930329694e-07 0 4.6458299930329695e-07 0.00021 4.6459299930329696e-07 0 4.6459299930329696e-07 0 4.6460299930329697e-07 0.00021 4.64612999303297e-07 0 4.64612999303297e-07 0 4.64622999303297e-07 0.00021 4.64632999303297e-07 0 4.64632999303297e-07 0 4.64642999303297e-07 0.00021 4.6465299930329703e-07 0 4.6465299930329703e-07 0 4.6466299930329704e-07 0.00021 4.6467299930329705e-07 0 4.648305754478449e-07 0 4.648405754478449e-07 0.00021 4.648505754478449e-07 0 4.649270381136494e-07 0 4.649370381136494e-07 0.00021 4.649470381136494e-07 0 4.649470381136494e-07 0 4.6495703811364943e-07 0.00021 4.6496703811364944e-07 0 4.6496703811364944e-07 0 4.6497703811364946e-07 0.00021 4.6498703811364947e-07 0 4.6498703811364947e-07 0 4.649970381136495e-07 0.00021 4.650070381136495e-07 0 4.650070381136495e-07 0 4.650170381136495e-07 0.00021 4.650270381136495e-07 0 4.650270381136495e-07 0 4.650370381136495e-07 0.00021 4.6504703811364953e-07 0 4.6504703811364953e-07 0 4.6505703811364955e-07 0.00021 4.6506703811364956e-07 0 4.6506703811364956e-07 0 4.6507703811364957e-07 0.00021 4.650870381136496e-07 0 4.650870381136496e-07 0 4.650970381136496e-07 0.00021 4.651070381136496e-07 0 4.6513261139474846e-07 0 4.6514261139474847e-07 0.00021 4.651526113947485e-07 0 4.651526113947485e-07 0 4.651626113947485e-07 0.00021 4.651726113947485e-07 0 4.651726113947485e-07 0 4.651826113947485e-07 0.00021 4.6519261139474853e-07 0 4.6519740064475285e-07 0 4.6520740064475286e-07 0.00021 4.652174006447529e-07 0 4.6531783500338974e-07 0 4.6532783500338975e-07 0.00021 4.6533783500338976e-07 0 4.6533783500338976e-07 0 4.653478350033898e-07 0.00021 4.653578350033898e-07 0 4.6542686512132504e-07 0 4.6543686512132506e-07 0.00021 4.6544686512132507e-07 0 4.65458373430721e-07 0 4.65468373430721e-07 0.00021 4.65478373430721e-07 0 4.65478373430721e-07 0 4.65488373430721e-07 0.00021 4.65498373430721e-07 0 4.6550010634801904e-07 0 4.6551010634801906e-07 0.00021 4.6552010634801907e-07 0 4.6555125753440155e-07 0 4.6556125753440156e-07 0.00021 4.6557125753440157e-07 0 4.6557631766237463e-07 0 4.6558631766237464e-07 0.00021 4.6559631766237465e-07 0 4.6560043884579145e-07 0 4.6561043884579146e-07 0.00021 4.6562043884579147e-07 0 4.6562967586751437e-07 0 4.656396758675144e-07 0.00021 4.656496758675144e-07 0 4.657841988453902e-07 0 4.657941988453902e-07 0.00021 4.658041988453902e-07 0 4.658041988453902e-07 0 4.6581419884539023e-07 0.00021 4.6582419884539024e-07 0 4.6582419884539024e-07 0 4.6583419884539025e-07 0.00021 4.6584419884539026e-07 0 4.658925661236059e-07 0 4.6590256612360593e-07 0.00021 4.6591256612360594e-07 0 4.6592054450211117e-07 0 4.659305445021112e-07 0.00021 4.659405445021112e-07 0 4.659405445021112e-07 0 4.659505445021112e-07 0.00021 4.659605445021112e-07 0 4.6599545824925464e-07 0 4.6600545824925465e-07 0.00021 4.6601545824925467e-07 0 4.660761114269879e-07 0 4.660861114269879e-07 0.00021 4.6609611142698793e-07 0 4.6610188692046555e-07 0 4.6611188692046556e-07 0.00021 4.661218869204656e-07 0 4.661218869204656e-07 0 4.661318869204656e-07 0.00021 4.661418869204656e-07 0 4.6616071332395594e-07 0 4.6617071332395595e-07 0.00021 4.6618071332395596e-07 0 4.6628292734371373e-07 0 4.6629292734371375e-07 0.00021 4.6630292734371376e-07 0 4.6630292734371376e-07 0 4.6631292734371377e-07 0.00021 4.663229273437138e-07 0 4.6638230298435415e-07 0 4.6639230298435416e-07 0.00021 4.664023029843542e-07 0 4.664556979779886e-07 0 4.664656979779886e-07 0.00021 4.664756979779886e-07 0 4.665004639747679e-07 0 4.665104639747679e-07 0.00021 4.665204639747679e-07 0 4.665318610379825e-07 0 4.665418610379825e-07 0.00021 4.665518610379825e-07 0 4.665704176664129e-07 0 4.6658041766641293e-07 0.00021 4.6659041766641294e-07 0 4.6661068993455456e-07 0 4.666206899345546e-07 0.00021 4.666306899345546e-07 0 4.666768397403406e-07 0 4.666868397403406e-07 0.00021 4.666968397403406e-07 0 4.666968397403406e-07 0 4.667068397403406e-07 0.00021 4.6671683974034063e-07 0 4.6671683974034063e-07 0 4.6672683974034064e-07 0.00021 4.6673683974034065e-07 0 4.667489935103682e-07 0 4.667589935103682e-07 0.00021 4.667689935103682e-07 0 4.6678276870778405e-07 0 4.6679276870778406e-07 0.00021 4.6680276870778407e-07 0 4.6680276870778407e-07 0 4.668127687077841e-07 0.00021 4.668227687077841e-07 0 4.668234326664051e-07 0 4.668334326664051e-07 0.00021 4.668434326664051e-07 0 4.668434326664051e-07 0 4.668534326664051e-07 0.00021 4.668634326664051e-07 0 4.668634326664051e-07 0 4.6687343266640514e-07 0.00021 4.6688343266640515e-07 0 4.6688343266640515e-07 0 4.6689343266640516e-07 0.00021 4.6690343266640517e-07 0 4.6696350481639836e-07 0 4.6697350481639837e-07 0.00021 4.669835048163984e-07 0 4.669835048163984e-07 0 4.669935048163984e-07 0.00021 4.670035048163984e-07 0 4.670035048163984e-07 0 4.670135048163984e-07 0.00021 4.6702350481639843e-07 0 4.6702350481639843e-07 0 4.6703350481639844e-07 0.00021 4.6704350481639845e-07 0 4.6704350481639845e-07 0 4.6705350481639846e-07 0.00021 4.6706350481639847e-07 0 4.6710436297411657e-07 0 4.671143629741166e-07 0.00021 4.671243629741166e-07 0 4.671511295982661e-07 0 4.671611295982661e-07 0.00021 4.6717112959826613e-07 0 4.671791345329222e-07 0 4.671891345329222e-07 0.00021 4.671991345329222e-07 0 4.6727630372034363e-07 0 4.6728630372034364e-07 0.00021 4.6729630372034365e-07 0 4.673449717075541e-07 0 4.673549717075541e-07 0.00021 4.673649717075541e-07 0 4.673669634809521e-07 0 4.673769634809521e-07 0.00021 4.6738696348095214e-07 0 4.6738696348095214e-07 0 4.6739696348095215e-07 0.00021 4.6740696348095216e-07 0 4.6740696348095216e-07 0 4.6741696348095217e-07 0.00021 4.674269634809522e-07 0 4.674269634809522e-07 0 4.674369634809522e-07 0.00021 4.674469634809522e-07 0 4.67450238015884e-07 0 4.6746023801588403e-07 0.00021 4.6747023801588404e-07 0 4.6749203521463453e-07 0 4.6750203521463454e-07 0.00021 4.6751203521463455e-07 0 4.675299072632401e-07 0 4.675399072632401e-07 0.00021 4.675499072632401e-07 0 4.6757150522217055e-07 0 4.6758150522217056e-07 0.00021 4.675915052221706e-07 0 4.6761330362325987e-07 0 4.676233036232599e-07 0.00021 4.676333036232599e-07 0 4.676751938903513e-07 0 4.6768519389035133e-07 0.00021 4.6769519389035134e-07 0 4.6769519389035134e-07 0 4.6770519389035135e-07 0.00021 4.6771519389035137e-07 0 4.6773388543920816e-07 0 4.6774388543920817e-07 0.00021 4.677538854392082e-07 0 4.677590948808546e-07 0 4.677690948808546e-07 0.00021 4.677790948808546e-07 0 4.678085152325609e-07 0 4.678185152325609e-07 0.00021 4.6782851523256093e-07 0 4.678490881917332e-07 0 4.678590881917332e-07 0.00021 4.678690881917332e-07 0 4.67874666744559e-07 0 4.67884666744559e-07 0.00021 4.6789466674455903e-07 0 4.678990157929554e-07 0 4.679090157929554e-07 0.00021 4.679190157929554e-07 0 4.6794229185272733e-07 0 4.6795229185272734e-07 0.00021 4.6796229185272735e-07 0 4.67973718830275e-07 0 4.67983718830275e-07 0.00021 4.67993718830275e-07 0 4.67993718830275e-07 0 4.6800371883027503e-07 0.00021 4.6801371883027504e-07 0 4.6801505515145075e-07 0 4.6802505515145076e-07 0.00021 4.6803505515145077e-07 0 4.6803505515145077e-07 0 4.680450551514508e-07 0.00021 4.680550551514508e-07 0 4.6811982790368203e-07 0 4.6812982790368204e-07 0.00021 4.6813982790368205e-07 0 4.682432313696193e-07 0 4.682532313696193e-07 0.00021 4.682632313696193e-07 0 4.6827635448599534e-07 0 4.6828635448599535e-07 0.00021 4.6829635448599536e-07 0 4.6829635448599536e-07 0 4.6830635448599537e-07 0.00021 4.683163544859954e-07 0 4.683163544859954e-07 0 4.683263544859954e-07 0.00021 4.683363544859954e-07 0 4.683363544859954e-07 0 4.683463544859954e-07 0.00021 4.683563544859954e-07 0 4.683563544859954e-07 0 4.6836635448599544e-07 0.00021 4.6837635448599545e-07 0 4.6837635448599545e-07 0 4.6838635448599546e-07 0.00021 4.6839635448599547e-07 0 4.6839635448599547e-07 0 4.684063544859955e-07 0.00021 4.684163544859955e-07 0 4.684163544859955e-07 0 4.684263544859955e-07 0.00021 4.684363544859955e-07 0 4.684363544859955e-07 0 4.6844635448599553e-07 0.00021 4.6845635448599554e-07 0 4.6845635448599554e-07 0 4.6846635448599555e-07 0.00021 4.6847635448599556e-07 0 4.6856325689387235e-07 0 4.6857325689387236e-07 0.00021 4.6858325689387237e-07 0 4.6858325689387237e-07 0 4.685932568938724e-07 0.00021 4.686032568938724e-07 0 4.686032568938724e-07 0 4.686132568938724e-07 0.00021 4.686232568938724e-07 0 4.686232568938724e-07 0 4.6863325689387243e-07 0.00021 4.6864325689387244e-07 0 4.6868709936271206e-07 0 4.686970993627121e-07 0.00021 4.687070993627121e-07 0 4.687070993627121e-07 0 4.687170993627121e-07 0.00021 4.687270993627121e-07 0 4.687270993627121e-07 0 4.687370993627121e-07 0.00021 4.6874709936271213e-07 0 4.6874709936271213e-07 0 4.6875709936271214e-07 0.00021 4.6876709936271215e-07 0 4.6876709936271215e-07 0 4.6877709936271217e-07 0.00021 4.687870993627122e-07 0 4.687870993627122e-07 0 4.687970993627122e-07 0.00021 4.688070993627122e-07 0 4.688118330998765e-07 0 4.6882183309987653e-07 0.00021 4.6883183309987654e-07 0 4.6885485610951755e-07 0 4.6886485610951757e-07 0.00021 4.688748561095176e-07 0 4.688748561095176e-07 0 4.688848561095176e-07 0.00021 4.688948561095176e-07 0 4.688948561095176e-07 0 4.689048561095176e-07 0.00021 4.689148561095176e-07 0 4.689260553877784e-07 0 4.689360553877784e-07 0.00021 4.689460553877784e-07 0 4.689460553877784e-07 0 4.6895605538777843e-07 0.00021 4.6896605538777844e-07 0 4.6896605538777844e-07 0 4.6897605538777845e-07 0.00021 4.6898605538777846e-07 0 4.6898605538777846e-07 0 4.6899605538777847e-07 0.00021 4.690060553877785e-07 0 4.690060553877785e-07 0 4.690160553877785e-07 0.00021 4.690260553877785e-07 0 4.6903017069831217e-07 0 4.690401706983122e-07 0.00021 4.690501706983122e-07 0 4.6905097152365494e-07 0 4.6906097152365495e-07 0.00021 4.6907097152365496e-07 0 4.690793276993821e-07 0 4.690893276993821e-07 0.00021 4.690993276993821e-07 0 4.6920799039854607e-07 0 4.692179903985461e-07 0.00021 4.692279903985461e-07 0 4.692279903985461e-07 0 4.692379903985461e-07 0.00021 4.692479903985461e-07 0 4.693315498882781e-07 0 4.693415498882781e-07 0.00021 4.693515498882781e-07 0 4.693515498882781e-07 0 4.6936154988827813e-07 0.00021 4.6937154988827814e-07 0 4.6937154988827814e-07 0 4.6938154988827815e-07 0.00021 4.6939154988827816e-07 0 4.6939154988827816e-07 0 4.6940154988827817e-07 0.00021 4.694115498882782e-07 0 4.694115498882782e-07 0 4.694215498882782e-07 0.00021 4.694315498882782e-07 0 4.694339387168099e-07 0 4.6944393871680993e-07 0.00021 4.6945393871680995e-07 0 4.6948337116777673e-07 0 4.6949337116777674e-07 0.00021 4.6950337116777675e-07 0 4.6950337116777675e-07 0 4.6951337116777677e-07 0.00021 4.695233711677768e-07 0 4.695233711677768e-07 0 4.695333711677768e-07 0.00021 4.695433711677768e-07 0 4.695433711677768e-07 0 4.695533711677768e-07 0.00021 4.695633711677768e-07 0 4.695633711677768e-07 0 4.6957337116777683e-07 0.00021 4.6958337116777684e-07 0 4.6958337116777684e-07 0 4.6959337116777686e-07 0.00021 4.6960337116777687e-07 0 4.6960337116777687e-07 0 4.696133711677769e-07 0.00021 4.696233711677769e-07 0 4.696233711677769e-07 0 4.696333711677769e-07 0.00021 4.696433711677769e-07 0 4.696516165924195e-07 0 4.696616165924195e-07 0.00021 4.6967161659241954e-07 0 4.6969826434558757e-07 0 4.697082643455876e-07 0.00021 4.697182643455876e-07 0 4.6984750542974115e-07 0 4.6985750542974116e-07 0.00021 4.6986750542974117e-07 0 4.6987372035174976e-07 0 4.6988372035174977e-07 0.00021 4.698937203517498e-07 0 4.698937203517498e-07 0 4.699037203517498e-07 0.00021 4.699137203517498e-07 0 4.699137203517498e-07 0 4.699237203517498e-07 0.00021 4.6993372035174983e-07 0 4.6993372035174983e-07 0 4.6994372035174984e-07 0.00021 4.6995372035174985e-07 0 4.6995372035174985e-07 0 4.6996372035174986e-07 0.00021 4.699737203517499e-07 0 4.6998362179232027e-07 0 4.699936217923203e-07 0.00021 4.700036217923203e-07 0 4.700036217923203e-07 0 4.700136217923203e-07 0.00021 4.700236217923203e-07 0 4.700467391334988e-07 0 4.700567391334988e-07 0.00021 4.700667391334988e-07 0 4.701333727991757e-07 0 4.701433727991757e-07 0.00021 4.701533727991757e-07 0 4.7015994916173226e-07 0 4.7016994916173227e-07 0.00021 4.701799491617323e-07 0 4.702071181596515e-07 0 4.7021711815965154e-07 0.00021 4.7022711815965155e-07 0 4.7022711815965155e-07 0 4.7023711815965156e-07 0.00021 4.7024711815965157e-07 0 4.7024711815965157e-07 0 4.702571181596516e-07 0.00021 4.702671181596516e-07 0 4.7028183222594495e-07 0 4.7029183222594497e-07 0.00021 4.70301832225945e-07 0 4.70301832225945e-07 0 4.70311832225945e-07 0.00021 4.70321832225945e-07 0 4.70321832225945e-07 0 4.70331832225945e-07 0.00021 4.70341832225945e-07 0 4.70421530523123e-07 0 4.70431530523123e-07 0.00021 4.70441530523123e-07 0 4.704549652045747e-07 0 4.704649652045747e-07 0.00021 4.704749652045747e-07 0 4.705101685563579e-07 0 4.705201685563579e-07 0.00021 4.705301685563579e-07 0 4.705301685563579e-07 0 4.705401685563579e-07 0.00021 4.7055016855635794e-07 0 4.7055994117995453e-07 0 4.7056994117995454e-07 0.00021 4.7057994117995455e-07 0 4.7057994117995455e-07 0 4.7058994117995456e-07 0.00021 4.705999411799546e-07 0 4.706002331845798e-07 0 4.706102331845798e-07 0.00021 4.706202331845798e-07 0 4.706202331845798e-07 0 4.7063023318457983e-07 0.00021 4.7064023318457984e-07 0 4.706423825707841e-07 0 4.706523825707841e-07 0.00021 4.7066238257078413e-07 0 4.7067186772220937e-07 0 4.706818677222094e-07 0.00021 4.706918677222094e-07 0 4.7069649155962924e-07 0 4.7070649155962926e-07 0.00021 4.7071649155962927e-07 0 4.707230001336367e-07 0 4.707330001336367e-07 0.00021 4.7074300013363673e-07 0 4.707837681779873e-07 0 4.707937681779873e-07 0.00021 4.708037681779873e-07 0 4.708037681779873e-07 0 4.708137681779873e-07 0.00021 4.7082376817798734e-07 0 4.7082376817798734e-07 0 4.7083376817798735e-07 0.00021 4.7084376817798736e-07 0 4.7084376817798736e-07 0 4.7085376817798737e-07 0.00021 4.708637681779874e-07 0 4.708637681779874e-07 0 4.708737681779874e-07 0.00021 4.708837681779874e-07 0 4.708837681779874e-07 0 4.708937681779874e-07 0.00021 4.7090376817798743e-07 0 4.7090376817798743e-07 0 4.7091376817798744e-07 0.00021 4.7092376817798745e-07 0 4.7092376817798745e-07 0 4.7093376817798746e-07 0.00021 4.709437681779875e-07 0 4.709437681779875e-07 0 4.709537681779875e-07 0.00021 4.709637681779875e-07 0 4.709637681779875e-07 0 4.709737681779875e-07 0.00021 4.709837681779875e-07 0 4.709837681779875e-07 0 4.7099376817798753e-07 0.00021 4.7100376817798754e-07 0 4.710284461330577e-07 0 4.710384461330577e-07 0.00021 4.710484461330577e-07 0 4.710484461330577e-07 0 4.710584461330577e-07 0.00021 4.7106844613305773e-07 0 4.7106844613305773e-07 0 4.7107844613305774e-07 0.00021 4.7108844613305775e-07 0 4.7108844613305775e-07 0 4.7109844613305776e-07 0.00021 4.711084461330578e-07 0 4.711084461330578e-07 0 4.711184461330578e-07 0.00021 4.711284461330578e-07 0 4.711866199756747e-07 0 4.711966199756747e-07 0.00021 4.712066199756747e-07 0 4.712066199756747e-07 0 4.712166199756747e-07 0.00021 4.7122661997567474e-07 0 4.7122661997567474e-07 0 4.7123661997567475e-07 0.00021 4.7124661997567476e-07 0 4.7124661997567476e-07 0 4.7125661997567477e-07 0.00021 4.712666199756748e-07 0 4.712666199756748e-07 0 4.712766199756748e-07 0.00021 4.712866199756748e-07 0 4.712866199756748e-07 0 4.712966199756748e-07 0.00021 4.713066199756748e-07 0 4.7144246627435454e-07 0 4.7145246627435456e-07 0.00021 4.7146246627435457e-07 0 4.7146246627435457e-07 0 4.714724662743546e-07 0.00021 4.714824662743546e-07 0 4.714824662743546e-07 0 4.714924662743546e-07 0.00021 4.715024662743546e-07 0 4.71572839947814e-07 0 4.71582839947814e-07 0.00021 4.71592839947814e-07 0 4.7162623979706405e-07 0 4.7163623979706406e-07 0.00021 4.7164623979706407e-07 0 4.7167592524673624e-07 0 4.7168592524673625e-07 0.00021 4.7169592524673626e-07 0 4.7171634513106005e-07 0 4.7172634513106006e-07 0.00021 4.717363451310601e-07 0 4.717363451310601e-07 0 4.717463451310601e-07 0.00021 4.717563451310601e-07 0 4.7176664181167566e-07 0 4.7177664181167567e-07 0.00021 4.717866418116757e-07 0 4.7181817073152627e-07 0 4.718281707315263e-07 0.00021 4.718381707315263e-07 0 4.718381707315263e-07 0 4.718481707315263e-07 0.00021 4.718581707315263e-07 0 4.718581707315263e-07 0 4.7186817073152633e-07 0.00021 4.7187817073152634e-07 0 4.7194124130755934e-07 0 4.7195124130755935e-07 0.00021 4.7196124130755936e-07 0 4.7198141284067825e-07 0 4.7199141284067826e-07 0.00021 4.7200141284067827e-07 0 4.7200141284067827e-07 0 4.720114128406783e-07 0.00021 4.720214128406783e-07 0 4.720214128406783e-07 0 4.720314128406783e-07 0.00021 4.720414128406783e-07 0 4.720435719381535e-07 0 4.720535719381535e-07 0.00021 4.720635719381535e-07 0 4.7209520891976955e-07 0 4.7210520891976956e-07 0.00021 4.721152089197696e-07 0 4.721152089197696e-07 0 4.721252089197696e-07 0.00021 4.721352089197696e-07 0 4.721352089197696e-07 0 4.721452089197696e-07 0.00021 4.721552089197696e-07 0 4.721552089197696e-07 0 4.7216520891976963e-07 0.00021 4.7217520891976964e-07 0 4.7225771925615484e-07 0 4.7226771925615485e-07 0.00021 4.7227771925615486e-07 0 4.7235080017286985e-07 0 4.7236080017286986e-07 0.00021 4.7237080017286987e-07 0 4.7237080017286987e-07 0 4.723808001728699e-07 0.00021 4.723908001728699e-07 0 4.723908001728699e-07 0 4.724008001728699e-07 0.00021 4.724108001728699e-07 0 4.724108001728699e-07 0 4.7242080017286993e-07 0.00021 4.7243080017286994e-07 0 4.725141307540334e-07 0 4.725241307540334e-07 0.00021 4.725341307540334e-07 0 4.725341307540334e-07 0 4.725441307540334e-07 0.00021 4.725541307540334e-07 0 4.725814300808915e-07 0 4.725914300808915e-07 0.00021 4.726014300808915e-07 0 4.726014300808915e-07 0 4.7261143008089153e-07 0.00021 4.7262143008089155e-07 0 4.7262143008089155e-07 0 4.7263143008089156e-07 0.00021 4.7264143008089157e-07 0 4.7264143008089157e-07 0 4.726514300808916e-07 0.00021 4.726614300808916e-07 0 4.726614300808916e-07 0 4.726714300808916e-07 0.00021 4.726814300808916e-07 0 4.7268806282631017e-07 0 4.726980628263102e-07 0.00021 4.727080628263102e-07 0 4.727080628263102e-07 0 4.727180628263102e-07 0.00021 4.727280628263102e-07 0 4.727635402465754e-07 0 4.727735402465754e-07 0.00021 4.727835402465754e-07 0 4.727914379771948e-07 0 4.7280143797719483e-07 0.00021 4.7281143797719484e-07 0 4.728220596205167e-07 0 4.7283205962051673e-07 0.00021 4.7284205962051674e-07 0 4.7284205962051674e-07 0 4.7285205962051676e-07 0.00021 4.7286205962051677e-07 0 4.7287215953770427e-07 0 4.728821595377043e-07 0.00021 4.728921595377043e-07 0 4.7291610152466133e-07 0 4.7292610152466134e-07 0.00021 4.7293610152466136e-07 0 4.7294497761712655e-07 0 4.7295497761712656e-07 0.00021 4.729649776171266e-07 0 4.729649776171266e-07 0 4.729749776171266e-07 0.00021 4.729849776171266e-07 0 4.729849776171266e-07 0 4.729949776171266e-07 0.00021 4.730049776171266e-07 0 4.7300949466556455e-07 0 4.7301949466556456e-07 0.00021 4.7302949466556457e-07 0 4.7306124069764516e-07 0 4.7307124069764517e-07 0.00021 4.730812406976452e-07 0 4.73143438928514e-07 0 4.73153438928514e-07 0.00021 4.7316343892851404e-07 0 4.7316343892851404e-07 0 4.7317343892851405e-07 0.00021 4.7318343892851406e-07 0 4.7322108118365946e-07 0 4.7323108118365947e-07 0.00021 4.732410811836595e-07 0 4.732410811836595e-07 0 4.732510811836595e-07 0.00021 4.732610811836595e-07 0 4.733007056425865e-07 0 4.733107056425865e-07 0.00021 4.7332070564258653e-07 0 4.733390914661842e-07 0 4.733490914661842e-07 0.00021 4.733590914661842e-07 0 4.733846463963044e-07 0 4.733946463963044e-07 0.00021 4.7340464639630444e-07 0 4.7340464639630444e-07 0 4.7341464639630445e-07 0.00021 4.7342464639630446e-07 0 4.734297255093095e-07 0 4.734397255093095e-07 0.00021 4.7344972550930953e-07 0 4.7345412194399266e-07 0 4.734641219439927e-07 0.00021 4.734741219439927e-07 0 4.734741219439927e-07 0 4.734841219439927e-07 0.00021 4.734941219439927e-07 0 4.734941219439927e-07 0 4.735041219439927e-07 0.00021 4.7351412194399273e-07 0 4.7354897397524434e-07 0 4.7355897397524435e-07 0.00021 4.7356897397524436e-07 0 4.7356897397524436e-07 0 4.7357897397524437e-07 0.00021 4.735889739752444e-07 0 4.736072216698372e-07 0 4.736172216698372e-07 0.00021 4.736272216698372e-07 0 4.736298831255907e-07 0 4.7363988312559074e-07 0.00021 4.7364988312559075e-07 0 4.736871576425738e-07 0 4.7369715764257383e-07 0.00021 4.7370715764257384e-07 0 4.737478541601769e-07 0 4.737578541601769e-07 0.00021 4.7376785416017693e-07 0 4.7387550175059993e-07 0 4.7388550175059994e-07 0.00021 4.7389550175059995e-07 0 4.7389550175059995e-07 0 4.7390550175059997e-07 0.00021 4.739155017506e-07 0 4.7394941591548425e-07 0 4.7395941591548426e-07 0.00021 4.7396941591548427e-07 0 4.7398470061635016e-07 0 4.7399470061635017e-07 0.00021 4.740047006163502e-07 0 4.741214066068702e-07 0 4.741314066068702e-07 0.00021 4.741414066068702e-07 0 4.741414066068702e-07 0 4.741514066068702e-07 0.00021 4.741614066068702e-07 0 4.741614066068702e-07 0 4.7417140660687024e-07 0.00021 4.7418140660687025e-07 0 4.7418140660687025e-07 0 4.7419140660687026e-07 0.00021 4.7420140660687027e-07 0 4.7420140660687027e-07 0 4.742114066068703e-07 0.00021 4.742214066068703e-07 0 4.742214066068703e-07 0 4.742314066068703e-07 0.00021 4.742414066068703e-07 0 4.7424745056907264e-07 0 4.7425745056907265e-07 0.00021 4.7426745056907267e-07 0 4.7426745056907267e-07 0 4.742774505690727e-07 0.00021 4.742874505690727e-07 0 4.742874505690727e-07 0 4.742974505690727e-07 0.00021 4.743074505690727e-07 0 4.7432449605938027e-07 0 4.743344960593803e-07 0.00021 4.743444960593803e-07 0 4.743457796357003e-07 0 4.743557796357003e-07 0.00021 4.743657796357003e-07 0 4.7440117496899975e-07 0 4.7441117496899976e-07 0.00021 4.7442117496899977e-07 0 4.74444819278485e-07 0 4.7445481927848503e-07 0.00021 4.7446481927848504e-07 0 4.7448115898504666e-07 0 4.7449115898504667e-07 0.00021 4.745011589850467e-07 0 4.746238601236759e-07 0 4.746338601236759e-07 0.00021 4.746438601236759e-07 0 4.746438601236759e-07 0 4.746538601236759e-07 0.00021 4.7466386012367593e-07 0 4.746676171390114e-07 0 4.746776171390114e-07 0.00021 4.746876171390114e-07 0 4.7470144303090106e-07 0 4.7471144303090107e-07 0.00021 4.747214430309011e-07 0 4.747214430309011e-07 0 4.747314430309011e-07 0.00021 4.747414430309011e-07 0 4.747414430309011e-07 0 4.747514430309011e-07 0.00021 4.7476144303090113e-07 0 4.747722714141316e-07 0 4.747822714141316e-07 0.00021 4.747922714141316e-07 0 4.7479353712787296e-07 0 4.7480353712787297e-07 0.00021 4.74813537127873e-07 0 4.74813537127873e-07 0 4.74823537127873e-07 0.00021 4.74833537127873e-07 0 4.749393408887946e-07 0 4.749493408887946e-07 0.00021 4.7495934088879464e-07 0 4.7496975159621603e-07 0 4.7497975159621604e-07 0.00021 4.7498975159621605e-07 0 4.7498975159621605e-07 0 4.7499975159621606e-07 0.00021 4.750097515962161e-07 0 4.750663234019971e-07 0 4.750763234019971e-07 0.00021 4.7508632340199713e-07 0 4.751556995118887e-07 0 4.751656995118887e-07 0.00021 4.751756995118887e-07 0 4.751756995118887e-07 0 4.751856995118887e-07 0.00021 4.7519569951188873e-07 0 4.7519569951188873e-07 0 4.7520569951188874e-07 0.00021 4.7521569951188875e-07 0 4.7521569951188875e-07 0 4.7522569951188876e-07 0.00021 4.7523569951188877e-07 0 4.7523569951188877e-07 0 4.752456995118888e-07 0.00021 4.752556995118888e-07 0 4.752556995118888e-07 0 4.752656995118888e-07 0.00021 4.752756995118888e-07 0 4.752756995118888e-07 0 4.7528569951188883e-07 0.00021 4.7529569951188884e-07 0 4.7529569951188884e-07 0 4.7530569951188885e-07 0.00021 4.7531569951188886e-07 0 4.7537981085612803e-07 0 4.7538981085612804e-07 0.00021 4.7539981085612805e-07 0 4.7539981085612805e-07 0 4.7540981085612806e-07 0.00021 4.7541981085612807e-07 0 4.7541981085612807e-07 0 4.754298108561281e-07 0.00021 4.754398108561281e-07 0 4.754398108561281e-07 0 4.754498108561281e-07 0.00021 4.754598108561281e-07 0 4.754598108561281e-07 0 4.7546981085612813e-07 0.00021 4.7547981085612814e-07 0 4.7547981085612814e-07 0 4.7548981085612815e-07 0.00021 4.7549981085612816e-07 0 4.7549981085612816e-07 0 4.755098108561282e-07 0.00021 4.755198108561282e-07 0 4.7553937945620586e-07 0 4.755493794562059e-07 0.00021 4.755593794562059e-07 0 4.755593794562059e-07 0 4.755693794562059e-07 0.00021 4.755793794562059e-07 0 4.755793794562059e-07 0 4.755893794562059e-07 0.00021 4.7559937945620593e-07 0 4.7559937945620593e-07 0 4.7560937945620594e-07 0.00021 4.7561937945620595e-07 0 4.7561937945620595e-07 0 4.7562937945620597e-07 0.00021 4.75639379456206e-07 0 4.75639379456206e-07 0 4.75649379456206e-07 0.00021 4.75659379456206e-07 0 4.7567855373757355e-07 0 4.7568855373757356e-07 0.00021 4.756985537375736e-07 0 4.757247964364529e-07 0 4.757347964364529e-07 0.00021 4.757447964364529e-07 0 4.7575096549119045e-07 0 4.7576096549119046e-07 0.00021 4.7577096549119047e-07 0 4.757880042915306e-07 0 4.757980042915306e-07 0.00021 4.758080042915306e-07 0 4.758080042915306e-07 0 4.7581800429153063e-07 0.00021 4.7582800429153064e-07 0 4.75839739631566e-07 0 4.75849739631566e-07 0.00021 4.75859739631566e-07 0 4.75859739631566e-07 0 4.75869739631566e-07 0.00021 4.7587973963156603e-07 0 4.7587973963156603e-07 0 4.7588973963156604e-07 0.00021 4.7589973963156606e-07 0 4.7589973963156606e-07 0 4.7590973963156607e-07 0.00021 4.759197396315661e-07 0 4.759197396315661e-07 0 4.759297396315661e-07 0.00021 4.759397396315661e-07 0 4.7593994661413984e-07 0 4.7594994661413985e-07 0.00021 4.7595994661413986e-07 0 4.7598374403685777e-07 0 4.759937440368578e-07 0.00021 4.760037440368578e-07 0 4.7606160891956623e-07 0 4.7607160891956624e-07 0.00021 4.7608160891956625e-07 0 4.7608160891956625e-07 0 4.7609160891956626e-07 0.00021 4.761016089195663e-07 0 4.761016089195663e-07 0 4.761116089195663e-07 0.00021 4.761216089195663e-07 0 4.761216089195663e-07 0 4.761316089195663e-07 0.00021 4.761416089195663e-07 0 4.7616765414479903e-07 0 4.7617765414479904e-07 0.00021 4.7618765414479906e-07 0 4.762943981800995e-07 0 4.763043981800995e-07 0.00021 4.763143981800995e-07 0 4.763405738706559e-07 0 4.763505738706559e-07 0.00021 4.7636057387065593e-07 0 4.7636079110919093e-07 0 4.7637079110919095e-07 0.00021 4.7638079110919096e-07 0 4.763963361190116e-07 0 4.7640633611901164e-07 0.00021 4.7641633611901165e-07 0 4.764511587249591e-07 0 4.764611587249591e-07 0.00021 4.7647115872495914e-07 0 4.7647260238955055e-07 0 4.7648260238955056e-07 0.00021 4.764926023895506e-07 0 4.765274005497281e-07 0 4.7653740054972814e-07 0.00021 4.7654740054972815e-07 0 4.765519064623372e-07 0 4.765619064623372e-07 0.00021 4.7657190646233723e-07 0 4.7657190646233723e-07 0 4.7658190646233724e-07 0.00021 4.7659190646233725e-07 0 4.7659190646233725e-07 0 4.7660190646233726e-07 0.00021 4.766119064623373e-07 0 4.766119064623373e-07 0 4.766219064623373e-07 0.00021 4.766319064623373e-07 0 4.766319064623373e-07 0 4.766419064623373e-07 0.00021 4.766519064623373e-07 0 4.766519064623373e-07 0 4.7666190646233733e-07 0.00021 4.7667190646233734e-07 0 4.7667190646233734e-07 0 4.7668190646233735e-07 0.00021 4.7669190646233736e-07 0 4.7669190646233736e-07 0 4.767019064623374e-07 0.00021 4.767119064623374e-07 0 4.767119064623374e-07 0 4.767219064623374e-07 0.00021 4.767319064623374e-07 0 4.767319064623374e-07 0 4.767419064623374e-07 0.00021 4.7675190646233743e-07 0 4.7675190646233743e-07 0 4.7676190646233744e-07 0.00021 4.7677190646233746e-07 0 4.7677190646233746e-07 0 4.7678190646233747e-07 0.00021 4.767919064623375e-07 0 4.767919064623375e-07 0 4.768019064623375e-07 0.00021 4.768119064623375e-07 0 4.768595049488002e-07 0 4.768695049488002e-07 0.00021 4.768795049488002e-07 0 4.768795049488003e-07 0 4.768895049488002e-07 0.00021 4.768995049488002e-07 0 4.769098178440083e-07 0 4.769198178440082e-07 0.00021 4.769298178440082e-07 0 4.769385726995095e-07 0 4.769485726995095e-07 0.00021 4.769585726995095e-07 0 4.770835421630701e-07 0 4.770935421630701e-07 0.00021 4.7710354216307e-07 0 4.771715707832492e-07 0 4.771815707832492e-07 0.00021 4.771915707832491e-07 0 4.772014867568377e-07 0 4.772114867568376e-07 0.00021 4.772214867568376e-07 0 4.772214867568377e-07 0 4.772314867568376e-07 0.00021 4.772414867568376e-07 0 4.773424074369217e-07 0 4.773524074369216e-07 0.00021 4.773624074369216e-07 0 4.773624074369217e-07 0 4.773724074369217e-07 0.00021 4.773824074369216e-07 0 4.773824074369217e-07 0 4.773924074369217e-07 0.00021 4.774024074369216e-07 0 4.774024074369217e-07 0 4.774124074369217e-07 0.00021 4.774224074369217e-07 0 4.774224074369218e-07 0 4.774324074369217e-07 0.00021 4.774424074369217e-07 0 4.774633260737314e-07 0 4.774733260737314e-07 0.00021 4.774833260737313e-07 0 4.774833260737314e-07 0 4.774933260737314e-07 0.00021 4.775033260737313e-07 0 4.775033260737314e-07 0 4.775133260737314e-07 0.00021 4.775233260737314e-07 0 4.775309777747583e-07 0 4.775409777747582e-07 0.00021 4.775509777747582e-07 0 4.776322749321364e-07 0 4.776422749321364e-07 0.00021 4.776522749321363e-07 0 4.776585824640393e-07 0 4.776685824640392e-07 0.00021 4.776785824640392e-07 0 4.777595753018098e-07 0 4.777695753018098e-07 0.00021 4.777795753018097e-07 0 4.777795753018098e-07 0 4.777895753018098e-07 0.00021 4.777995753018097e-07 0 4.778265601822245e-07 0 4.778365601822245e-07 0.00021 4.778465601822244e-07 0 4.778585027055601e-07 0 4.7786850270556e-07 0.00021 4.7787850270556e-07 0 4.778785027055601e-07 0 4.7788850270556e-07 0.00021 4.7789850270556e-07 0 4.778985027055601e-07 0 4.779085027055601e-07 0.00021 4.7791850270556e-07 0 4.779380279286526e-07 0 4.779480279286526e-07 0.00021 4.779580279286525e-07 0 4.779580279286526e-07 0 4.779680279286526e-07 0.00021 4.779780279286526e-07 0 4.779780279286527e-07 0 4.779880279286526e-07 0.00021 4.779980279286526e-07 0 4.7799940518797e-07 0 4.7800940518797e-07 0.00021 4.7801940518797e-07 0 4.780244929014721e-07 0 4.780344929014721e-07 0.00021 4.78044492901472e-07 0 4.780444929014721e-07 0 4.780544929014721e-07 0.00021 4.78064492901472e-07 0 4.780644929014721e-07 0 4.780744929014721e-07 0.00021 4.780844929014721e-07 0 4.780844929014722e-07 0 4.780944929014721e-07 0.00021 4.781044929014721e-07 0 4.781044929014722e-07 0 4.781144929014722e-07 0.00021 4.781244929014721e-07 0 4.781244929014722e-07 0 4.781344929014722e-07 0.00021 4.781444929014721e-07 0 4.781550935780768e-07 0 4.781650935780767e-07 0.00021 4.781750935780767e-07 0 4.781787390430327e-07 0 4.781887390430326e-07 0.00021 4.781987390430326e-07 0 4.781987390430327e-07 0 4.782087390430326e-07 0.00021 4.782187390430326e-07 0 4.782234253952229e-07 0 4.782334253952229e-07 0.00021 4.782434253952228e-07 0 4.782434253952229e-07 0 4.782534253952229e-07 0.00021 4.782634253952229e-07 0 4.783469075161202e-07 0 4.783569075161202e-07 0.00021 4.783669075161201e-07 0 4.783669075161202e-07 0 4.783769075161202e-07 0.00021 4.783869075161201e-07 0 4.784383303533191e-07 0 4.784483303533191e-07 0.00021 4.78458330353319e-07 0 4.784740952736987e-07 0 4.784840952736986e-07 0.00021 4.784940952736986e-07 0 4.784940952736987e-07 0 4.785040952736987e-07 0.00021 4.785140952736986e-07 0 4.785962975138325e-07 0 4.786062975138325e-07 0.00021 4.786162975138324e-07 0 4.786162975138325e-07 0 4.786262975138325e-07 0.00021 4.786362975138324e-07 0 4.78646331796162e-07 0 4.78656331796162e-07 0.00021 4.78666331796162e-07 0 4.78686160962744e-07 0 4.786961609627439e-07 0.00021 4.787061609627439e-07 0 4.78706160962744e-07 0 4.787161609627439e-07 0.00021 4.787261609627439e-07 0 4.787332122838006e-07 0 4.787432122838005e-07 0.00021 4.787532122838005e-07 0 4.787938750838226e-07 0 4.788038750838225e-07 0.00021 4.788138750838225e-07 0 4.788296440141759e-07 0 4.788396440141758e-07 0.00021 4.788496440141758e-07 0 4.788581638370062e-07 0 4.788681638370062e-07 0.00021 4.788781638370062e-07 0 4.789194577762062e-07 0 4.789294577762062e-07 0.00021 4.789394577762061e-07 0 4.789924550458518e-07 0 4.790024550458518e-07 0.00021 4.790124550458518e-07 0 4.790129362644731e-07 0 4.790229362644731e-07 0.00021 4.79032936264473e-07 0 4.79045792539816e-07 0 4.790557925398159e-07 0.00021 4.790657925398159e-07 0 4.79065792539816e-07 0 4.79075792539816e-07 0.00021 4.790857925398159e-07 0 4.79085792539816e-07 0 4.79095792539816e-07 0.00021 4.791057925398159e-07 0 4.79105792539816e-07 0 4.79115792539816e-07 0.00021 4.79125792539816e-07 0 4.791605977975083e-07 0 4.791705977975083e-07 0.00021 4.791805977975082e-07 0 4.791805977975083e-07 0 4.791905977975083e-07 0.00021 4.792005977975083e-07 0 4.792005977975084e-07 0 4.792105977975083e-07 0.00021 4.792205977975083e-07 0 4.792467029081503e-07 0 4.792567029081503e-07 0.00021 4.792667029081502e-07 0 4.792817722656051e-07 0 4.792917722656051e-07 0.00021 4.793017722656051e-07 0 4.793017722656052e-07 0 4.793117722656051e-07 0.00021 4.793217722656051e-07 0 4.793217722656052e-07 0 4.793317722656051e-07 0.00021 4.793417722656051e-07 0 4.793417722656052e-07 0 4.793517722656052e-07 0.00021 4.793617722656051e-07 0 4.793617722656052e-07 0 4.793717722656052e-07 0.00021 4.793817722656051e-07 0 4.794068446927445e-07 0 4.794168446927444e-07 0.00021 4.794268446927444e-07 0 4.795394721290119e-07 0 4.795494721290118e-07 0.00021 4.795594721290118e-07 0 4.795594721290119e-07 0 4.795694721290118e-07 0.00021 4.795794721290118e-07 0 4.796246419505731e-07 0 4.796346419505731e-07 0.00021 4.796446419505731e-07 0 4.796697005343675e-07 0 4.796797005343675e-07 0.00021 4.796897005343674e-07 0 4.798177142378823e-07 0 4.798277142378822e-07 0.00021 4.798377142378822e-07 0 4.798567567302981e-07 0 4.798667567302981e-07 0.00021 4.798767567302981e-07 0 4.798945018781952e-07 0 4.799045018781952e-07 0.00021 4.799145018781951e-07 0 4.79928920761717e-07 0 4.799389207617169e-07 0.00021 4.799489207617169e-07 0 4.79948920761717e-07 0 4.79958920761717e-07 0.00021 4.799689207617169e-07 0 4.799840012675685e-07 0 4.799940012675685e-07 0.00021 4.800040012675685e-07 0 4.800763910148089e-07 0 4.800863910148088e-07 0.00021 4.800963910148088e-07 0 4.800963910148089e-07 0 4.801063910148088e-07 0.00021 4.801163910148088e-07 0 4.801163910148089e-07 0 4.801263910148089e-07 0.00021 4.801363910148088e-07 0 4.801363910148089e-07 0 4.801463910148089e-07 0.00021 4.801563910148089e-07 0 4.80156391014809e-07 0 4.801663910148089e-07 0.00021 4.801763910148089e-07 0 4.80176391014809e-07 0 4.801863910148089e-07 0.00021 4.801963910148089e-07 0 4.802696021087716e-07 0 4.802796021087715e-07 0.00021 4.802896021087715e-07 0 4.802896021087716e-07 0 4.802996021087715e-07 0.00021 4.803096021087715e-07 0 4.803572835358868e-07 0 4.803672835358867e-07 0.00021 4.803772835358867e-07 0 4.803772835358868e-07 0 4.803872835358867e-07 0.00021 4.803972835358867e-07 0 4.803972835358868e-07 0 4.804072835358868e-07 0.00021 4.804172835358867e-07 0 4.804172835358868e-07 0 4.804272835358868e-07 0.00021 4.804372835358867e-07 0 4.80485432798553e-07 0 4.80495432798553e-07 0.00021 4.805054327985529e-07 0 4.80505432798553e-07 0 4.80515432798553e-07 0.00021 4.805254327985529e-07 0 4.80525432798553e-07 0 4.80535432798553e-07 0.00021 4.80545432798553e-07 0 4.805454327985531e-07 0 4.80555432798553e-07 0.00021 4.80565432798553e-07 0 4.805654327985531e-07 0 4.80575432798553e-07 0.00021 4.80585432798553e-07 0 4.805854327985531e-07 0 4.805954327985531e-07 0.00021 4.80605432798553e-07 0 4.806054327985531e-07 0 4.806154327985531e-07 0.00021 4.80625432798553e-07 0 4.806254327985532e-07 0 4.806354327985531e-07 0.00021 4.806454327985531e-07 0 4.806454327985532e-07 0 4.806554327985531e-07 0.00021 4.806654327985531e-07 0 4.806654327985532e-07 0 4.806754327985532e-07 0.00021 4.806854327985531e-07 0 4.806854327985532e-07 0 4.806954327985532e-07 0.00021 4.807054327985531e-07 0 4.807054327985532e-07 0 4.807154327985532e-07 0.00021 4.807254327985532e-07 0 4.807254327985533e-07 0 4.807354327985532e-07 0.00021 4.807454327985532e-07 0 4.807454327985533e-07 0 4.807554327985533e-07 0.00021 4.807654327985532e-07 0 4.807654327985533e-07 0 4.807754327985533e-07 0.00021 4.807854327985532e-07 0 4.807854327985533e-07 0 4.807954327985533e-07 0.00021 4.808054327985533e-07 0 4.808054327985534e-07 0 4.808154327985533e-07 0.00021 4.808254327985533e-07 0 4.808254327985534e-07 0 4.808354327985533e-07 0.00021 4.808454327985533e-07 0 4.808454327985534e-07 0 4.808554327985534e-07 0.00021 4.808654327985533e-07 0 4.808654327985534e-07 0 4.808754327985534e-07 0.00021 4.808854327985533e-07 0 4.809361187032387e-07 0 4.809461187032387e-07 0.00021 4.809561187032386e-07 0 4.809561187032387e-07 0 4.809661187032387e-07 0.00021 4.809761187032386e-07 0 4.809781867683414e-07 0 4.809881867683413e-07 0.00021 4.809981867683413e-07 0 4.809981867683414e-07 0 4.810081867683413e-07 0.00021 4.810181867683413e-07 0 4.81032898342922e-07 0 4.810428983429219e-07 0.00021 4.810528983429219e-07 0 4.810893889056403e-07 0 4.810993889056403e-07 0.00021 4.811093889056402e-07 0 4.811312132004542e-07 0 4.811412132004542e-07 0.00021 4.811512132004542e-07 0 4.811593457201114e-07 0 4.811693457201113e-07 0.00021 4.811793457201113e-07 0 4.811793457201114e-07 0 4.811893457201113e-07 0.00021 4.811993457201113e-07 0 4.812010332826479e-07 0 4.812110332826478e-07 0.00021 4.812210332826478e-07 0 4.812210332826479e-07 0 4.812310332826479e-07 0.00021 4.812410332826478e-07 0 4.812618933984843e-07 0 4.812718933984843e-07 0.00021 4.812818933984842e-07 0 4.81299606976521e-07 0 4.81309606976521e-07 0.00021 4.813196069765209e-07 0 4.81319606976521e-07 0 4.81329606976521e-07 0.00021 4.813396069765209e-07 0 4.81339606976521e-07 0 4.81349606976521e-07 0.00021 4.81359606976521e-07 0 4.81371409516883e-07 0 4.81381409516883e-07 0.00021 4.813914095168829e-07 0 4.81391409516883e-07 0 4.81401409516883e-07 0.00021 4.81411409516883e-07 0 4.814114095168831e-07 0 4.81421409516883e-07 0.00021 4.81431409516883e-07 0 4.814469748928587e-07 0 4.814569748928587e-07 0.00021 4.814669748928586e-07 0 4.81483090114033e-07 0 4.81493090114033e-07 0.00021 4.815030901140329e-07 0 4.816067158031715e-07 0 4.816167158031715e-07 0.00021 4.816267158031715e-07 0 4.816414129462309e-07 0 4.816514129462309e-07 0.00021 4.816614129462309e-07 0 4.81661412946231e-07 0 4.816714129462309e-07 0.00021 4.816814129462309e-07 0 4.817483040348659e-07 0 4.817583040348658e-07 0.00021 4.817683040348658e-07 0 4.817825342640939e-07 0 4.817925342640939e-07 0.00021 4.818025342640938e-07 0 4.818025342640939e-07 0 4.818125342640939e-07 0.00021 4.818225342640939e-07 0 4.818896889686086e-07 0 4.818996889686086e-07 0.00021 4.819096889686085e-07 0 4.819563390768398e-07 0 4.819663390768397e-07 0.00021 4.819763390768397e-07 0 4.819763390768398e-07 0 4.819863390768398e-07 0.00021 4.819963390768397e-07 0 4.820153634525722e-07 0 4.820253634525721e-07 0.00021 4.820353634525721e-07 0 4.820487780966395e-07 0 4.820587780966394e-07 0.00021 4.820687780966394e-07 0 4.820985978297492e-07 0 4.821085978297492e-07 0.00021 4.821185978297492e-07 0 4.821185978297493e-07 0 4.821285978297492e-07 0.00021 4.821385978297492e-07 0 4.821421802825171e-07 0 4.82152180282517e-07 0.00021 4.82162180282517e-07 0 4.821930709485614e-07 0 4.822030709485613e-07 0.00021 4.822130709485613e-07 0 4.822263814844851e-07 0 4.82236381484485e-07 0.00021 4.82246381484485e-07 0 4.822463814844851e-07 0 4.82256381484485e-07 0.00021 4.82266381484485e-07 0 4.822729280448795e-07 0 4.822829280448794e-07 0.00021 4.822929280448794e-07 0 4.823097743003451e-07 0 4.82319774300345e-07 0.00021 4.82329774300345e-07 0 4.823297743003451e-07 0 4.823397743003451e-07 0.00021 4.82349774300345e-07 0 4.823497743003451e-07 0 4.823597743003451e-07 0.00021 4.82369774300345e-07 0 4.823807273886109e-07 0 4.823907273886108e-07 0.00021 4.824007273886108e-07 0 4.824007273886109e-07 0 4.824107273886109e-07 0.00021 4.824207273886108e-07 0 4.824207273886109e-07 0 4.824307273886109e-07 0.00021 4.824407273886108e-07 0 4.82440727388611e-07 0 4.824507273886109e-07 0.00021 4.824607273886109e-07 0 4.82460727388611e-07 0 4.824707273886109e-07 0.00021 4.824807273886109e-07 0 4.82480727388611e-07 0 4.82490727388611e-07 0.00021 4.825007273886109e-07 0 4.82500727388611e-07 0 4.82510727388611e-07 0.00021 4.825207273886109e-07 0 4.82520727388611e-07 0 4.82530727388611e-07 0.00021 4.82540727388611e-07 0 4.825407273886111e-07 0 4.82550727388611e-07 0.00021 4.82560727388611e-07 0 4.825607273886111e-07 0 4.82570727388611e-07 0.00021 4.82580727388611e-07 0 4.825807273886111e-07 0 4.825907273886111e-07 0.00021 4.82600727388611e-07 0 4.826007273886111e-07 0 4.826107273886111e-07 0.00021 4.82620727388611e-07 0 4.826207273886112e-07 0 4.826307273886111e-07 0.00021 4.826407273886111e-07 0 4.826407273886112e-07 0 4.826507273886111e-07 0.00021 4.826607273886111e-07 0 4.826607273886112e-07 0 4.826707273886112e-07 0.00021 4.826807273886111e-07 0 4.826888798133352e-07 0 4.826988798133351e-07 0.00021 4.827088798133351e-07 0 4.827088798133352e-07 0 4.827188798133352e-07 0.00021 4.827288798133351e-07 0 4.827288798133352e-07 0 4.827388798133352e-07 0.00021 4.827488798133351e-07 0 4.827488798133352e-07 0 4.827588798133352e-07 0.00021 4.827688798133352e-07 0 4.828051852290731e-07 0 4.828151852290731e-07 0.00021 4.82825185229073e-07 0 4.828251852290731e-07 0 4.828351852290731e-07 0.00021 4.82845185229073e-07 0 4.828451852290731e-07 0 4.828551852290731e-07 0.00021 4.828651852290731e-07 0 4.828913391020074e-07 0 4.829013391020074e-07 0.00021 4.829113391020073e-07 0 4.829113391020075e-07 0 4.829213391020074e-07 0.00021 4.829313391020074e-07 0 4.829618711586584e-07 0 4.829718711586584e-07 0.00021 4.829818711586583e-07 0 4.829980298697852e-07 0 4.830080298697852e-07 0.00021 4.830180298697851e-07 0 4.83041056840323e-07 0 4.83051056840323e-07 0.00021 4.830610568403229e-07 0 4.83061056840323e-07 0 4.83071056840323e-07 0.00021 4.830810568403229e-07 0 4.83081056840323e-07 0 4.83091056840323e-07 0.00021 4.83101056840323e-07 0 4.831010568403231e-07 0 4.83111056840323e-07 0.00021 4.83121056840323e-07 0 4.831210568403231e-07 0 4.83131056840323e-07 0.00021 4.83141056840323e-07 0 4.831587390830536e-07 0 4.831687390830536e-07 0.00021 4.831787390830535e-07 0 4.831787390830536e-07 0 4.831887390830536e-07 0.00021 4.831987390830536e-07 0 4.832296635293603e-07 0 4.832396635293603e-07 0.00021 4.832496635293603e-07 0 4.832594524704031e-07 0 4.832694524704031e-07 0.00021 4.83279452470403e-07 0 4.832794524704031e-07 0 4.832894524704031e-07 0.00021 4.83299452470403e-07 0 4.832994524704032e-07 0 4.833094524704031e-07 0.00021 4.833194524704031e-07 0 4.833194524704032e-07 0 4.833294524704031e-07 0.00021 4.833394524704031e-07 0 4.833625981454591e-07 0 4.833725981454591e-07 0.00021 4.83382598145459e-07 0 4.83419509631548e-07 0 4.83429509631548e-07 0.00021 4.834395096315479e-07 0 4.83439509631548e-07 0 4.83449509631548e-07 0.00021 4.83459509631548e-07 0 4.834595096315481e-07 0 4.83469509631548e-07 0.00021 4.83479509631548e-07 0 4.834795096315481e-07 0 4.83489509631548e-07 0.00021 4.83499509631548e-07 0 4.835717588298168e-07 0 4.835817588298168e-07 0.00021 4.835917588298168e-07 0 4.836089834520332e-07 0 4.836189834520332e-07 0.00021 4.836289834520331e-07 0 4.83703013452394e-07 0 4.83713013452394e-07 0.00021 4.837230134523939e-07 0 4.83723013452394e-07 0 4.83733013452394e-07 0.00021 4.837430134523939e-07 0 4.83743013452394e-07 0 4.83753013452394e-07 0.00021 4.83763013452394e-07 0 4.837665311788887e-07 0 4.837765311788886e-07 0.00021 4.837865311788886e-07 0 4.837865311788887e-07 0 4.837965311788886e-07 0.00021 4.838065311788886e-07 0 4.838065311788887e-07 0 4.838165311788887e-07 0.00021 4.838265311788886e-07 0 4.838265311788887e-07 0 4.838365311788887e-07 0.00021 4.838465311788886e-07 0 4.838848207712872e-07 0 4.838948207712871e-07 0.00021 4.839048207712871e-07 0 4.839048207712872e-07 0 4.839148207712871e-07 0.00021 4.839248207712871e-07 0 4.839685626102743e-07 0 4.839785626102742e-07 0.00021 4.839885626102742e-07 0 4.840021432434353e-07 0 4.840121432434353e-07 0.00021 4.840221432434353e-07 0 4.840221432434354e-07 0 4.840321432434353e-07 0.00021 4.840421432434353e-07 0 4.840689454200872e-07 0 4.840789454200872e-07 0.00021 4.840889454200871e-07 0 4.841049616093436e-07 0 4.841149616093435e-07 0.00021 4.841249616093435e-07 0 4.841249616093436e-07 0 4.841349616093436e-07 0.00021 4.841449616093435e-07 0 4.841449616093436e-07 0 4.841549616093436e-07 0.00021 4.841649616093435e-07 0 4.842087576734049e-07 0 4.842187576734049e-07 0.00021 4.842287576734048e-07 0 4.842287576734049e-07 0 4.842387576734049e-07 0.00021 4.842487576734049e-07 0 4.84249935458321e-07 0 4.84259935458321e-07 0.00021 4.842699354583209e-07 0 4.842759203421071e-07 0 4.842859203421071e-07 0.00021 4.842959203421071e-07 0 4.84332333178328e-07 0 4.84342333178328e-07 0.00021 4.843523331783279e-07 0 4.843648825607851e-07 0 4.843748825607851e-07 0.00021 4.84384882560785e-07 0 4.844917242828543e-07 0 4.845017242828542e-07 0.00021 4.845117242828542e-07 0 4.845394613483418e-07 0 4.845494613483418e-07 0.00021 4.845594613483418e-07 0 4.846640450800616e-07 0 4.846740450800615e-07 0.00021 4.846840450800615e-07 0 4.846889244051786e-07 0 4.846989244051785e-07 0.00021 4.847089244051785e-07 0 4.847089244051786e-07 0 4.847189244051786e-07 0.00021 4.847289244051785e-07 0 4.847289244051786e-07 0 4.847389244051786e-07 0.00021 4.847489244051785e-07 0 4.847592468421623e-07 0 4.847692468421622e-07 0.00021 4.847792468421622e-07 0 4.847792468421623e-07 0 4.847892468421622e-07 0.00021 4.847992468421622e-07 0 4.84817525779336e-07 0 4.84827525779336e-07 0.00021 4.848375257793359e-07 0 4.849338849992082e-07 0 4.849438849992082e-07 0.00021 4.849538849992082e-07 0 4.850412424519623e-07 0 4.850512424519622e-07 0.00021 4.850612424519622e-07 0 4.850872499721567e-07 0 4.850972499721567e-07 0.00021 4.851072499721566e-07 0 4.851072499721567e-07 0 4.851172499721567e-07 0.00021 4.851272499721566e-07 0 4.851272499721567e-07 0 4.851372499721567e-07 0.00021 4.851472499721567e-07 0 4.851472499721568e-07 0 4.851572499721567e-07 0.00021 4.851672499721567e-07 0 4.851672499721568e-07 0 4.851772499721567e-07 0.00021 4.851872499721567e-07 0 4.852541670138972e-07 0 4.852641670138971e-07 0.00021 4.852741670138971e-07 0 4.853455734830435e-07 0 4.853555734830434e-07 0.00021 4.853655734830434e-07 0 4.854100309156622e-07 0 4.854200309156622e-07 0.00021 4.854300309156621e-07 0 4.855881639457553e-07 0 4.855981639457552e-07 0.00021 4.856081639457552e-07 0 4.856292917903477e-07 0 4.856392917903477e-07 0.00021 4.856492917903476e-07 0 4.856884295327657e-07 0 4.856984295327657e-07 0.00021 4.857084295327657e-07 0 4.857270719181691e-07 0 4.857370719181691e-07 0.00021 4.85747071918169e-07 0 4.858196581516332e-07 0 4.858296581516332e-07 0.00021 4.858396581516331e-07 0 4.858537016793182e-07 0 4.858637016793181e-07 0.00021 4.858737016793181e-07 0 4.858737016793182e-07 0 4.858837016793181e-07 0.00021 4.858937016793181e-07 0 4.85913699036078e-07 0 4.85923699036078e-07 0.00021 4.859336990360779e-07 0 4.859471778717333e-07 0 4.859571778717332e-07 0.00021 4.859671778717332e-07 0 4.859956837589181e-07 0 4.860056837589181e-07 0.00021 4.86015683758918e-07 0 4.860160669027564e-07 0 4.860260669027564e-07 0.00021 4.860360669027563e-07 0 4.860990372062043e-07 0 4.861090372062043e-07 0.00021 4.861190372062043e-07 0 4.861190372062044e-07 0 4.861290372062043e-07 0.00021 4.861390372062043e-07 0 4.861865157973169e-07 0 4.861965157973168e-07 0.00021 4.862065157973168e-07 0 4.862653610167702e-07 0 4.862753610167702e-07 0.00021 4.862853610167701e-07 0 4.862898640828271e-07 0 4.862998640828271e-07 0.00021 4.86309864082827e-07 0 4.863098640828271e-07 0 4.863198640828271e-07 0.00021 4.86329864082827e-07 0 4.863298640828271e-07 0 4.863398640828271e-07 0.00021 4.863498640828271e-07 0 4.863562914012349e-07 0 4.863662914012349e-07 0.00021 4.863762914012348e-07 0 4.86398455344952e-07 0 4.864084553449519e-07 0.00021 4.864184553449519e-07 0 4.864222647125104e-07 0 4.864322647125104e-07 0.00021 4.864422647125104e-07 0 4.864679565586345e-07 0 4.864779565586344e-07 0.00021 4.864879565586344e-07 0 4.864879565586345e-07 0 4.864979565586344e-07 0.00021 4.865079565586344e-07 0 4.865079565586345e-07 0 4.865179565586345e-07 0.00021 4.865279565586344e-07 0 4.865850290452526e-07 0 4.865950290452525e-07 0.00021 4.866050290452525e-07 0 4.866050290452526e-07 0 4.866150290452525e-07 0.00021 4.866250290452525e-07 0 4.866250290452526e-07 0 4.866350290452526e-07 0.00021 4.866450290452525e-07 0 4.866450290452526e-07 0 4.866550290452526e-07 0.00021 4.866650290452525e-07 0 4.866650290452527e-07 0 4.866750290452526e-07 0.00021 4.866850290452526e-07 0 4.866850290452527e-07 0 4.866950290452526e-07 0.00021 4.867050290452526e-07 0 4.867050290452527e-07 0 4.867150290452527e-07 0.00021 4.867250290452526e-07 0 4.867250290452527e-07 0 4.867350290452527e-07 0.00021 4.867450290452526e-07 0 4.867450290452527e-07 0 4.867550290452527e-07 0.00021 4.867650290452527e-07 0 4.867650290452528e-07 0 4.867750290452527e-07 0.00021 4.867850290452527e-07 0 4.868002560169824e-07 0 4.868102560169824e-07 0.00021 4.868202560169823e-07 0 4.868487292565614e-07 0 4.868587292565614e-07 0.00021 4.868687292565613e-07 0 4.868687292565614e-07 0 4.868787292565614e-07 0.00021 4.868887292565613e-07 0 4.868887292565614e-07 0 4.868987292565614e-07 0.00021 4.869087292565614e-07 0 4.869087292565615e-07 0 4.869187292565614e-07 0.00021 4.869287292565614e-07 0 4.869287292565615e-07 0 4.869387292565614e-07 0.00021 4.869487292565614e-07 0 4.869487292565615e-07 0 4.869587292565615e-07 0.00021 4.869687292565614e-07 0 4.869687292565615e-07 0 4.869787292565615e-07 0.00021 4.869887292565615e-07 0 4.869887292565616e-07 0 4.869987292565615e-07 0.00021 4.870087292565615e-07 0 4.870087292565616e-07 0 4.870187292565615e-07 0.00021 4.870287292565615e-07 0 4.870287292565616e-07 0 4.870387292565616e-07 0.00021 4.870487292565615e-07 0 4.870487292565616e-07 0 4.870587292565616e-07 0.00021 4.870687292565615e-07 0 4.870687292565616e-07 0 4.870787292565616e-07 0.00021 4.870887292565616e-07 0 4.870887292565617e-07 0 4.870987292565616e-07 0.00021 4.871087292565616e-07 0 4.871087292565617e-07 0 4.871187292565617e-07 0.00021 4.871287292565616e-07 0 4.871287292565617e-07 0 4.871387292565617e-07 0.00021 4.871487292565616e-07 0 4.871487292565617e-07 0 4.871587292565617e-07 0.00021 4.871687292565617e-07 0 4.872129192431026e-07 0 4.872229192431026e-07 0.00021 4.872329192431025e-07 0 4.872781780390678e-07 0 4.872881780390678e-07 0.00021 4.872981780390677e-07 0 4.872981780390678e-07 0 4.873081780390678e-07 0.00021 4.873181780390678e-07 0 4.873181780390679e-07 0 4.873281780390678e-07 0.00021 4.873381780390678e-07 0 4.873381780390679e-07 0 4.873481780390678e-07 0.00021 4.873581780390678e-07 0 4.873581780390679e-07 0 4.873681780390679e-07 0.00021 4.873781780390678e-07 0 4.873781780390679e-07 0 4.873881780390679e-07 0.00021 4.873981780390679e-07 0 4.87398178039068e-07 0 4.874081780390679e-07 0.00021 4.874181780390679e-07 0 4.87418178039068e-07 0 4.874281780390679e-07 0.00021 4.874381780390679e-07 0 4.874596864279675e-07 0 4.874696864279675e-07 0.00021 4.874796864279674e-07 0 4.874796864279675e-07 0 4.874896864279675e-07 0.00021 4.874996864279674e-07 0 4.874996864279675e-07 0 4.875096864279675e-07 0.00021 4.875196864279675e-07 0 4.875196864279676e-07 0 4.875296864279675e-07 0.00021 4.875396864279675e-07 0 4.875396864279676e-07 0 4.875496864279675e-07 0.00021 4.875596864279675e-07 0 4.875596864279676e-07 0 4.875696864279676e-07 0.00021 4.875796864279675e-07 0 4.875796864279676e-07 0 4.875896864279676e-07 0.00021 4.875996864279676e-07 0 4.876617692840755e-07 0 4.876717692840755e-07 0.00021 4.876817692840754e-07 0 4.876881735973031e-07 0 4.87698173597303e-07 0.00021 4.87708173597303e-07 0 4.877564092826582e-07 0 4.877664092826582e-07 0.00021 4.877764092826582e-07 0 4.877791820789717e-07 0 4.877891820789717e-07 0.00021 4.877991820789716e-07 0 4.877991820789718e-07 0 4.878091820789717e-07 0.00021 4.878191820789717e-07 0 4.878191820789718e-07 0 4.878291820789717e-07 0.00021 4.878391820789717e-07 0 4.878391820789718e-07 0 4.878491820789718e-07 0.00021 4.878591820789717e-07 0 4.878591820789718e-07 0 4.878691820789718e-07 0.00021 4.878791820789717e-07 0 4.878794193038934e-07 0 4.878894193038934e-07 0.00021 4.878994193038933e-07 0 4.878994193038934e-07 0 4.879094193038934e-07 0.00021 4.879194193038933e-07 0 4.879194193038935e-07 0 4.879294193038934e-07 0.00021 4.879394193038934e-07 0 4.879394193038935e-07 0 4.879494193038934e-07 0.00021 4.879594193038934e-07 0 4.879594193038935e-07 0 4.879694193038935e-07 0.00021 4.879794193038934e-07 0 4.879794193038935e-07 0 4.879894193038935e-07 0.00021 4.879994193038934e-07 0 4.879994193038935e-07 0 4.880094193038935e-07 0.00021 4.880194193038935e-07 0 4.880194193038936e-07 0 4.880294193038935e-07 0.00021 4.880394193038935e-07 0 4.880394193038936e-07 0 4.880494193038935e-07 0.00021 4.880594193038935e-07 0 4.880594193038936e-07 0 4.880694193038936e-07 0.00021 4.880794193038935e-07 0 4.880794193038936e-07 0 4.880894193038936e-07 0.00021 4.880994193038936e-07 0 4.880994193038937e-07 0 4.881094193038936e-07 0.00021 4.881194193038936e-07 0 4.881194193038937e-07 0 4.881294193038936e-07 0.00021 4.881394193038936e-07 0 4.881394193038937e-07 0 4.881494193038937e-07 0.00021 4.881594193038936e-07 0 4.881594193038937e-07 0 4.881694193038937e-07 0.00021 4.881794193038936e-07 0 4.881794193038937e-07 0 4.881894193038937e-07 0.00021 4.881994193038937e-07 0 4.882216358175861e-07 0 4.882316358175861e-07 0.00021 4.88241635817586e-07 0 4.882981517942254e-07 0 4.883081517942254e-07 0.00021 4.883181517942254e-07 0 4.883551505800846e-07 0 4.883651505800845e-07 0.00021 4.883751505800845e-07 0 4.883751505800846e-07 0 4.883851505800846e-07 0.00021 4.883951505800845e-07 0 4.883951505800846e-07 0 4.884051505800846e-07 0.00021 4.884151505800845e-07 0 4.884262924142771e-07 0 4.88436292414277e-07 0.00021 4.88446292414277e-07 0 4.885588115495508e-07 0 4.885688115495508e-07 0.00021 4.885788115495507e-07 0 4.886299982997602e-07 0 4.886399982997602e-07 0.00021 4.886499982997602e-07 0 4.886752438440897e-07 0 4.886852438440896e-07 0.00021 4.886952438440896e-07 0 4.887058487470297e-07 0 4.887158487470297e-07 0.00021 4.887258487470296e-07 0 4.887302416001596e-07 0 4.887402416001595e-07 0.00021 4.887502416001595e-07 0 4.888328453282142e-07 0 4.888428453282141e-07 0.00021 4.888528453282141e-07 0 4.88896553793996e-07 0 4.889065537939959e-07 0.00021 4.889165537939959e-07 0 4.889488443462853e-07 0 4.889588443462853e-07 0.00021 4.889688443462852e-07 0 4.890841057625526e-07 0 4.890941057625525e-07 0.00021 4.891041057625525e-07 0 4.89111350778702e-07 0 4.89121350778702e-07 0.00021 4.89131350778702e-07 0 4.891562481423686e-07 0 4.891662481423685e-07 0.00021 4.891762481423685e-07 0 4.891859612467867e-07 0 4.891959612467866e-07 0.00021 4.892059612467866e-07 0 4.89219080941556e-07 0 4.892290809415559e-07 0.00021 4.892390809415559e-07 0 4.893698219092042e-07 0 4.893798219092042e-07 0.00021 4.893898219092042e-07 0 4.894037153648235e-07 0 4.894137153648235e-07 0.00021 4.894237153648234e-07 0 4.894237153648235e-07 0 4.894337153648235e-07 0.00021 4.894437153648234e-07 0 4.894437153648235e-07 0 4.894537153648235e-07 0.00021 4.894637153648235e-07 0 4.894637153648236e-07 0 4.894737153648235e-07 0.00021 4.894837153648235e-07 0 4.894837153648236e-07 0 4.894937153648235e-07 0.00021 4.895037153648235e-07 0 4.895037153648236e-07 0 4.895137153648236e-07 0.00021 4.895237153648235e-07 0 4.895237153648236e-07 0 4.895337153648236e-07 0.00021 4.895437153648236e-07 0 4.895437153648237e-07 0 4.895537153648236e-07 0.00021 4.895637153648236e-07 0 4.895637153648237e-07 0 4.895737153648236e-07 0.00021 4.895837153648236e-07 0 4.895837153648237e-07 0 4.895937153648237e-07 0.00021 4.896037153648236e-07 0 4.896037153648237e-07 0 4.896137153648237e-07 0.00021 4.896237153648236e-07 0 4.896237153648238e-07 0 4.896337153648237e-07 0.00021 4.896437153648237e-07 0 4.896437153648238e-07 0 4.896537153648237e-07 0.00021 4.896637153648237e-07 0 4.896815297990923e-07 0 4.896915297990923e-07 0.00021 4.897015297990922e-07 0 4.897015297990924e-07 0 4.897115297990923e-07 0.00021 4.897215297990923e-07 0 4.897215297990924e-07 0 4.897315297990923e-07 0.00021 4.897415297990923e-07 0 4.897427896553824e-07 0 4.897527896553823e-07 0.00021 4.897627896553823e-07 0 4.897627896553824e-07 0 4.897727896553823e-07 0.00021 4.897827896553823e-07 0 4.897855235188527e-07 0 4.897955235188527e-07 0.00021 4.898055235188527e-07 0 4.898055235188528e-07 0 4.898155235188527e-07 0.00021 4.898255235188527e-07 0 4.898255235188528e-07 0 4.898355235188527e-07 0.00021 4.898455235188527e-07 0 4.898455235188528e-07 0 4.898555235188528e-07 0.00021 4.898655235188527e-07 0 4.899935748696123e-07 0 4.900035748696122e-07 0.00021 4.900135748696122e-07 0 4.900135748696123e-07 0 4.900235748696122e-07 0.00021 4.900335748696122e-07 0 4.900335748696123e-07 0 4.900435748696123e-07 0.00021 4.900535748696122e-07 0 4.900535748696123e-07 0 4.900635748696123e-07 0.00021 4.900735748696122e-07 0 4.900735748696123e-07 0 4.900835748696123e-07 0.00021 4.900935748696123e-07 0 4.900935748696124e-07 0 4.901035748696123e-07 0.00021 4.901135748696123e-07 0 4.901135748696124e-07 0 4.901235748696123e-07 0.00021 4.901335748696123e-07 0 4.901335748696124e-07 0 4.901435748696124e-07 0.00021 4.901535748696123e-07 0 4.901535748696124e-07 0 4.901635748696124e-07 0.00021 4.901735748696124e-07 0 4.902224460679959e-07 0 4.902324460679958e-07 0.00021 4.902424460679958e-07 0 4.902436229216719e-07 0 4.902536229216719e-07 0.00021 4.902636229216719e-07 0 4.90263622921672e-07 0 4.902736229216719e-07 0.00021 4.902836229216719e-07 0 4.90283622921672e-07 0 4.902936229216719e-07 0.00021 4.903036229216719e-07 0 4.903543490746308e-07 0 4.903643490746308e-07 0.00021 4.903743490746307e-07 0 4.903743490746308e-07 0 4.903843490746308e-07 0.00021 4.903943490746307e-07 0 4.904286382787695e-07 0 4.904386382787694e-07 0.00021 4.904486382787694e-07 0 4.904486382787695e-07 0 4.904586382787694e-07 0.00021 4.904686382787694e-07 0 4.904868958791389e-07 0 4.904968958791388e-07 0.00021 4.905068958791388e-07 0 4.905125482117331e-07 0 4.905225482117331e-07 0.00021 4.905325482117331e-07 0 4.905325482117332e-07 0 4.905425482117331e-07 0.00021 4.905525482117331e-07 0 4.906035680818107e-07 0 4.906135680818107e-07 0.00021 4.906235680818106e-07 0 4.906461525322968e-07 0 4.906561525322968e-07 0.00021 4.906661525322967e-07 0 4.906661525322968e-07 0 4.906761525322968e-07 0.00021 4.906861525322968e-07 0 4.907526728184641e-07 0 4.90762672818464e-07 0.00021 4.90772672818464e-07 0 4.907944402976713e-07 0 4.908044402976712e-07 0.00021 4.908144402976712e-07 0 4.908144402976713e-07 0 4.908244402976713e-07 0.00021 4.908344402976712e-07 0 4.908765661324915e-07 0 4.908865661324914e-07 0.00021 4.908965661324914e-07 0 4.908965661324915e-07 0 4.909065661324914e-07 0.00021 4.909165661324914e-07 0 4.910208327914106e-07 0 4.910308327914106e-07 0.00021 4.910408327914106e-07 0 4.910408327914107e-07 0 4.910508327914106e-07 0.00021 4.910608327914106e-07 0 4.910608327914107e-07 0 4.910708327914106e-07 0.00021 4.910808327914106e-07 0 4.911212000645186e-07 0 4.911312000645185e-07 0.00021 4.911412000645185e-07 0 4.911412000645186e-07 0 4.911512000645186e-07 0.00021 4.911612000645185e-07 0 4.911612000645186e-07 0 4.911712000645186e-07 0.00021 4.911812000645185e-07 0 4.911812000645187e-07 0 4.911912000645186e-07 0.00021 4.912012000645186e-07 0 4.912012000645187e-07 0 4.912112000645186e-07 0.00021 4.912212000645186e-07 0 4.912212000645187e-07 0 4.912312000645187e-07 0.00021 4.912412000645186e-07 0 4.912412000645187e-07 0 4.912512000645187e-07 0.00021 4.912612000645186e-07 0 4.912612000645187e-07 0 4.912712000645187e-07 0.00021 4.912812000645187e-07 0 4.912812000645188e-07 0 4.912912000645187e-07 0.00021 4.913012000645187e-07 0 4.913012000645188e-07 0 4.913112000645187e-07 0.00021 4.913212000645187e-07 0 4.913212000645188e-07 0 4.913312000645188e-07 0.00021 4.913412000645187e-07 0 4.913441447584371e-07 0 4.913541447584371e-07 0.00021 4.91364144758437e-07 0 4.913641447584371e-07 0 4.913741447584371e-07 0.00021 4.913841447584371e-07 0 4.913841447584372e-07 0 4.913941447584371e-07 0.00021 4.914041447584371e-07 0 4.914049638310944e-07 0 4.914149638310944e-07 0.00021 4.914249638310943e-07 0 4.914249638310944e-07 0 4.914349638310944e-07 0.00021 4.914449638310943e-07 0 4.914449638310944e-07 0 4.914549638310944e-07 0.00021 4.914649638310944e-07 0 4.914800618671028e-07 0 4.914900618671028e-07 0.00021 4.915000618671027e-07 0 4.915000618671028e-07 0 4.915100618671028e-07 0.00021 4.915200618671028e-07 0 4.916322361361668e-07 0 4.916422361361668e-07 0.00021 4.916522361361667e-07 0 4.916522361361668e-07 0 4.916622361361668e-07 0.00021 4.916722361361668e-07 0 4.916722361361669e-07 0 4.916822361361668e-07 0.00021 4.916922361361668e-07 0 4.917973649112552e-07 0 4.918073649112551e-07 0.00021 4.918173649112551e-07 0 4.918173649112552e-07 0 4.918273649112551e-07 0.00021 4.918373649112551e-07 0 4.918373649112552e-07 0 4.918473649112552e-07 0.00021 4.918573649112551e-07 0 4.918573649112552e-07 0 4.918673649112552e-07 0.00021 4.918773649112551e-07 0 4.918773649112553e-07 0 4.918873649112552e-07 0.00021 4.918973649112552e-07 0 4.918973649112553e-07 0 4.919073649112552e-07 0.00021 4.919173649112552e-07 0 4.919173649112553e-07 0 4.919273649112553e-07 0.00021 4.919373649112552e-07 0 4.919373649112553e-07 0 4.919473649112553e-07 0.00021 4.919573649112552e-07 0 4.919573649112553e-07 0 4.919673649112553e-07 0.00021 4.919773649112553e-07 0 4.919773649112554e-07 0 4.919873649112553e-07 0.00021 4.919973649112553e-07 0 4.919973649112554e-07 0 4.920073649112553e-07 0.00021 4.920173649112553e-07 0 4.920173649112554e-07 0 4.920273649112554e-07 0.00021 4.920373649112553e-07 0 4.920373649112554e-07 0 4.920473649112554e-07 0.00021 4.920573649112553e-07 0 4.920778362310398e-07 0 4.920878362310397e-07 0.00021 4.920978362310397e-07 0 4.920978362310398e-07 0 4.921078362310397e-07 0.00021 4.921178362310397e-07 0 4.921178362310398e-07 0 4.921278362310398e-07 0.00021 4.921378362310397e-07 0 4.921378362310398e-07 0 4.921478362310398e-07 0.00021 4.921578362310397e-07 0 4.921578362310398e-07 0 4.921678362310398e-07 0.00021 4.921778362310398e-07 0 4.922248918814278e-07 0 4.922348918814277e-07 0.00021 4.922448918814277e-07 0 4.922559307296189e-07 0 4.922659307296188e-07 0.00021 4.922759307296188e-07 0 4.922759307296189e-07 0 4.922859307296189e-07 0.00021 4.922959307296188e-07 0 4.922959307296189e-07 0 4.923059307296189e-07 0.00021 4.923159307296188e-07 0 4.923444015245725e-07 0 4.923544015245725e-07 0.00021 4.923644015245725e-07 0 4.923758365147386e-07 0 4.923858365147385e-07 0.00021 4.923958365147385e-07 0 4.923958365147386e-07 0 4.924058365147386e-07 0.00021 4.924158365147385e-07 0 4.924158365147386e-07 0 4.924258365147386e-07 0.00021 4.924358365147386e-07 0 4.924380314978207e-07 0 4.924480314978206e-07 0.00021 4.924580314978206e-07 0 4.924580314978207e-07 0 4.924680314978207e-07 0.00021 4.924780314978206e-07 0 4.924780314978207e-07 0 4.924880314978207e-07 0.00021 4.924980314978206e-07 0 4.927424179577041e-07 0 4.927524179577041e-07 0.00021 4.927624179577041e-07 0 4.927624179577042e-07 0 4.927724179577041e-07 0.00021 4.927824179577041e-07 0 4.927824179577042e-07 0 4.927924179577041e-07 0.00021 4.928024179577041e-07 0 4.928024179577042e-07 0 4.928124179577042e-07 0.00021 4.928224179577041e-07 0 4.928224179577042e-07 0 4.928324179577042e-07 0.00021 4.928424179577041e-07 0 4.929085347256499e-07 0 4.929185347256498e-07 0.00021 4.929285347256498e-07 0 4.929593956156048e-07 0 4.929693956156047e-07 0.00021 4.929793956156047e-07 0 4.929816992789618e-07 0 4.929916992789618e-07 0.00021 4.930016992789617e-07 0 4.930182417501396e-07 0 4.930282417501395e-07 0.00021 4.930382417501395e-07 0 4.931052656910438e-07 0 4.931152656910438e-07 0.00021 4.931252656910437e-07 0 4.931252656910438e-07 0 4.931352656910438e-07 0.00021 4.931452656910438e-07 0 4.932026351464139e-07 0 4.932126351464139e-07 0.00021 4.932226351464138e-07 0 4.932714513590892e-07 0 4.932814513590892e-07 0.00021 4.932914513590892e-07 0 4.933829147647925e-07 0 4.933929147647924e-07 0.00021 4.934029147647924e-07 0 4.934386386620846e-07 0 4.934486386620845e-07 0.00021 4.934586386620845e-07 0 4.934707115053666e-07 0 4.934807115053666e-07 0.00021 4.934907115053665e-07 0 4.934907115053666e-07 0 4.935007115053666e-07 0.00021 4.935107115053666e-07 0 4.935129917235379e-07 0 4.935229917235379e-07 0.00021 4.935329917235378e-07 0 4.935855373692475e-07 0 4.935955373692474e-07 0.00021 4.936055373692474e-07 0 4.936055373692475e-07 0 4.936155373692474e-07 0.00021 4.936255373692474e-07 0 4.936382538326729e-07 0 4.936482538326728e-07 0.00021 4.936582538326728e-07 0 4.936642734013302e-07 0 4.936742734013301e-07 0.00021 4.936842734013301e-07 0 4.936878416928511e-07 0 4.936978416928511e-07 0.00021 4.93707841692851e-07 0 4.937086722829375e-07 0 4.937186722829375e-07 0.00021 4.937286722829374e-07 0 4.937286722829376e-07 0 4.937386722829375e-07 0.00021 4.937486722829375e-07 0 4.937486722829376e-07 0 4.937586722829375e-07 0.00021 4.937686722829375e-07 0 4.937686722829376e-07 0 4.937786722829376e-07 0.00021 4.937886722829375e-07 0 4.937886722829376e-07 0 4.937986722829376e-07 0.00021 4.938086722829375e-07 0 4.938086722829376e-07 0 4.938186722829376e-07 0.00021 4.938286722829376e-07 0 4.938286722829377e-07 0 4.938386722829376e-07 0.00021 4.938486722829376e-07 0 4.938486722829377e-07 0 4.938586722829376e-07 0.00021 4.938686722829376e-07 0 4.938686722829377e-07 0 4.938786722829377e-07 0.00021 4.938886722829376e-07 0 4.938886722829377e-07 0 4.938986722829377e-07 0.00021 4.939086722829377e-07 0 4.939467311058421e-07 0 4.939567311058421e-07 0.00021 4.93966731105842e-07 0 4.940247353674806e-07 0 4.940347353674805e-07 0.00021 4.940447353674805e-07 0 4.940945960507931e-07 0 4.941045960507931e-07 0.00021 4.94114596050793e-07 0 4.941145960507931e-07 0 4.941245960507931e-07 0.00021 4.941345960507931e-07 0 4.941345960507932e-07 0 4.941445960507931e-07 0.00021 4.941545960507931e-07 0 4.941938859680425e-07 0 4.942038859680425e-07 0.00021 4.942138859680424e-07 0 4.942138859680425e-07 0 4.942238859680425e-07 0.00021 4.942338859680425e-07 0 4.942338859680426e-07 0 4.942438859680425e-07 0.00021 4.942538859680425e-07 0 4.942538859680426e-07 0 4.942638859680426e-07 0.00021 4.942738859680425e-07 0 4.942738859680426e-07 0 4.942838859680426e-07 0.00021 4.942938859680425e-07 0 4.943187686879033e-07 0 4.943287686879032e-07 0.00021 4.943387686879032e-07 0 4.94363041055848e-07 0 4.94373041055848e-07 0.00021 4.943830410558479e-07 0 4.944100664306147e-07 0 4.944200664306146e-07 0.00021 4.944300664306146e-07 0 4.944584143604884e-07 0 4.944684143604884e-07 0.00021 4.944784143604884e-07 0 4.945276509287196e-07 0 4.945376509287195e-07 0.00021 4.945476509287195e-07 0 4.945497821939563e-07 0 4.945597821939563e-07 0.00021 4.945697821939562e-07 0 4.945697821939563e-07 0 4.945797821939563e-07 0.00021 4.945897821939562e-07 0 4.945936080520477e-07 0 4.946036080520477e-07 0.00021 4.946136080520477e-07 0 4.946136080520478e-07 0 4.946236080520477e-07 0.00021 4.946336080520477e-07 0 4.947049652257121e-07 0 4.94714965225712e-07 0.00021 4.94724965225712e-07 0 4.947603912180643e-07 0 4.947703912180643e-07 0.00021 4.947803912180642e-07 0 4.947803912180643e-07 0 4.947903912180643e-07 0.00021 4.948003912180642e-07 0 4.948003912180643e-07 0 4.948103912180643e-07 0.00021 4.948203912180643e-07 0 4.948211615983138e-07 0 4.948311615983138e-07 0.00021 4.948411615983137e-07 0 4.948411615983138e-07 0 4.948511615983138e-07 0.00021 4.948611615983137e-07 0 4.948747548250751e-07 0 4.948847548250751e-07 0.00021 4.94894754825075e-07 0 4.949256021308444e-07 0 4.949356021308443e-07 0.00021 4.949456021308443e-07 0 4.949456021308444e-07 0 4.949556021308444e-07 0.00021 4.949656021308443e-07 0 4.949656021308444e-07 0 4.949756021308444e-07 0.00021 4.949856021308444e-07 0 4.949934776894761e-07 0 4.950034776894761e-07 0.00021 4.95013477689476e-07 0 4.950357549222918e-07 0 4.950457549222918e-07 0.00021 4.950557549222918e-07 0 4.950557549222919e-07 0 4.950657549222918e-07 0.00021 4.950757549222918e-07 0 4.950757549222919e-07 0 4.950857549222918e-07 0.00021 4.950957549222918e-07 0 4.95105550966288e-07 0 4.95115550966288e-07 0.00021 4.95125550966288e-07 0 4.951308810931947e-07 0 4.951408810931947e-07 0.00021 4.951508810931946e-07 0 4.952443769284758e-07 0 4.952543769284757e-07 0.00021 4.952643769284757e-07 0 4.953088692797718e-07 0 4.953188692797718e-07 0.00021 4.953288692797718e-07 0 4.953354146448541e-07 0 4.953454146448541e-07 0.00021 4.95355414644854e-07 0 4.953768339906568e-07 0 4.953868339906567e-07 0.00021 4.953968339906567e-07 0 4.953968339906568e-07 0 4.954068339906568e-07 0.00021 4.954168339906567e-07 0 4.954271831730699e-07 0 4.954371831730698e-07 0.00021 4.954471831730698e-07 0 4.954723244143161e-07 0 4.954823244143161e-07 0.00021 4.954923244143161e-07 0 4.954923244143162e-07 0 4.955023244143161e-07 0.00021 4.955123244143161e-07 0 4.955154947631431e-07 0 4.95525494763143e-07 0.00021 4.95535494763143e-07 0 4.955504245190555e-07 0 4.955604245190554e-07 0.00021 4.955704245190554e-07 0 4.955704245190555e-07 0 4.955804245190554e-07 0.00021 4.955904245190554e-07 0 4.956209961504418e-07 0 4.956309961504418e-07 0.00021 4.956409961504418e-07 0 4.956723009408448e-07 0 4.956823009408447e-07 0.00021 4.956923009408447e-07 0 4.957063414778635e-07 0 4.957163414778634e-07 0.00021 4.957263414778634e-07 0 4.957263414778635e-07 0 4.957363414778635e-07 0.00021 4.957463414778634e-07 0 4.957471473729956e-07 0 4.957571473729956e-07 0.00021 4.957671473729955e-07 0 4.957671473729956e-07 0 4.957771473729956e-07 0.00021 4.957871473729956e-07 0 4.957871473729957e-07 0 4.957971473729956e-07 0.00021 4.958071473729956e-07 0 4.958071473729957e-07 0 4.958171473729956e-07 0.00021 4.958271473729956e-07 0 4.958271473729957e-07 0 4.958371473729957e-07 0.00021 4.958471473729956e-07 0 4.958471473729957e-07 0 4.958571473729957e-07 0.00021 4.958671473729956e-07 0 4.958671473729958e-07 0 4.958771473729957e-07 0.00021 4.958871473729957e-07 0 4.958891277943976e-07 0 4.958991277943976e-07 0.00021 4.959091277943975e-07 0 4.959091277943976e-07 0 4.959191277943976e-07 0.00021 4.959291277943976e-07 0 4.959291277943977e-07 0 4.959391277943976e-07 0.00021 4.959491277943976e-07 0 4.959946401104286e-07 0 4.960046401104285e-07 0.00021 4.960146401104285e-07 0 4.960414928099277e-07 0 4.960514928099276e-07 0.00021 4.960614928099276e-07 0 4.961018037719123e-07 0 4.961118037719123e-07 0.00021 4.961218037719122e-07 0 4.961464561428154e-07 0 4.961564561428154e-07 0.00021 4.961664561428154e-07 0 4.961664561428155e-07 0 4.961764561428154e-07 0.00021 4.961864561428154e-07 0 4.961864561428155e-07 0 4.961964561428154e-07 0.00021 4.962064561428154e-07 0 4.962064561428155e-07 0 4.962164561428155e-07 0.00021 4.962264561428154e-07 0 4.962264561428155e-07 0 4.962364561428155e-07 0.00021 4.962464561428154e-07 0 4.962526429236424e-07 0 4.962626429236423e-07 0.00021 4.962726429236423e-07 0 4.963516914350312e-07 0 4.963616914350311e-07 0.00021 4.963716914350311e-07 0 4.96376673315841e-07 0 4.96386673315841e-07 0.00021 4.963966733158409e-07 0 4.96396673315841e-07 0 4.96406673315841e-07 0.00021 4.96416673315841e-07 0 4.964166733158411e-07 0 4.96426673315841e-07 0.00021 4.96436673315841e-07 0 4.964366733158411e-07 0 4.96446673315841e-07 0.00021 4.96456673315841e-07 0 4.964566733158411e-07 0 4.964666733158411e-07 0.00021 4.96476673315841e-07 0 4.964766733158411e-07 0 4.964866733158411e-07 0.00021 4.96496673315841e-07 0 4.965022571202359e-07 0 4.965122571202358e-07 0.00021 4.965222571202358e-07 0 4.965231466068775e-07 0 4.965331466068775e-07 0.00021 4.965431466068775e-07 0 4.965431466068776e-07 0 4.965531466068775e-07 0.00021 4.965631466068775e-07 0 4.965631466068776e-07 0 4.965731466068775e-07 0.00021 4.965831466068775e-07 0 4.966033824244418e-07 0 4.966133824244417e-07 0.00021 4.966233824244417e-07 0 4.966233824244418e-07 0 4.966333824244418e-07 0.00021 4.966433824244417e-07 0 4.966818839216668e-07 0 4.966918839216668e-07 0.00021 4.967018839216667e-07 0 4.967121846889285e-07 0 4.967221846889285e-07 0.00021 4.967321846889284e-07 0 4.967321846889285e-07 0 4.967421846889285e-07 0.00021 4.967521846889285e-07 0 4.967906928433519e-07 0 4.968006928433519e-07 0.00021 4.968106928433518e-07 0 4.968106928433519e-07 0 4.968206928433519e-07 0.00021 4.968306928433519e-07 0 4.968588960776522e-07 0 4.968688960776522e-07 0.00021 4.968788960776521e-07 0 4.969017636399194e-07 0 4.969117636399194e-07 0.00021 4.969217636399193e-07 0 4.969470760296602e-07 0 4.969570760296601e-07 0.00021 4.969670760296601e-07 0 4.969867708597984e-07 0 4.969967708597984e-07 0.00021 4.970067708597983e-07 0 4.970525867584565e-07 0 4.970625867584565e-07 0.00021 4.970725867584564e-07 0 4.971090339497708e-07 0 4.971190339497707e-07 0.00021 4.971290339497707e-07 0 4.972132688081067e-07 0 4.972232688081067e-07 0.00021 4.972332688081067e-07 0 4.972332688081068e-07 0 4.972432688081067e-07 0.00021 4.972532688081067e-07 0 4.972532688081068e-07 0 4.972632688081067e-07 0.00021 4.972732688081067e-07 0 4.972732688081068e-07 0 4.972832688081068e-07 0.00021 4.972932688081067e-07 0 4.972932688081068e-07 0 4.973032688081068e-07 0.00021 4.973132688081067e-07 0 4.973132688081069e-07 0 4.973232688081068e-07 0.00021 4.973332688081068e-07 0 4.973332688081069e-07 0 4.973432688081068e-07 0.00021 4.973532688081068e-07 0 4.973532688081069e-07 0 4.973632688081069e-07 0.00021 4.973732688081068e-07 0 4.973732688081069e-07 0 4.973832688081069e-07 0.00021 4.973932688081068e-07 0 4.973932688081069e-07 0 4.974032688081069e-07 0.00021 4.974132688081069e-07 0 4.97413268808107e-07 0 4.974232688081069e-07 0.00021 4.974332688081069e-07 0 4.974343445715462e-07 0 4.974443445715462e-07 0.00021 4.974543445715462e-07 0 4.974543445715463e-07 0 4.974643445715462e-07 0.00021 4.974743445715462e-07 0 4.974743445715463e-07 0 4.974843445715462e-07 0.00021 4.974943445715462e-07 0 4.974943445715463e-07 0 4.975043445715463e-07 0.00021 4.975143445715462e-07 0 4.975523734521946e-07 0 4.975623734521946e-07 0.00021 4.975723734521945e-07 0 4.97585454861667e-07 0 4.97595454861667e-07 0.00021 4.976054548616669e-07 0 4.976395690114982e-07 0 4.976495690114982e-07 0.00021 4.976595690114982e-07 0 4.976595690114983e-07 0 4.976695690114982e-07 0.00021 4.976795690114982e-07 0 4.977252840546479e-07 0 4.977352840546478e-07 0.00021 4.977452840546478e-07 0 4.977890729188569e-07 0 4.977990729188568e-07 0.00021 4.978090729188568e-07 0 4.978090729188569e-07 0 4.978190729188569e-07 0.00021 4.978290729188568e-07 0 4.978290729188569e-07 0 4.978390729188569e-07 0.00021 4.978490729188568e-07 0 4.978490729188569e-07 0 4.978590729188569e-07 0.00021 4.978690729188569e-07 0 4.979117669628524e-07 0 4.979217669628523e-07 0.00021 4.979317669628523e-07 0 4.979678858652866e-07 0 4.979778858652866e-07 0.00021 4.979878858652865e-07 0 4.97989914888377e-07 0 4.97999914888377e-07 0.00021 4.980099148883769e-07 0 4.98009914888377e-07 0 4.98019914888377e-07 0.00021 4.98029914888377e-07 0 4.980683993021987e-07 0 4.980783993021986e-07 0.00021 4.980883993021986e-07 0 4.980958778397499e-07 0 4.981058778397498e-07 0.00021 4.981158778397498e-07 0 4.981167082445215e-07 0 4.981267082445214e-07 0.00021 4.981367082445214e-07 0 4.981526423502997e-07 0 4.981626423502996e-07 0.00021 4.981726423502996e-07 0 4.981833433412677e-07 0 4.981933433412676e-07 0.00021 4.982033433412676e-07 0 4.982033433412677e-07 0 4.982133433412676e-07 0.00021 4.982233433412676e-07 0 4.982233433412677e-07 0 4.982333433412677e-07 0.00021 4.982433433412676e-07 0 4.984005339390119e-07 0 4.984105339390119e-07 0.00021 4.984205339390118e-07 0 4.98420533939012e-07 0 4.984305339390119e-07 0.00021 4.984405339390119e-07 0 4.984585407804059e-07 0 4.984685407804059e-07 0.00021 4.984785407804058e-07 0 4.984785407804059e-07 0 4.984885407804059e-07 0.00021 4.984985407804058e-07 0 4.984985407804059e-07 0 4.985085407804059e-07 0.00021 4.985185407804059e-07 0 4.98518540780406e-07 0 4.985285407804059e-07 0.00021 4.985385407804059e-07 0 4.98538540780406e-07 0 4.985485407804059e-07 0.00021 4.985585407804059e-07 0 4.98558540780406e-07 0 4.98568540780406e-07 0.00021 4.985785407804059e-07 0 4.98578540780406e-07 0 4.98588540780406e-07 0.00021 4.985985407804059e-07 0 4.98598540780406e-07 0 4.98608540780406e-07 0.00021 4.98618540780406e-07 0 4.986185407804061e-07 0 4.98628540780406e-07 0.00021 4.98638540780406e-07 0 4.986385407804061e-07 0 4.986485407804061e-07 0.00021 4.98658540780406e-07 0 4.986585407804061e-07 0 4.986685407804061e-07 0.00021 4.98678540780406e-07 0 4.986785407804061e-07 0 4.986885407804061e-07 0.00021 4.986985407804061e-07 0 4.986985407804062e-07 0 4.987085407804061e-07 0.00021 4.987185407804061e-07 0 4.987493770976025e-07 0 4.987593770976025e-07 0.00021 4.987693770976024e-07 0 4.987797920546245e-07 0 4.987897920546244e-07 0.00021 4.987997920546244e-07 0 4.987997920546245e-07 0 4.988097920546245e-07 0.00021 4.988197920546244e-07 0 4.988423542469247e-07 0 4.988523542469247e-07 0.00021 4.988623542469246e-07 0 4.988658662040321e-07 0 4.98875866204032e-07 0.00021 4.98885866204032e-07 0 4.988858662040321e-07 0 4.988958662040321e-07 0.00021 4.98905866204032e-07 0 4.989058662040321e-07 0 4.989158662040321e-07 0.00021 4.98925866204032e-07 0 4.989258662040322e-07 0 4.989358662040321e-07 0.00021 4.989458662040321e-07 0 4.989458662040322e-07 0 4.989558662040321e-07 0.00021 4.989658662040321e-07 0 4.989658662040322e-07 0 4.989758662040322e-07 0.00021 4.989858662040321e-07 0 4.990589648394283e-07 0 4.990689648394283e-07 0.00021 4.990789648394282e-07 0 4.990789648394283e-07 0 4.990889648394283e-07 0.00021 4.990989648394282e-07 0 4.990989648394284e-07 0 4.991089648394283e-07 0.00021 4.991189648394283e-07 0 4.991189648394284e-07 0 4.991289648394283e-07 0.00021 4.991389648394283e-07 0 4.991389648394284e-07 0 4.991489648394284e-07 0.00021 4.991589648394283e-07 0 4.991589648394284e-07 0 4.991689648394284e-07 0.00021 4.991789648394283e-07 0 4.991789648394284e-07 0 4.991889648394284e-07 0.00021 4.991989648394284e-07 0 4.991989648394285e-07 0 4.992089648394284e-07 0.00021 4.992189648394284e-07 0 4.992206755025736e-07 0 4.992306755025736e-07 0.00021 4.992406755025735e-07 0 4.993170893910948e-07 0 4.993270893910947e-07 0.00021 4.993370893910947e-07 0 4.993425893794678e-07 0 4.993525893794678e-07 0.00021 4.993625893794678e-07 0 4.99369988773873e-07 0 4.99379988773873e-07 0.00021 4.99389988773873e-07 0 4.994724379642949e-07 0 4.994824379642949e-07 0.00021 4.994924379642948e-07 0 4.99492437964295e-07 0 4.995024379642949e-07 0.00021 4.995124379642949e-07 0 4.99512437964295e-07 0 4.995224379642949e-07 0.00021 4.995324379642949e-07 0 4.99532437964295e-07 0 4.99542437964295e-07 0.00021 4.995524379642949e-07 0 4.99552437964295e-07 0 4.99562437964295e-07 0.00021 4.995724379642949e-07 0 4.99572437964295e-07 0 4.99582437964295e-07 0.00021 4.99592437964295e-07 0 4.995924379642951e-07 0 4.99602437964295e-07 0.00021 4.99612437964295e-07 0 4.996124379642951e-07 0 4.99622437964295e-07 0.00021 4.99632437964295e-07 0 4.996324379642951e-07 0 4.996424379642951e-07 0.00021 4.99652437964295e-07 0 4.996524379642951e-07 0 4.996624379642951e-07 0.00021 4.99672437964295e-07 0 4.997062482288692e-07 0 4.997162482288692e-07 0.00021 4.997262482288691e-07 0 4.997308664248923e-07 0 4.997408664248922e-07 0.00021 4.997508664248922e-07 0 4.997604941689467e-07 0 4.997704941689466e-07 0.00021 4.997804941689466e-07 0 4.99802165197854e-07 0 4.998121651978539e-07 0.00021 4.998221651978539e-07 0 4.99822165197854e-07 0 4.998321651978539e-07 0.00021 4.998421651978539e-07 0 4.998536738090728e-07 0 4.998636738090728e-07 0.00021 4.998736738090727e-07 0 4.999366819507077e-07 0 4.999466819507077e-07 0.00021 4.999566819507076e-07 0 4.999658110380348e-07 0 4.999758110380347e-07 0.00021 4.999858110380347e-07 0 4.999858110380348e-07 0 4.999958110380348e-07 0.00021 5.000058110380347e-07 0 )
VIN3 3 0 pwl(0 0 1.9057991167082836e-10 0 2.0057991167082836e-10 0.00021 2.1057991167082835e-10 0 4.913610566032585e-10 0 5.013610566032585e-10 0.00021 5.113610566032584e-10 0 5.113610566032586e-10 0 5.213610566032585e-10 0.00021 5.313610566032585e-10 0 5.313610566032586e-10 0 5.413610566032585e-10 0.00021 5.513610566032585e-10 0 6.602246208665114e-10 0 6.702246208665114e-10 0.00021 6.802246208665114e-10 0 1.1410570490907352e-09 0 1.1510570490907352e-09 0.00021 1.1610570490907352e-09 0 1.3397640201275687e-09 0 1.3497640201275686e-09 0.00021 1.3597640201275686e-09 0 1.562577920686059e-09 0 1.572577920686059e-09 0.00021 1.582577920686059e-09 0 2.393529784513398e-09 0 2.4035297845133982e-09 0.00021 2.4135297845133984e-09 0 4.180566943243957e-09 0 4.190566943243957e-09 0.00021 4.200566943243957e-09 0 5.150063279322612e-09 0 5.160063279322612e-09 0.00021 5.170063279322612e-09 0 5.170063279322613e-09 0 5.1800632793226124e-09 0.00021 5.190063279322612e-09 0 5.819826091630123e-09 0 5.8298260916301224e-09 0.00021 5.839826091630122e-09 0 5.8412129086814905e-09 0 5.85121290868149e-09 0.00021 5.86121290868149e-09 0 6.156685997820849e-09 0 6.166685997820849e-09 0.00021 6.1766859978208486e-09 0 6.407121241536488e-09 0 6.4171212415364876e-09 0.00021 6.427121241536487e-09 0 7.336344294094343e-09 0 7.346344294094343e-09 0.00021 7.356344294094343e-09 0 7.440777256541352e-09 0 7.450777256541352e-09 0.00021 7.460777256541352e-09 0 7.531375042731714e-09 0 7.541375042731714e-09 0.00021 7.551375042731713e-09 0 7.97157976960389e-09 0 7.98157976960389e-09 0.00021 7.99157976960389e-09 0 7.99157976960389e-09 0 8.00157976960389e-09 0.00021 8.01157976960389e-09 0 8.022418597849744e-09 0 8.032418597849744e-09 0.00021 8.042418597849744e-09 0 8.326327039312215e-09 0 8.336327039312215e-09 0.00021 8.346327039312214e-09 0 8.554818763614308e-09 0 8.564818763614308e-09 0.00021 8.574818763614308e-09 0 9.0674339240763e-09 0 9.0774339240763e-09 0.00021 9.0874339240763e-09 0 9.189466599397538e-09 0 9.199466599397538e-09 0.00021 9.209466599397538e-09 0 9.321688774585237e-09 0 9.331688774585237e-09 0.00021 9.341688774585237e-09 0 9.868056018714424e-09 0 9.878056018714424e-09 0.00021 9.888056018714424e-09 0 1.0376994033700714e-08 0 1.0386994033700713e-08 0.00021 1.0396994033700713e-08 0 1.0472414519398139e-08 0 1.0482414519398139e-08 0.00021 1.0492414519398138e-08 0 1.0534589138557235e-08 0 1.0544589138557235e-08 0.00021 1.0554589138557235e-08 0 1.0895460856689083e-08 0 1.0905460856689083e-08 0.00021 1.0915460856689083e-08 0 1.1054266496653846e-08 0 1.1064266496653846e-08 0.00021 1.1074266496653845e-08 0 1.1306398599300468e-08 0 1.1316398599300468e-08 0.00021 1.1326398599300468e-08 0 1.161577165133006e-08 0 1.162577165133006e-08 0.00021 1.163577165133006e-08 0 1.19792619912799e-08 0 1.19892619912799e-08 0.00021 1.19992619912799e-08 0 1.2843071938707253e-08 0 1.2853071938707252e-08 0.00021 1.2863071938707252e-08 0 1.2888410122490754e-08 0 1.2898410122490754e-08 0.00021 1.2908410122490754e-08 0 1.3320822572470571e-08 0 1.333082257247057e-08 0.00021 1.334082257247057e-08 0 1.3652472643545999e-08 0 1.3662472643545999e-08 0.00021 1.3672472643545999e-08 0 1.4212397516953218e-08 0 1.4222397516953218e-08 0.00021 1.4232397516953218e-08 0 1.438910014932635e-08 0 1.4399100149326349e-08 0.00021 1.4409100149326349e-08 0 1.4527362125300717e-08 0 1.4537362125300716e-08 0.00021 1.4547362125300716e-08 0 1.47684087836616e-08 0 1.47784087836616e-08 0.00021 1.4788408783661599e-08 0 1.484642722077601e-08 0 1.485642722077601e-08 0.00021 1.486642722077601e-08 0 1.5066444855032548e-08 0 1.507644485503255e-08 0.00021 1.508644485503255e-08 0 1.5097733161546244e-08 0 1.5107733161546246e-08 0.00021 1.5117733161546247e-08 0 1.558358264267899e-08 0 1.5593582642678992e-08 0.00021 1.5603582642678994e-08 0 1.6255957902114884e-08 0 1.6265957902114885e-08 0.00021 1.6275957902114887e-08 0 1.6418828132103567e-08 0 1.642882813210357e-08 0.00021 1.643882813210357e-08 0 1.7351833763153156e-08 0 1.7361833763153157e-08 0.00021 1.737183376315316e-08 0 1.7383606039430537e-08 0 1.739360603943054e-08 0.00021 1.740360603943054e-08 0 1.7466071162694567e-08 0 1.7476071162694568e-08 0.00021 1.748607116269457e-08 0 1.755375952418913e-08 0 1.7563759524189132e-08 0.00021 1.7573759524189134e-08 0 1.7779008820583056e-08 0 1.7789008820583057e-08 0.00021 1.779900882058306e-08 0 1.805505367243036e-08 0 1.806505367243036e-08 0.00021 1.807505367243036e-08 0 1.821315680161147e-08 0 1.822315680161147e-08 0.00021 1.8233156801611472e-08 0 1.824990024167163e-08 0 1.8259900241671633e-08 0.00021 1.8269900241671634e-08 0 1.883930769185971e-08 0 1.8849307691859712e-08 0.00021 1.8859307691859713e-08 0 1.8986059546919924e-08 0 1.8996059546919925e-08 0.00021 1.9006059546919927e-08 0 1.9019562671744783e-08 0 1.9029562671744784e-08 0.00021 1.9039562671744786e-08 0 1.924707741786842e-08 0 1.925707741786842e-08 0.00021 1.9267077417868423e-08 0 1.933454481243e-08 0 1.9344544812430003e-08 0.00021 1.9354544812430004e-08 0 1.9457241839339765e-08 0 1.9467241839339766e-08 0.00021 1.9477241839339768e-08 0 1.9531543747764053e-08 0 1.9541543747764055e-08 0.00021 1.9551543747764056e-08 0 1.9683517838420575e-08 0 1.9693517838420577e-08 0.00021 1.9703517838420578e-08 0 1.9977840712928528e-08 0 1.998784071292853e-08 0.00021 1.999784071292853e-08 0 2.000640413785028e-08 0 2.0016404137850283e-08 0.00021 2.0026404137850284e-08 0 2.035525031989564e-08 0 2.0365250319895642e-08 0.00021 2.0375250319895643e-08 0 2.1204880634906475e-08 0 2.1214880634906476e-08 0.00021 2.1224880634906477e-08 0 2.1459979931926002e-08 0 2.1469979931926003e-08 0.00021 2.1479979931926005e-08 0 2.2550750599371843e-08 0 2.2560750599371845e-08 0.00021 2.2570750599371846e-08 0 2.270028526348105e-08 0 2.271028526348105e-08 0.00021 2.2720285263481052e-08 0 2.30796103578448e-08 0 2.30896103578448e-08 0.00021 2.30996103578448e-08 0 2.3675163475522742e-08 0 2.3685163475522744e-08 0.00021 2.3695163475522745e-08 0 2.392473103084215e-08 0 2.3934731030842153e-08 0.00021 2.3944731030842154e-08 0 2.4144230135415308e-08 0 2.415423013541531e-08 0.00021 2.416423013541531e-08 0 2.4321443247441345e-08 0 2.4331443247441346e-08 0.00021 2.4341443247441348e-08 0 2.434288302028115e-08 0 2.435288302028115e-08 0.00021 2.4362883020281152e-08 0 2.5656395325050738e-08 0 2.566639532505074e-08 0.00021 2.567639532505074e-08 0 2.6149139794512252e-08 0 2.6159139794512253e-08 0.00021 2.6169139794512255e-08 0 2.6303109776645527e-08 0 2.631310977664553e-08 0.00021 2.632310977664553e-08 0 2.6820844331380183e-08 0 2.6830844331380184e-08 0.00021 2.6840844331380185e-08 0 2.7120242910201046e-08 0 2.7130242910201048e-08 0.00021 2.714024291020105e-08 0 2.7140242910201046e-08 0 2.7150242910201047e-08 0.00021 2.716024291020105e-08 0 2.7528042974640787e-08 0 2.753804297464079e-08 0.00021 2.754804297464079e-08 0 2.7945076549969252e-08 0 2.7955076549969254e-08 0.00021 2.7965076549969255e-08 0 2.8094094681791282e-08 0 2.8104094681791283e-08 0.00021 2.8114094681791285e-08 0 2.811409468179128e-08 0 2.8124094681791283e-08 0.00021 2.8134094681791284e-08 0 2.890414798145934e-08 0 2.8914147981459343e-08 0.00021 2.8924147981459344e-08 0 2.9519896794467153e-08 0 2.9529896794467155e-08 0.00021 2.9539896794467156e-08 0 3.064223414362143e-08 0 3.065223414362143e-08 0.00021 3.0662234143621426e-08 0 3.066223414362143e-08 0 3.067223414362143e-08 0.00021 3.068223414362143e-08 0 3.150829321433503e-08 0 3.1518293214335026e-08 0.00021 3.1528293214335024e-08 0 3.2288358829604714e-08 0 3.229835882960471e-08 0.00021 3.230835882960471e-08 0 3.322805103761214e-08 0 3.3238051037612137e-08 0.00021 3.3248051037612135e-08 0 3.387369356159291e-08 0 3.388369356159291e-08 0.00021 3.3893693561592906e-08 0 3.397576163597677e-08 0 3.3985761635976766e-08 0.00021 3.3995761635976764e-08 0 3.4666626062070073e-08 0 3.467662606207007e-08 0.00021 3.468662606207007e-08 0 3.481894820672646e-08 0 3.482894820672646e-08 0.00021 3.483894820672646e-08 0 3.499868869430509e-08 0 3.500868869430509e-08 0.00021 3.501868869430509e-08 0 3.542279467822443e-08 0 3.543279467822443e-08 0.00021 3.5442794678224425e-08 0 3.567010241091076e-08 0 3.5680102410910756e-08 0.00021 3.5690102410910754e-08 0 3.592512129422115e-08 0 3.593512129422115e-08 0.00021 3.594512129422115e-08 0 3.595577120072393e-08 0 3.596577120072393e-08 0.00021 3.5975771200723926e-08 0 3.6165512526840005e-08 0 3.6175512526840003e-08 0.00021 3.618551252684e-08 0 3.727908159351249e-08 0 3.7289081593512485e-08 0.00021 3.7299081593512484e-08 0 3.7305557704490515e-08 0 3.731555770449051e-08 0.00021 3.732555770449051e-08 0 3.776354663459734e-08 0 3.777354663459734e-08 0.00021 3.778354663459734e-08 0 3.7783546634597346e-08 0 3.7793546634597344e-08 0.00021 3.780354663459734e-08 0 3.8272623887559196e-08 0 3.8282623887559194e-08 0.00021 3.829262388755919e-08 0 3.8453654517280166e-08 0 3.8463654517280164e-08 0.00021 3.847365451728016e-08 0 3.876388502388096e-08 0 3.8773885023880956e-08 0.00021 3.8783885023880954e-08 0 3.8809522808638077e-08 0 3.8819522808638075e-08 0.00021 3.882952280863807e-08 0 3.910385577019881e-08 0 3.9113855770198806e-08 0.00021 3.9123855770198804e-08 0 3.916231234313473e-08 0 3.917231234313473e-08 0.00021 3.918231234313473e-08 0 3.9342361051240585e-08 0 3.935236105124058e-08 0.00021 3.936236105124058e-08 0 3.9604638172288096e-08 0 3.9614638172288094e-08 0.00021 3.962463817228809e-08 0 3.973901019412785e-08 0 3.9749010194127846e-08 0.00021 3.9759010194127844e-08 0 3.979363378331621e-08 0 3.9803633783316206e-08 0.00021 3.9813633783316205e-08 0 3.9982744349061966e-08 0 3.9992744349061964e-08 0.00021 4.000274434906196e-08 0 4.0072788596031935e-08 0 4.008278859603193e-08 0.00021 4.009278859603193e-08 0 4.010053518641724e-08 0 4.0110535186417236e-08 0.00021 4.0120535186417234e-08 0 4.084029089328152e-08 0 4.085029089328152e-08 0.00021 4.086029089328152e-08 0 4.130522897498888e-08 0 4.131522897498888e-08 0.00021 4.1325228974988875e-08 0 4.153724996881672e-08 0 4.1547249968816715e-08 0.00021 4.1557249968816713e-08 0 4.2145133495824113e-08 0 4.215513349582411e-08 0.00021 4.216513349582411e-08 0 4.228978566127748e-08 0 4.229978566127748e-08 0.00021 4.230978566127748e-08 0 4.237424424440175e-08 0 4.238424424440175e-08 0.00021 4.239424424440175e-08 0 4.250165939564526e-08 0 4.2511659395645256e-08 0.00021 4.2521659395645254e-08 0 4.3335830412914265e-08 0 4.3345830412914263e-08 0.00021 4.335583041291426e-08 0 4.346508617153987e-08 0 4.3475086171539867e-08 0.00021 4.3485086171539865e-08 0 4.399690343240546e-08 0 4.400690343240546e-08 0.00021 4.401690343240546e-08 0 4.43264305500718e-08 0 4.43364305500718e-08 0.00021 4.4346430550071796e-08 0 4.441955877400845e-08 0 4.442955877400845e-08 0.00021 4.443955877400845e-08 0 4.4584117699630876e-08 0 4.4594117699630874e-08 0.00021 4.460411769963087e-08 0 4.4680867265967196e-08 0 4.4690867265967194e-08 0.00021 4.470086726596719e-08 0 4.4766370715463145e-08 0 4.477637071546314e-08 0.00021 4.478637071546314e-08 0 4.514231430547413e-08 0 4.515231430547413e-08 0.00021 4.5162314305474126e-08 0 4.563235120470112e-08 0 4.564235120470112e-08 0.00021 4.5652351204701116e-08 0 4.565235120470112e-08 0 4.566235120470112e-08 0.00021 4.567235120470112e-08 0 4.629344078137024e-08 0 4.630344078137024e-08 0.00021 4.631344078137024e-08 0 4.6567836230084103e-08 0 4.65778362300841e-08 0.00021 4.65878362300841e-08 0 4.7220837468563705e-08 0 4.72308374685637e-08 0.00021 4.72408374685637e-08 0 4.724083746856371e-08 0 4.7250837468563706e-08 0.00021 4.7260837468563704e-08 0 4.7640165365138193e-08 0 4.765016536513819e-08 0.00021 4.766016536513819e-08 0 4.766692052581214e-08 0 4.767692052581214e-08 0.00021 4.7686920525812136e-08 0 4.794019769261838e-08 0 4.795019769261838e-08 0.00021 4.796019769261838e-08 0 4.864279853760329e-08 0 4.865279853760329e-08 0.00021 4.866279853760329e-08 0 4.893940784159846e-08 0 4.894940784159846e-08 0.00021 4.895940784159846e-08 0 5.000451717818151e-08 0 5.001451717818151e-08 0.00021 5.002451717818151e-08 0 5.008527250663362e-08 0 5.009527250663362e-08 0.00021 5.010527250663362e-08 0 5.124850519152483e-08 0 5.125850519152483e-08 0.00021 5.126850519152483e-08 0 5.129644047668362e-08 0 5.130644047668362e-08 0.00021 5.1316440476683616e-08 0 5.195716586560323e-08 0 5.1967165865603226e-08 0.00021 5.1977165865603224e-08 0 5.2165779933161154e-08 0 5.217577993316115e-08 0.00021 5.218577993316115e-08 0 5.240128631283826e-08 0 5.2411286312838256e-08 0.00021 5.2421286312838254e-08 0 5.2605312098634625e-08 0 5.261531209863462e-08 0.00021 5.262531209863462e-08 0 5.279306381674257e-08 0 5.280306381674257e-08 0.00021 5.281306381674257e-08 0 5.3629922890128686e-08 0 5.3639922890128684e-08 0.00021 5.364992289012868e-08 0 5.3984188754560245e-08 0 5.3994188754560243e-08 0.00021 5.400418875456024e-08 0 5.413695723886e-08 0 5.414695723886e-08 0.00021 5.415695723886e-08 0 5.422362629293565e-08 0 5.4233626292935645e-08 0.00021 5.4243626292935644e-08 0 5.425243149785006e-08 0 5.4262431497850055e-08 0.00021 5.427243149785005e-08 0 5.500425143827011e-08 0 5.501425143827011e-08 0.00021 5.502425143827011e-08 0 5.5776866455646816e-08 0 5.5786866455646814e-08 0.00021 5.579686645564681e-08 0 5.5978758017093605e-08 0 5.59887580170936e-08 0.00021 5.59987580170936e-08 0 5.6262430271697844e-08 0 5.627243027169784e-08 0.00021 5.628243027169784e-08 0 5.6839140114066316e-08 0 5.6849140114066314e-08 0.00021 5.685914011406631e-08 0 5.7359769433771086e-08 0 5.7369769433771084e-08 0.00021 5.737976943377108e-08 0 5.76253721745485e-08 0 5.7635372174548495e-08 0.00021 5.7645372174548494e-08 0 5.7739114972360996e-08 0 5.7749114972360994e-08 0.00021 5.775911497236099e-08 0 5.794490262367315e-08 0 5.7954902623673145e-08 0.00021 5.7964902623673143e-08 0 5.866623269893488e-08 0 5.867623269893488e-08 0.00021 5.8686232698934876e-08 0 5.915976137257861e-08 0 5.9169761372578605e-08 0.00021 5.91797613725786e-08 0 5.921767006969734e-08 0 5.922767006969734e-08 0.00021 5.9237670069697337e-08 0 5.9381971643236386e-08 0 5.9391971643236384e-08 0.00021 5.940197164323638e-08 0 6.058502252319957e-08 0 6.059502252319957e-08 0.00021 6.060502252319957e-08 0 6.075472438792847e-08 0 6.076472438792847e-08 0.00021 6.077472438792847e-08 0 6.112300047950257e-08 0 6.113300047950257e-08 0.00021 6.114300047950257e-08 0 6.132093872565502e-08 0 6.133093872565501e-08 0.00021 6.134093872565501e-08 0 6.149825157142653e-08 0 6.150825157142653e-08 0.00021 6.151825157142652e-08 0 6.163997439161613e-08 0 6.164997439161613e-08 0.00021 6.165997439161612e-08 0 6.1822079446207e-08 0 6.1832079446207e-08 0.00021 6.184207944620699e-08 0 6.250531256201779e-08 0 6.251531256201779e-08 0.00021 6.252531256201779e-08 0 6.283630751585548e-08 0 6.284630751585547e-08 0.00021 6.285630751585547e-08 0 6.285630751585547e-08 0 6.286630751585547e-08 0.00021 6.287630751585547e-08 0 6.318034676132261e-08 0 6.31903467613226e-08 0.00021 6.32003467613226e-08 0 6.352572568941624e-08 0 6.353572568941624e-08 0.00021 6.354572568941624e-08 0 6.379097181828701e-08 0 6.380097181828701e-08 0.00021 6.381097181828701e-08 0 6.416094047487535e-08 0 6.417094047487534e-08 0.00021 6.418094047487534e-08 0 6.437254877827673e-08 0 6.438254877827673e-08 0.00021 6.439254877827673e-08 0 6.474547090302036e-08 0 6.475547090302035e-08 0.00021 6.476547090302035e-08 0 6.487530921144535e-08 0 6.488530921144535e-08 0.00021 6.489530921144535e-08 0 6.498868589738337e-08 0 6.499868589738337e-08 0.00021 6.500868589738337e-08 0 6.54338945059266e-08 0 6.54438945059266e-08 0.00021 6.54538945059266e-08 0 6.593347127424498e-08 0 6.594347127424498e-08 0.00021 6.595347127424498e-08 0 6.599737024329372e-08 0 6.600737024329372e-08 0.00021 6.601737024329372e-08 0 6.633255445091165e-08 0 6.634255445091165e-08 0.00021 6.635255445091165e-08 0 6.661208441690244e-08 0 6.662208441690244e-08 0.00021 6.663208441690244e-08 0 6.681988432787333e-08 0 6.682988432787332e-08 0.00021 6.683988432787332e-08 0 6.717229632792385e-08 0 6.718229632792384e-08 0.00021 6.719229632792384e-08 0 6.729249727706597e-08 0 6.730249727706596e-08 0.00021 6.731249727706596e-08 0 6.75722988571682e-08 0 6.75822988571682e-08 0.00021 6.75922988571682e-08 0 6.765739633493561e-08 0 6.766739633493561e-08 0.00021 6.76773963349356e-08 0 6.76773963349356e-08 0 6.76873963349356e-08 0.00021 6.76973963349356e-08 0 6.799629176881201e-08 0 6.800629176881201e-08 0.00021 6.801629176881201e-08 0 6.80889851550534e-08 0 6.80989851550534e-08 0.00021 6.81089851550534e-08 0 6.840826388975092e-08 0 6.841826388975092e-08 0.00021 6.842826388975092e-08 0 6.942054779574039e-08 0 6.943054779574038e-08 0.00021 6.944054779574038e-08 0 6.993932338150869e-08 0 6.994932338150869e-08 0.00021 6.995932338150869e-08 0 6.998801545521532e-08 0 6.999801545521532e-08 0.00021 7.000801545521532e-08 0 7.001734176317047e-08 0 7.002734176317047e-08 0.00021 7.003734176317046e-08 0 7.006664251984838e-08 0 7.007664251984838e-08 0.00021 7.008664251984838e-08 0 7.060399815430478e-08 0 7.061399815430478e-08 0.00021 7.062399815430478e-08 0 7.101978227581665e-08 0 7.102978227581665e-08 0.00021 7.103978227581665e-08 0 7.125007843542912e-08 0 7.126007843542911e-08 0.00021 7.127007843542911e-08 0 7.129228704262052e-08 0 7.130228704262052e-08 0.00021 7.131228704262052e-08 0 7.137765948669391e-08 0 7.13876594866939e-08 0.00021 7.13976594866939e-08 0 7.143899628549017e-08 0 7.144899628549017e-08 0.00021 7.145899628549017e-08 0 7.154037019944547e-08 0 7.155037019944547e-08 0.00021 7.156037019944547e-08 0 7.168970370614647e-08 0 7.169970370614647e-08 0.00021 7.170970370614647e-08 0 7.193418054043266e-08 0 7.194418054043266e-08 0.00021 7.195418054043266e-08 0 7.211266093399498e-08 0 7.212266093399498e-08 0.00021 7.213266093399497e-08 0 7.22276632410955e-08 0 7.22376632410955e-08 0.00021 7.22476632410955e-08 0 7.246417364292229e-08 0 7.247417364292229e-08 0.00021 7.248417364292229e-08 0 7.261694463656748e-08 0 7.262694463656748e-08 0.00021 7.263694463656748e-08 0 7.291790431033148e-08 0 7.292790431033148e-08 0.00021 7.293790431033148e-08 0 7.308424219738994e-08 0 7.309424219738993e-08 0.00021 7.310424219738993e-08 0 7.3761983824537e-08 0 7.3771983824537e-08 0.00021 7.378198382453699e-08 0 7.381151673198649e-08 0 7.382151673198649e-08 0.00021 7.383151673198648e-08 0 7.427196133704032e-08 0 7.428196133704032e-08 0.00021 7.429196133704032e-08 0 7.566173866736207e-08 0 7.567173866736207e-08 0.00021 7.568173866736207e-08 0 7.589710851776872e-08 0 7.590710851776872e-08 0.00021 7.591710851776871e-08 0 7.651261839830247e-08 0 7.652261839830247e-08 0.00021 7.653261839830247e-08 0 7.706007885039361e-08 0 7.707007885039361e-08 0.00021 7.708007885039361e-08 0 7.789775653031335e-08 0 7.790775653031335e-08 0.00021 7.791775653031335e-08 0 7.845874107993162e-08 0 7.846874107993161e-08 0.00021 7.847874107993161e-08 0 7.847874107993161e-08 0 7.848874107993161e-08 0.00021 7.849874107993161e-08 0 7.898027474669943e-08 0 7.899027474669943e-08 0.00021 7.900027474669943e-08 0 7.921641367663096e-08 0 7.922641367663096e-08 0.00021 7.923641367663096e-08 0 7.942220686818206e-08 0 7.943220686818206e-08 0.00021 7.944220686818206e-08 0 8.002808938755865e-08 0 8.003808938755865e-08 0.00021 8.004808938755865e-08 0 8.06392987576696e-08 0 8.06492987576696e-08 0.00021 8.06592987576696e-08 0 8.071813726724937e-08 0 8.072813726724936e-08 0.00021 8.073813726724936e-08 0 8.087363600337551e-08 0 8.088363600337551e-08 0.00021 8.08936360033755e-08 0 8.168677075398484e-08 0 8.169677075398484e-08 0.00021 8.170677075398483e-08 0 8.197406514265639e-08 0 8.198406514265639e-08 0.00021 8.199406514265639e-08 0 8.204055673947139e-08 0 8.205055673947139e-08 0.00021 8.206055673947138e-08 0 8.408445378279862e-08 0 8.409445378279861e-08 0.00021 8.410445378279861e-08 0 8.412943554817438e-08 0 8.413943554817438e-08 0.00021 8.414943554817438e-08 0 8.426436330926832e-08 0 8.427436330926832e-08 0.00021 8.428436330926832e-08 0 8.437077536589584e-08 0 8.438077536589584e-08 0.00021 8.439077536589584e-08 0 8.459931982641353e-08 0 8.460931982641352e-08 0.00021 8.461931982641352e-08 0 8.473314106869704e-08 0 8.474314106869703e-08 0.00021 8.475314106869703e-08 0 8.490492524033784e-08 0 8.491492524033784e-08 0.00021 8.492492524033784e-08 0 8.492492524033784e-08 0 8.493492524033783e-08 0.00021 8.494492524033783e-08 0 8.494492524033783e-08 0 8.495492524033783e-08 0.00021 8.496492524033783e-08 0 8.587371991312851e-08 0 8.58837199131285e-08 0.00021 8.58937199131285e-08 0 8.593522554990004e-08 0 8.594522554990004e-08 0.00021 8.595522554990004e-08 0 8.646770121851214e-08 0 8.647770121851214e-08 0.00021 8.648770121851213e-08 0 8.751761362076458e-08 0 8.752761362076457e-08 0.00021 8.753761362076457e-08 0 8.788965015625445e-08 0 8.789965015625444e-08 0.00021 8.790965015625444e-08 0 8.86357533724134e-08 0 8.86457533724134e-08 0.00021 8.86557533724134e-08 0 8.894927641386308e-08 0 8.895927641386308e-08 0.00021 8.896927641386308e-08 0 8.937959738296914e-08 0 8.938959738296914e-08 0.00021 8.939959738296914e-08 0 9.003256125525266e-08 0 9.004256125525265e-08 0.00021 9.005256125525265e-08 0 9.05874551437184e-08 0 9.059745514371839e-08 0.00021 9.060745514371839e-08 0 9.098729448982003e-08 0 9.099729448982003e-08 0.00021 9.100729448982003e-08 0 9.14242241482698e-08 0 9.14342241482698e-08 0.00021 9.14442241482698e-08 0 9.176053410286021e-08 0 9.177053410286021e-08 0.00021 9.178053410286021e-08 0 9.25449575329268e-08 0 9.255495753292679e-08 0.00021 9.256495753292679e-08 0 9.27481881120459e-08 0 9.27581881120459e-08 0.00021 9.27681881120459e-08 0 9.280686349190668e-08 0 9.281686349190668e-08 0.00021 9.282686349190668e-08 0 9.31414019410347e-08 0 9.31514019410347e-08 0.00021 9.31614019410347e-08 0 9.378543751495225e-08 0 9.379543751495225e-08 0.00021 9.380543751495225e-08 0 9.382130413350466e-08 0 9.383130413350465e-08 0.00021 9.384130413350465e-08 0 9.401999932280948e-08 0 9.402999932280948e-08 0.00021 9.403999932280948e-08 0 9.412513315569663e-08 0 9.413513315569663e-08 0.00021 9.414513315569663e-08 0 9.432291736203864e-08 0 9.433291736203864e-08 0.00021 9.434291736203864e-08 0 9.441977596280397e-08 0 9.442977596280396e-08 0.00021 9.443977596280396e-08 0 9.482279411592762e-08 0 9.483279411592762e-08 0.00021 9.484279411592762e-08 0 9.524003890169045e-08 0 9.525003890169045e-08 0.00021 9.526003890169045e-08 0 9.529266539626562e-08 0 9.530266539626562e-08 0.00021 9.531266539626561e-08 0 9.579552458058961e-08 0 9.580552458058961e-08 0.00021 9.581552458058961e-08 0 9.617761353470951e-08 0 9.61876135347095e-08 0.00021 9.61976135347095e-08 0 9.67594628992094e-08 0 9.67694628992094e-08 0.00021 9.67794628992094e-08 0 9.770361833351981e-08 0 9.771361833351981e-08 0.00021 9.77236183335198e-08 0 9.780605524417178e-08 0 9.781605524417177e-08 0.00021 9.782605524417177e-08 0 9.782662519757452e-08 0 9.783662519757452e-08 0.00021 9.784662519757452e-08 0 9.800118595493789e-08 0 9.801118595493789e-08 0.00021 9.802118595493789e-08 0 9.85133163678385e-08 0 9.852331636783849e-08 0.00021 9.853331636783849e-08 0 9.880492243765013e-08 0 9.881492243765013e-08 0.00021 9.882492243765013e-08 0 9.934752293227092e-08 0 9.935752293227091e-08 0.00021 9.936752293227091e-08 0 9.94083773513186e-08 0 9.94183773513186e-08 0.00021 9.94283773513186e-08 0 1.0180635987178342e-07 0 1.0181635987178342e-07 0.00021 1.0182635987178342e-07 0 1.0182635987178342e-07 0 1.0183635987178341e-07 0.00021 1.0184635987178341e-07 0 1.0204956040001813e-07 0 1.0205956040001813e-07 0.00021 1.0206956040001813e-07 0 1.0235477859222648e-07 0 1.0236477859222648e-07 0.00021 1.0237477859222648e-07 0 1.0252264721388456e-07 0 1.0253264721388455e-07 0.00021 1.0254264721388455e-07 0 1.029000709650771e-07 0 1.029100709650771e-07 0.00021 1.029200709650771e-07 0 1.03032707578004e-07 0 1.03042707578004e-07 0.00021 1.0305270757800399e-07 0 1.0315498158682569e-07 0 1.0316498158682569e-07 0.00021 1.0317498158682569e-07 0 1.0361970291966596e-07 0 1.0362970291966596e-07 0.00021 1.0363970291966595e-07 0 1.0404343107865485e-07 0 1.0405343107865484e-07 0.00021 1.0406343107865484e-07 0 1.0419294198402045e-07 0 1.0420294198402044e-07 0.00021 1.0421294198402044e-07 0 1.0424331010249164e-07 0 1.0425331010249164e-07 0.00021 1.0426331010249163e-07 0 1.0451165319420421e-07 0 1.0452165319420421e-07 0.00021 1.045316531942042e-07 0 1.0473816378152243e-07 0 1.0474816378152243e-07 0.00021 1.0475816378152243e-07 0 1.0490038393971039e-07 0 1.0491038393971039e-07 0.00021 1.0492038393971038e-07 0 1.050979856937381e-07 0 1.0510798569373809e-07 0.00021 1.0511798569373809e-07 0 1.0516297112715611e-07 0 1.0517297112715611e-07 0.00021 1.051829711271561e-07 0 1.0531016388158904e-07 0 1.0532016388158903e-07 0.00021 1.0533016388158903e-07 0 1.0591879086151847e-07 0 1.0592879086151847e-07 0.00021 1.0593879086151847e-07 0 1.0593879086151847e-07 0 1.0594879086151847e-07 0.00021 1.0595879086151846e-07 0 1.0595879086151846e-07 0 1.0596879086151846e-07 0.00021 1.0597879086151846e-07 0 1.0601206896974768e-07 0 1.0602206896974768e-07 0.00021 1.0603206896974768e-07 0 1.0632670739449279e-07 0 1.0633670739449279e-07 0.00021 1.0634670739449279e-07 0 1.066052235794647e-07 0 1.066152235794647e-07 0.00021 1.066252235794647e-07 0 1.0676841799607437e-07 0 1.0677841799607437e-07 0.00021 1.0678841799607437e-07 0 1.0682447467449722e-07 0 1.0683447467449722e-07 0.00021 1.0684447467449722e-07 0 1.0684447467449722e-07 0 1.0685447467449722e-07 0.00021 1.0686447467449722e-07 0 1.071842079811676e-07 0 1.071942079811676e-07 0.00021 1.072042079811676e-07 0 1.0731007666305481e-07 0 1.073200766630548e-07 0.00021 1.073300766630548e-07 0 1.0768431413107493e-07 0 1.0769431413107493e-07 0.00021 1.0770431413107493e-07 0 1.0841078104601794e-07 0 1.0842078104601794e-07 0.00021 1.0843078104601794e-07 0 1.0843078104601794e-07 0 1.0844078104601793e-07 0.00021 1.0845078104601793e-07 0 1.0853123455260445e-07 0 1.0854123455260445e-07 0.00021 1.0855123455260445e-07 0 1.0933358134335341e-07 0 1.0934358134335341e-07 0.00021 1.0935358134335341e-07 0 1.0937853925202532e-07 0 1.0938853925202532e-07 0.00021 1.0939853925202532e-07 0 1.0992862513939457e-07 0 1.0993862513939456e-07 0.00021 1.0994862513939456e-07 0 1.106732754190705e-07 0 1.106832754190705e-07 0.00021 1.1069327541907049e-07 0 1.1073539364264734e-07 0 1.1074539364264734e-07 0.00021 1.1075539364264734e-07 0 1.1163717126829572e-07 0 1.1164717126829572e-07 0.00021 1.1165717126829572e-07 0 1.1175943369523375e-07 0 1.1176943369523375e-07 0.00021 1.1177943369523374e-07 0 1.1184449871730014e-07 0 1.1185449871730013e-07 0.00021 1.1186449871730013e-07 0 1.1186449871730013e-07 0 1.1187449871730013e-07 0.00021 1.1188449871730013e-07 0 1.1211913730536596e-07 0 1.1212913730536596e-07 0.00021 1.1213913730536596e-07 0 1.124605871549673e-07 0 1.124705871549673e-07 0.00021 1.124805871549673e-07 0 1.1299722963670077e-07 0 1.1300722963670077e-07 0.00021 1.1301722963670077e-07 0 1.1323590584027997e-07 0 1.1324590584027997e-07 0.00021 1.1325590584027997e-07 0 1.1355537669732878e-07 0 1.1356537669732878e-07 0.00021 1.1357537669732878e-07 0 1.1395046543061402e-07 0 1.1396046543061402e-07 0.00021 1.1397046543061401e-07 0 1.1422255349318617e-07 0 1.1423255349318617e-07 0.00021 1.1424255349318617e-07 0 1.1427282534570134e-07 0 1.1428282534570134e-07 0.00021 1.1429282534570133e-07 0 1.1429282534570133e-07 0 1.1430282534570133e-07 0.00021 1.1431282534570133e-07 0 1.1431282534570133e-07 0 1.1432282534570133e-07 0.00021 1.1433282534570133e-07 0 1.1479642158276749e-07 0 1.1480642158276749e-07 0.00021 1.1481642158276749e-07 0 1.1482217973465515e-07 0 1.1483217973465515e-07 0.00021 1.1484217973465514e-07 0 1.1525744254185488e-07 0 1.1526744254185488e-07 0.00021 1.1527744254185487e-07 0 1.1527744254185487e-07 0 1.1528744254185487e-07 0.00021 1.1529744254185487e-07 0 1.1532594844658602e-07 0 1.1533594844658602e-07 0.00021 1.1534594844658601e-07 0 1.1551464560412071e-07 0 1.1552464560412071e-07 0.00021 1.1553464560412071e-07 0 1.1577681634709543e-07 0 1.1578681634709542e-07 0.00021 1.1579681634709542e-07 0 1.1607779948030039e-07 0 1.1608779948030038e-07 0.00021 1.1609779948030038e-07 0 1.1626629598969503e-07 0 1.1627629598969503e-07 0.00021 1.1628629598969503e-07 0 1.1706585308793983e-07 0 1.1707585308793983e-07 0.00021 1.1708585308793982e-07 0 1.1716425630077377e-07 0 1.1717425630077377e-07 0.00021 1.1718425630077376e-07 0 1.1745809120068527e-07 0 1.1746809120068527e-07 0.00021 1.1747809120068527e-07 0 1.1754004458728916e-07 0 1.1755004458728916e-07 0.00021 1.1756004458728916e-07 0 1.177101596149075e-07 0 1.177201596149075e-07 0.00021 1.177301596149075e-07 0 1.177301596149075e-07 0 1.177401596149075e-07 0.00021 1.177501596149075e-07 0 1.177501596149075e-07 0 1.177601596149075e-07 0.00021 1.177701596149075e-07 0 1.1844632652599084e-07 0 1.1845632652599084e-07 0.00021 1.1846632652599084e-07 0 1.185211449731569e-07 0 1.1853114497315689e-07 0.00021 1.1854114497315689e-07 0 1.1924900692209246e-07 0 1.1925900692209247e-07 0.00021 1.1926900692209248e-07 0 1.1968529903739505e-07 0 1.1969529903739506e-07 0.00021 1.1970529903739507e-07 0 1.1981844316041363e-07 0 1.1982844316041364e-07 0.00021 1.1983844316041365e-07 0 1.199728212213517e-07 0 1.1998282122135171e-07 0.00021 1.1999282122135173e-07 0 1.2034623605630005e-07 0 1.2035623605630006e-07 0.00021 1.2036623605630007e-07 0 1.205348342143099e-07 0 1.205448342143099e-07 0.00021 1.2055483421430991e-07 0 1.2109592535735032e-07 0 1.2110592535735033e-07 0.00021 1.2111592535735034e-07 0 1.218304714538763e-07 0 1.218404714538763e-07 0.00021 1.2185047145387632e-07 0 1.2198671276033977e-07 0 1.2199671276033978e-07 0.00021 1.220067127603398e-07 0 1.2219897662095261e-07 0 1.2220897662095263e-07 0.00021 1.2221897662095264e-07 0 1.2278453312602646e-07 0 1.2279453312602647e-07 0.00021 1.2280453312602648e-07 0 1.23013493580726e-07 0 1.2302349358072602e-07 0.00021 1.2303349358072603e-07 0 1.233142630828928e-07 0 1.2332426308289282e-07 0.00021 1.2333426308289283e-07 0 1.23383576732258e-07 0 1.2339357673225802e-07 0.00021 1.2340357673225803e-07 0 1.237964759517623e-07 0 1.2380647595176232e-07 0.00021 1.2381647595176233e-07 0 1.246088670681813e-07 0 1.2461886706818131e-07 0.00021 1.2462886706818133e-07 0 1.246443698339245e-07 0 1.2465436983392452e-07 0.00021 1.2466436983392453e-07 0 1.2575890265886405e-07 0 1.2576890265886406e-07 0.00021 1.2577890265886407e-07 0 1.2578605896754327e-07 0 1.2579605896754328e-07 0.00021 1.258060589675433e-07 0 1.2580605896754327e-07 0 1.2581605896754328e-07 0.00021 1.258260589675433e-07 0 1.2612725656842994e-07 0 1.2613725656842996e-07 0.00021 1.2614725656842997e-07 0 1.2730457983860727e-07 0 1.2731457983860728e-07 0.00021 1.273245798386073e-07 0 1.2754259820222294e-07 0 1.2755259820222295e-07 0.00021 1.2756259820222296e-07 0 1.2773796233901784e-07 0 1.2774796233901785e-07 0.00021 1.2775796233901786e-07 0 1.2776652638179487e-07 0 1.2777652638179488e-07 0.00021 1.277865263817949e-07 0 1.2801388041229018e-07 0 1.280238804122902e-07 0.00021 1.280338804122902e-07 0 1.2876008823903412e-07 0 1.2877008823903414e-07 0.00021 1.2878008823903415e-07 0 1.2898805353049607e-07 0 1.2899805353049608e-07 0.00021 1.290080535304961e-07 0 1.290535830398117e-07 0 1.290635830398117e-07 0.00021 1.2907358303981172e-07 0 1.302552087639884e-07 0 1.302652087639884e-07 0.00021 1.3027520876398841e-07 0 1.3072617681843842e-07 0 1.3073617681843843e-07 0.00021 1.3074617681843844e-07 0 1.3128422438630125e-07 0 1.3129422438630126e-07 0.00021 1.3130422438630127e-07 0 1.3207680158007216e-07 0 1.3208680158007217e-07 0.00021 1.3209680158007218e-07 0 1.3260283335986654e-07 0 1.3261283335986655e-07 0.00021 1.3262283335986657e-07 0 1.329125090712236e-07 0 1.329225090712236e-07 0.00021 1.3293250907122362e-07 0 1.3313730714299582e-07 0 1.3314730714299583e-07 0.00021 1.3315730714299585e-07 0 1.3320006373999137e-07 0 1.3321006373999139e-07 0.00021 1.332200637399914e-07 0 1.3496559403561101e-07 0 1.3497559403561103e-07 0.00021 1.3498559403561104e-07 0 1.3501379050721611e-07 0 1.3502379050721612e-07 0.00021 1.3503379050721614e-07 0 1.3537866535794044e-07 0 1.3538866535794045e-07 0.00021 1.3539866535794046e-07 0 1.3546705367250473e-07 0 1.3547705367250474e-07 0.00021 1.3548705367250475e-07 0 1.3571946276275768e-07 0 1.357294627627577e-07 0.00021 1.357394627627577e-07 0 1.360614298346027e-07 0 1.360714298346027e-07 0.00021 1.3608142983460272e-07 0 1.3613958962507674e-07 0 1.3614958962507675e-07 0.00021 1.3615958962507677e-07 0 1.3648612506250203e-07 0 1.3649612506250204e-07 0.00021 1.3650612506250205e-07 0 1.367677862843325e-07 0 1.3677778628433252e-07 0.00021 1.3678778628433253e-07 0 1.3710588928683607e-07 0 1.3711588928683608e-07 0.00021 1.371258892868361e-07 0 1.3735090210312357e-07 0 1.3736090210312358e-07 0.00021 1.373709021031236e-07 0 1.3771564934587522e-07 0 1.3772564934587523e-07 0.00021 1.3773564934587524e-07 0 1.3783387261847733e-07 0 1.3784387261847734e-07 0.00021 1.3785387261847736e-07 0 1.3867498889307456e-07 0 1.3868498889307457e-07 0.00021 1.3869498889307458e-07 0 1.3887830013108556e-07 0 1.3888830013108557e-07 0.00021 1.3889830013108558e-07 0 1.389888394574142e-07 0 1.3899883945741421e-07 0.00021 1.3900883945741423e-07 0 1.3906099956161207e-07 0 1.3907099956161208e-07 0.00021 1.390809995616121e-07 0 1.3922489726729734e-07 0 1.3923489726729735e-07 0.00021 1.3924489726729736e-07 0 1.3934461644238733e-07 0 1.3935461644238734e-07 0.00021 1.3936461644238735e-07 0 1.3948268872915064e-07 0 1.3949268872915065e-07 0.00021 1.3950268872915067e-07 0 1.399984238440869e-07 0 1.400084238440869e-07 0.00021 1.4001842384408692e-07 0 1.405971237391279e-07 0 1.4060712373912792e-07 0.00021 1.4061712373912793e-07 0 1.4093048834449214e-07 0 1.4094048834449215e-07 0.00021 1.4095048834449216e-07 0 1.4120602007686477e-07 0 1.4121602007686478e-07 0.00021 1.412260200768648e-07 0 1.4142140471226377e-07 0 1.4143140471226379e-07 0.00021 1.414414047122638e-07 0 1.418615618422009e-07 0 1.418715618422009e-07 0.00021 1.418815618422009e-07 0 1.4191137586343756e-07 0 1.4192137586343757e-07 0.00021 1.4193137586343758e-07 0 1.4202859325752717e-07 0 1.4203859325752718e-07 0.00021 1.420485932575272e-07 0 1.4207767244260024e-07 0 1.4208767244260025e-07 0.00021 1.4209767244260027e-07 0 1.4234881991082316e-07 0 1.4235881991082317e-07 0.00021 1.4236881991082318e-07 0 1.4258377804316074e-07 0 1.4259377804316075e-07 0.00021 1.4260377804316076e-07 0 1.427163616669826e-07 0 1.427263616669826e-07 0.00021 1.4273636166698262e-07 0 1.429140963632808e-07 0 1.429240963632808e-07 0.00021 1.4293409636328082e-07 0 1.430070226152359e-07 0 1.430170226152359e-07 0.00021 1.4302702261523592e-07 0 1.4319712495772817e-07 0 1.4320712495772818e-07 0.00021 1.432171249577282e-07 0 1.4322386214740662e-07 0 1.4323386214740663e-07 0.00021 1.4324386214740664e-07 0 1.4324541270615098e-07 0 1.43255412706151e-07 0.00021 1.43265412706151e-07 0 1.4382469927739183e-07 0 1.4383469927739184e-07 0.00021 1.4384469927739185e-07 0 1.4434299276318013e-07 0 1.4435299276318015e-07 0.00021 1.4436299276318016e-07 0 1.4436823210726257e-07 0 1.4437823210726258e-07 0.00021 1.443882321072626e-07 0 1.4443253350181904e-07 0 1.4444253350181905e-07 0.00021 1.4445253350181906e-07 0 1.446925516298024e-07 0 1.447025516298024e-07 0.00021 1.4471255162980242e-07 0 1.4521364897821285e-07 0 1.4522364897821286e-07 0.00021 1.4523364897821287e-07 0 1.4590689115366465e-07 0 1.4591689115366466e-07 0.00021 1.4592689115366468e-07 0 1.459917084939641e-07 0 1.460017084939641e-07 0.00021 1.4601170849396412e-07 0 1.4605413857774364e-07 0 1.4606413857774365e-07 0.00021 1.4607413857774366e-07 0 1.464197107302069e-07 0 1.464297107302069e-07 0.00021 1.4643971073020692e-07 0 1.468686294416463e-07 0 1.4687862944164632e-07 0.00021 1.4688862944164633e-07 0 1.469662377735159e-07 0 1.469762377735159e-07 0.00021 1.4698623777351592e-07 0 1.4698705483319084e-07 0 1.4699705483319085e-07 0.00021 1.4700705483319087e-07 0 1.4741387418090143e-07 0 1.4742387418090144e-07 0.00021 1.4743387418090145e-07 0 1.4748282843508587e-07 0 1.4749282843508588e-07 0.00021 1.475028284350859e-07 0 1.4752217030724775e-07 0 1.4753217030724776e-07 0.00021 1.4754217030724777e-07 0 1.4796363312244508e-07 0 1.479736331224451e-07 0.00021 1.479836331224451e-07 0 1.4899742317496505e-07 0 1.4900742317496506e-07 0.00021 1.4901742317496507e-07 0 1.494311724780108e-07 0 1.4944117247801082e-07 0.00021 1.4945117247801084e-07 0 1.4948688980507653e-07 0 1.4949688980507655e-07 0.00021 1.4950688980507656e-07 0 1.495513196168985e-07 0 1.495613196168985e-07 0.00021 1.4957131961689852e-07 0 1.5029044648464455e-07 0 1.5030044648464456e-07 0.00021 1.5031044648464457e-07 0 1.505359358591337e-07 0 1.5054593585913372e-07 0.00021 1.5055593585913373e-07 0 1.508745126237854e-07 0 1.5088451262378542e-07 0.00021 1.5089451262378543e-07 0 1.5120930790423765e-07 0 1.5121930790423766e-07 0.00021 1.5122930790423767e-07 0 1.5156535111125047e-07 0 1.5157535111125048e-07 0.00021 1.515853511112505e-07 0 1.5168163830474756e-07 0 1.5169163830474757e-07 0.00021 1.5170163830474758e-07 0 1.5190235077233428e-07 0 1.519123507723343e-07 0.00021 1.519223507723343e-07 0 1.5220233528226724e-07 0 1.5221233528226726e-07 0.00021 1.5222233528226727e-07 0 1.5237716842526114e-07 0 1.5238716842526115e-07 0.00021 1.5239716842526116e-07 0 1.527890128085059e-07 0 1.527990128085059e-07 0.00021 1.528090128085059e-07 0 1.5323128403621667e-07 0 1.5324128403621668e-07 0.00021 1.532512840362167e-07 0 1.5348596424103604e-07 0 1.5349596424103605e-07 0.00021 1.5350596424103606e-07 0 1.5378638577034864e-07 0 1.5379638577034865e-07 0.00021 1.5380638577034866e-07 0 1.53873707808809e-07 0 1.5388370780880902e-07 0.00021 1.5389370780880903e-07 0 1.5410914915581645e-07 0 1.5411914915581646e-07 0.00021 1.5412914915581648e-07 0 1.5415112703066458e-07 0 1.541611270306646e-07 0.00021 1.541711270306646e-07 0 1.5427346092158944e-07 0 1.5428346092158946e-07 0.00021 1.5429346092158947e-07 0 1.5494419201070774e-07 0 1.5495419201070775e-07 0.00021 1.5496419201070776e-07 0 1.5553063915031858e-07 0 1.5554063915031859e-07 0.00021 1.555506391503186e-07 0 1.5605582790194055e-07 0 1.5606582790194056e-07 0.00021 1.5607582790194057e-07 0 1.560848004931566e-07 0 1.5609480049315662e-07 0.00021 1.5610480049315663e-07 0 1.56838857994039e-07 0 1.5684885799403902e-07 0.00021 1.5685885799403904e-07 0 1.5705170259188608e-07 0 1.570617025918861e-07 0.00021 1.570717025918861e-07 0 1.5719585238520522e-07 0 1.5720585238520523e-07 0.00021 1.5721585238520524e-07 0 1.5721585238520522e-07 0 1.5722585238520523e-07 0.00021 1.5723585238520524e-07 0 1.5774006387123405e-07 0 1.5775006387123406e-07 0.00021 1.5776006387123408e-07 0 1.5780751539898973e-07 0 1.5781751539898974e-07 0.00021 1.5782751539898975e-07 0 1.5806751802911102e-07 0 1.5807751802911103e-07 0.00021 1.5808751802911104e-07 0 1.582527239275466e-07 0 1.582627239275466e-07 0.00021 1.582727239275466e-07 0 1.5905295678249167e-07 0 1.5906295678249168e-07 0.00021 1.590729567824917e-07 0 1.5931820203241197e-07 0 1.5932820203241198e-07 0.00021 1.59338202032412e-07 0 1.5963681048909426e-07 0 1.5964681048909427e-07 0.00021 1.5965681048909428e-07 0 1.5975555891899674e-07 0 1.5976555891899675e-07 0.00021 1.5977555891899676e-07 0 1.5985108529627872e-07 0 1.5986108529627873e-07 0.00021 1.5987108529627874e-07 0 1.6019829469017825e-07 0 1.6020829469017826e-07 0.00021 1.6021829469017827e-07 0 1.606054511782161e-07 0 1.606154511782161e-07 0.00021 1.6062545117821612e-07 0 1.6076635106937565e-07 0 1.6077635106937566e-07 0.00021 1.6078635106937568e-07 0 1.6146883462501675e-07 0 1.6147883462501676e-07 0.00021 1.6148883462501678e-07 0 1.616785984130093e-07 0 1.616885984130093e-07 0.00021 1.6169859841300932e-07 0 1.616985984130093e-07 0 1.617085984130093e-07 0.00021 1.617185984130093e-07 0 1.6197579632912563e-07 0 1.6198579632912564e-07 0.00021 1.6199579632912565e-07 0 1.6209430412455613e-07 0 1.6210430412455614e-07 0.00021 1.6211430412455615e-07 0 1.6216011707898166e-07 0 1.6217011707898167e-07 0.00021 1.6218011707898168e-07 0 1.6218011707898165e-07 0 1.6219011707898167e-07 0.00021 1.6220011707898168e-07 0 1.6225396008198814e-07 0 1.6226396008198815e-07 0.00021 1.6227396008198816e-07 0 1.6277256942128083e-07 0 1.6278256942128084e-07 0.00021 1.6279256942128085e-07 0 1.6296985057995774e-07 0 1.6297985057995775e-07 0.00021 1.6298985057995776e-07 0 1.630452136824596e-07 0 1.630552136824596e-07 0.00021 1.6306521368245962e-07 0 1.6378424949975307e-07 0 1.6379424949975309e-07 0.00021 1.638042494997531e-07 0 1.6395842237997955e-07 0 1.6396842237997956e-07 0.00021 1.6397842237997957e-07 0 1.641833203934932e-07 0 1.6419332039349322e-07 0.00021 1.6420332039349323e-07 0 1.6430094078103005e-07 0 1.6431094078103006e-07 0.00021 1.6432094078103008e-07 0 1.643853897206989e-07 0 1.643953897206989e-07 0.00021 1.6440538972069891e-07 0 1.6451999666146765e-07 0 1.6452999666146766e-07 0.00021 1.6453999666146767e-07 0 1.6470986582781852e-07 0 1.6471986582781853e-07 0.00021 1.6472986582781854e-07 0 1.651034506423952e-07 0 1.651134506423952e-07 0.00021 1.6512345064239522e-07 0 1.651653481891307e-07 0 1.6517534818913072e-07 0.00021 1.6518534818913073e-07 0 1.6575088513931523e-07 0 1.6576088513931525e-07 0.00021 1.6577088513931526e-07 0 1.6587135441808626e-07 0 1.6588135441808627e-07 0.00021 1.6589135441808628e-07 0 1.6589135441808625e-07 0 1.6590135441808626e-07 0.00021 1.6591135441808627e-07 0 1.6608524743106115e-07 0 1.6609524743106116e-07 0.00021 1.6610524743106117e-07 0 1.6629450614322824e-07 0 1.6630450614322826e-07 0.00021 1.6631450614322827e-07 0 1.6634704506602167e-07 0 1.6635704506602168e-07 0.00021 1.663670450660217e-07 0 1.6653815356256125e-07 0 1.6654815356256126e-07 0.00021 1.6655815356256127e-07 0 1.6680082709025334e-07 0 1.6681082709025335e-07 0.00021 1.6682082709025336e-07 0 1.6711360318667006e-07 0 1.6712360318667007e-07 0.00021 1.6713360318667008e-07 0 1.6814193363858896e-07 0 1.6815193363858897e-07 0.00021 1.6816193363858898e-07 0 1.6826460841315555e-07 0 1.6827460841315556e-07 0.00021 1.6828460841315558e-07 0 1.6830735884569953e-07 0 1.6831735884569954e-07 0.00021 1.6832735884569956e-07 0 1.6839034735411033e-07 0 1.6840034735411034e-07 0.00021 1.6841034735411035e-07 0 1.6844859042890823e-07 0 1.6845859042890824e-07 0.00021 1.6846859042890825e-07 0 1.6925552607141593e-07 0 1.6926552607141594e-07 0.00021 1.6927552607141596e-07 0 1.6941568881799988e-07 0 1.694256888179999e-07 0.00021 1.694356888179999e-07 0 1.6950634668070587e-07 0 1.6951634668070588e-07 0.00021 1.695263466807059e-07 0 1.696597413104876e-07 0 1.696697413104876e-07 0.00021 1.696797413104876e-07 0 1.703190405219037e-07 0 1.7032904052190372e-07 0.00021 1.7033904052190373e-07 0 1.7058660779639734e-07 0 1.7059660779639735e-07 0.00021 1.7060660779639736e-07 0 1.709868014275117e-07 0 1.7099680142751171e-07 0.00021 1.7100680142751173e-07 0 1.712461860103845e-07 0 1.712561860103845e-07 0.00021 1.7126618601038452e-07 0 1.713089403154275e-07 0 1.7131894031542752e-07 0.00021 1.7132894031542753e-07 0 1.7138331706994357e-07 0 1.7139331706994358e-07 0.00021 1.714033170699436e-07 0 1.7144520413254807e-07 0 1.7145520413254808e-07 0.00021 1.714652041325481e-07 0 1.715304248460092e-07 0 1.7154042484600922e-07 0.00021 1.7155042484600923e-07 0 1.7157893875077932e-07 0 1.7158893875077933e-07 0.00021 1.7159893875077934e-07 0 1.7166753725072087e-07 0 1.7167753725072088e-07 0.00021 1.716875372507209e-07 0 1.720593398286553e-07 0 1.720693398286553e-07 0.00021 1.7207933982865532e-07 0 1.720793398286553e-07 0 1.720893398286553e-07 0.00021 1.7209933982865532e-07 0 1.7213188813406177e-07 0 1.7214188813406178e-07 0.00021 1.721518881340618e-07 0 1.7248170676081652e-07 0 1.7249170676081653e-07 0.00021 1.7250170676081654e-07 0 1.7256446157214192e-07 0 1.7257446157214193e-07 0.00021 1.7258446157214194e-07 0 1.7283373584632638e-07 0 1.728437358463264e-07 0.00021 1.728537358463264e-07 0 1.7295196690498406e-07 0 1.7296196690498408e-07 0.00021 1.729719669049841e-07 0 1.730138285001383e-07 0 1.7302382850013832e-07 0.00021 1.7303382850013833e-07 0 1.7446930497044805e-07 0 1.7447930497044806e-07 0.00021 1.7448930497044807e-07 0 1.749584467542796e-07 0 1.7496844675427962e-07 0.00021 1.7497844675427963e-07 0 1.751739787113929e-07 0 1.7518397871139292e-07 0.00021 1.7519397871139293e-07 0 1.757391971006942e-07 0 1.757491971006942e-07 0.00021 1.7575919710069422e-07 0 1.7645415422890954e-07 0 1.7646415422890956e-07 0.00021 1.7647415422890957e-07 0 1.7706478257525333e-07 0 1.7707478257525334e-07 0.00021 1.7708478257525335e-07 0 1.7709497902686308e-07 0 1.771049790268631e-07 0.00021 1.771149790268631e-07 0 1.7756788849636386e-07 0 1.7757788849636387e-07 0.00021 1.7758788849636388e-07 0 1.7795556723570592e-07 0 1.7796556723570593e-07 0.00021 1.7797556723570595e-07 0 1.7892774426528508e-07 0 1.789377442652851e-07 0.00021 1.789477442652851e-07 0 1.789683344088672e-07 0 1.7897833440886722e-07 0.00021 1.7898833440886723e-07 0 1.7899613784939928e-07 0 1.790061378493993e-07 0.00021 1.790161378493993e-07 0 1.7901613784939928e-07 0 1.790261378493993e-07 0.00021 1.790361378493993e-07 0 1.7923769680653338e-07 0 1.792476968065334e-07 0.00021 1.792576968065334e-07 0 1.7991298901865054e-07 0 1.7992298901865056e-07 0.00021 1.7993298901865057e-07 0 1.801769782285091e-07 0 1.801869782285091e-07 0.00021 1.8019697822850912e-07 0 1.8036172518028156e-07 0 1.8037172518028157e-07 0.00021 1.8038172518028158e-07 0 1.804440580600841e-07 0 1.804540580600841e-07 0.00021 1.8046405806008412e-07 0 1.8088147879385156e-07 0 1.8089147879385158e-07 0.00021 1.8090147879385159e-07 0 1.8141593662304614e-07 0 1.8142593662304615e-07 0.00021 1.8143593662304617e-07 0 1.8166614556314096e-07 0 1.8167614556314098e-07 0.00021 1.81686145563141e-07 0 1.8221652537554507e-07 0 1.8222652537554509e-07 0.00021 1.822365253755451e-07 0 1.82406007924806e-07 0 1.82416007924806e-07 0.00021 1.8242600792480602e-07 0 1.8250582464168162e-07 0 1.8251582464168163e-07 0.00021 1.8252582464168164e-07 0 1.8252582464168161e-07 0 1.8253582464168163e-07 0.00021 1.8254582464168164e-07 0 1.8265267585920743e-07 0 1.8266267585920744e-07 0.00021 1.8267267585920745e-07 0 1.8296887772256432e-07 0 1.8297887772256433e-07 0.00021 1.8298887772256434e-07 0 1.8319030764455678e-07 0 1.832003076445568e-07 0.00021 1.832103076445568e-07 0 1.842697634648933e-07 0 1.842797634648933e-07 0.00021 1.8428976346489332e-07 0 1.8444328655035366e-07 0 1.8445328655035367e-07 0.00021 1.8446328655035368e-07 0 1.8452532563115178e-07 0 1.845353256311518e-07 0.00021 1.845453256311518e-07 0 1.848169607688171e-07 0 1.848269607688171e-07 0.00021 1.8483696076881712e-07 0 1.848369607688171e-07 0 1.848469607688171e-07 0.00021 1.8485696076881712e-07 0 1.8496159845535132e-07 0 1.8497159845535133e-07 0.00021 1.8498159845535134e-07 0 1.8510615129586078e-07 0 1.851161512958608e-07 0.00021 1.851261512958608e-07 0 1.8517523634334062e-07 0 1.8518523634334063e-07 0.00021 1.8519523634334064e-07 0 1.8522345403445886e-07 0 1.8523345403445887e-07 0.00021 1.8524345403445888e-07 0 1.8555944162811073e-07 0 1.8556944162811074e-07 0.00021 1.8557944162811075e-07 0 1.8570241433738571e-07 0 1.8571241433738573e-07 0.00021 1.8572241433738574e-07 0 1.8576467114493151e-07 0 1.8577467114493152e-07 0.00021 1.8578467114493154e-07 0 1.8675437172374868e-07 0 1.867643717237487e-07 0.00021 1.867743717237487e-07 0 1.8691747552923776e-07 0 1.8692747552923777e-07 0.00021 1.8693747552923778e-07 0 1.870183012435691e-07 0 1.8702830124356912e-07 0.00021 1.8703830124356913e-07 0 1.8746818015869828e-07 0 1.874781801586983e-07 0.00021 1.874881801586983e-07 0 1.880116523419813e-07 0 1.8802165234198132e-07 0.00021 1.8803165234198133e-07 0 1.884124251182487e-07 0 1.884224251182487e-07 0.00021 1.8843242511824872e-07 0 1.8846203088157314e-07 0 1.8847203088157315e-07 0.00021 1.8848203088157316e-07 0 1.8870919454690907e-07 0 1.8871919454690908e-07 0.00021 1.887291945469091e-07 0 1.8908993050018293e-07 0 1.8909993050018294e-07 0.00021 1.8910993050018295e-07 0 1.8915913532899307e-07 0 1.8916913532899308e-07 0.00021 1.891791353289931e-07 0 1.8969304330380147e-07 0 1.8970304330380148e-07 0.00021 1.897130433038015e-07 0 1.8983012891065294e-07 0 1.8984012891065296e-07 0.00021 1.8985012891065297e-07 0 1.9009522072785145e-07 0 1.9010522072785147e-07 0.00021 1.9011522072785148e-07 0 1.9026263843985621e-07 0 1.9027263843985623e-07 0.00021 1.9028263843985624e-07 0 1.9031636075829315e-07 0 1.9032636075829316e-07 0.00021 1.9033636075829317e-07 0 1.9051918455063774e-07 0 1.9052918455063775e-07 0.00021 1.9053918455063776e-07 0 1.905500187402836e-07 0 1.905600187402836e-07 0.00021 1.905700187402836e-07 0 1.9059298979344822e-07 0 1.9060298979344823e-07 0.00021 1.9061298979344824e-07 0 1.9105529580018098e-07 0 1.91065295800181e-07 0.00021 1.91075295800181e-07 0 1.9197686495324366e-07 0 1.9198686495324367e-07 0.00021 1.9199686495324368e-07 0 1.9250244391523422e-07 0 1.9251244391523423e-07 0.00021 1.9252244391523424e-07 0 1.927773763624796e-07 0 1.927873763624796e-07 0.00021 1.9279737636247961e-07 0 1.928124594721259e-07 0 1.9282245947212592e-07 0.00021 1.9283245947212593e-07 0 1.9324748612973053e-07 0 1.9325748612973054e-07 0.00021 1.9326748612973056e-07 0 1.9330738120471405e-07 0 1.9331738120471406e-07 0.00021 1.9332738120471407e-07 0 1.9343388598945764e-07 0 1.9344388598945765e-07 0.00021 1.9345388598945766e-07 0 1.9378529318422148e-07 0 1.937952931842215e-07 0.00021 1.938052931842215e-07 0 1.9413742983638774e-07 0 1.9414742983638775e-07 0.00021 1.9415742983638776e-07 0 1.9445262747992842e-07 0 1.9446262747992843e-07 0.00021 1.9447262747992844e-07 0 1.9542579073094253e-07 0 1.9543579073094254e-07 0.00021 1.9544579073094255e-07 0 1.9632797040613642e-07 0 1.9633797040613643e-07 0.00021 1.9634797040613645e-07 0 1.9642742165883727e-07 0 1.9643742165883728e-07 0.00021 1.964474216588373e-07 0 1.9703176011815354e-07 0 1.9704176011815355e-07 0.00021 1.9705176011815356e-07 0 1.972580548772644e-07 0 1.972680548772644e-07 0.00021 1.972780548772644e-07 0 1.9730293346377907e-07 0 1.9731293346377908e-07 0.00021 1.973229334637791e-07 0 1.975357431191573e-07 0 1.9754574311915732e-07 0.00021 1.9755574311915733e-07 0 1.9777917750022332e-07 0 1.9778917750022333e-07 0.00021 1.9779917750022334e-07 0 1.9788321647042827e-07 0 1.9789321647042828e-07 0.00021 1.979032164704283e-07 0 1.9872523723707577e-07 0 1.9873523723707579e-07 0.00021 1.987452372370758e-07 0 1.992040121133135e-07 0 1.9921401211331352e-07 0.00021 1.9922401211331353e-07 0 1.9924839914152203e-07 0 1.9925839914152204e-07 0.00021 1.9926839914152205e-07 0 1.9926839914152203e-07 0 1.9927839914152204e-07 0.00021 1.9928839914152205e-07 0 1.9945888747104376e-07 0 1.9946888747104377e-07 0.00021 1.9947888747104378e-07 0 1.9959015368075593e-07 0 1.9960015368075595e-07 0.00021 1.9961015368075596e-07 0 1.9997061073559832e-07 0 1.9998061073559834e-07 0.00021 1.9999061073559835e-07 0 2.0001709329487216e-07 0 2.0002709329487217e-07 0.00021 2.0003709329487218e-07 0 2.0143323141499248e-07 0 2.014432314149925e-07 0.00021 2.014532314149925e-07 0 2.0156345707103635e-07 0 2.0157345707103636e-07 0.00021 2.0158345707103637e-07 0 2.0161224576199916e-07 0 2.0162224576199917e-07 0.00021 2.0163224576199918e-07 0 2.018613317912016e-07 0 2.0187133179120162e-07 0.00021 2.0188133179120163e-07 0 2.0204070453997687e-07 0 2.0205070453997689e-07 0.00021 2.020607045399769e-07 0 2.0206741206560518e-07 0 2.020774120656052e-07 0.00021 2.020874120656052e-07 0 2.0219367540681e-07 0 2.0220367540681e-07 0.00021 2.0221367540681002e-07 0 2.0228858553799144e-07 0 2.0229858553799145e-07 0.00021 2.0230858553799146e-07 0 2.0285006693523776e-07 0 2.0286006693523778e-07 0.00021 2.028700669352378e-07 0 2.029829897936442e-07 0 2.029929897936442e-07 0.00021 2.0300298979364422e-07 0 2.0385367905140889e-07 0 2.038636790514089e-07 0.00021 2.038736790514089e-07 0 2.0387367905140888e-07 0 2.038836790514089e-07 0.00021 2.038936790514089e-07 0 2.0389367905140888e-07 0 2.039036790514089e-07 0.00021 2.039136790514089e-07 0 2.0391367905140887e-07 0 2.0392367905140889e-07 0.00021 2.039336790514089e-07 0 2.0419786092833443e-07 0 2.0420786092833444e-07 0.00021 2.0421786092833446e-07 0 2.042616579961068e-07 0 2.0427165799610682e-07 0.00021 2.0428165799610683e-07 0 2.0492030925026644e-07 0 2.0493030925026645e-07 0.00021 2.0494030925026646e-07 0 2.0520622674626408e-07 0 2.0521622674626409e-07 0.00021 2.052262267462641e-07 0 2.052633258412617e-07 0 2.0527332584126172e-07 0.00021 2.0528332584126173e-07 0 2.0537294209976563e-07 0 2.0538294209976564e-07 0.00021 2.0539294209976565e-07 0 2.058416862544058e-07 0 2.058516862544058e-07 0.00021 2.058616862544058e-07 0 2.062624883941536e-07 0 2.062724883941536e-07 0.00021 2.0628248839415362e-07 0 2.0642687112665658e-07 0 2.064368711266566e-07 0.00021 2.064468711266566e-07 0 2.065077409801847e-07 0 2.065177409801847e-07 0.00021 2.0652774098018472e-07 0 2.066573697904187e-07 0 2.0666736979041872e-07 0.00021 2.0667736979041873e-07 0 2.0733988594525347e-07 0 2.0734988594525348e-07 0.00021 2.073598859452535e-07 0 2.0770971327602963e-07 0 2.0771971327602964e-07 0.00021 2.0772971327602965e-07 0 2.0777434944046112e-07 0 2.0778434944046113e-07 0.00021 2.0779434944046114e-07 0 2.077943494404611e-07 0 2.0780434944046112e-07 0.00021 2.0781434944046114e-07 0 2.07888048345822e-07 0 2.0789804834582202e-07 0.00021 2.0790804834582203e-07 0 2.0852157436250901e-07 0 2.0853157436250903e-07 0.00021 2.0854157436250904e-07 0 2.090043791695954e-07 0 2.0901437916959542e-07 0.00021 2.0902437916959543e-07 0 2.092152950741457e-07 0 2.0922529507414572e-07 0.00021 2.0923529507414574e-07 0 2.0943456128034617e-07 0 2.0944456128034618e-07 0.00021 2.094545612803462e-07 0 2.0958036103259742e-07 0 2.0959036103259743e-07 0.00021 2.0960036103259744e-07 0 2.096003610325974e-07 0 2.0961036103259742e-07 0.00021 2.0962036103259743e-07 0 2.1026668450025809e-07 0 2.102766845002581e-07 0.00021 2.102866845002581e-07 0 2.1101062579421922e-07 0 2.1102062579421924e-07 0.00021 2.1103062579421925e-07 0 2.113008389030283e-07 0 2.113108389030283e-07 0.00021 2.1132083890302832e-07 0 2.113208389030283e-07 0 2.113308389030283e-07 0.00021 2.1134083890302832e-07 0 2.1152478810691155e-07 0 2.1153478810691157e-07 0.00021 2.1154478810691158e-07 0 2.1163519476191952e-07 0 2.1164519476191953e-07 0.00021 2.1165519476191954e-07 0 2.1190589979156875e-07 0 2.1191589979156876e-07 0.00021 2.1192589979156877e-07 0 2.1206488838699067e-07 0 2.1207488838699068e-07 0.00021 2.120848883869907e-07 0 2.1285223333022525e-07 0 2.1286223333022526e-07 0.00021 2.1287223333022527e-07 0 2.1295434348154404e-07 0 2.1296434348154405e-07 0.00021 2.1297434348154407e-07 0 2.133510007541913e-07 0 2.133610007541913e-07 0.00021 2.1337100075419132e-07 0 2.1381005878531257e-07 0 2.1382005878531258e-07 0.00021 2.138300587853126e-07 0 2.1399001450418842e-07 0 2.1400001450418843e-07 0.00021 2.1401001450418844e-07 0 2.1415927537640598e-07 0 2.14169275376406e-07 0.00021 2.14179275376406e-07 0 2.1445493461735324e-07 0 2.1446493461735325e-07 0.00021 2.1447493461735326e-07 0 2.148334570546514e-07 0 2.1484345705465142e-07 0.00021 2.1485345705465143e-07 0 2.1519895798019814e-07 0 2.1520895798019815e-07 0.00021 2.1521895798019817e-07 0 2.1527098098153868e-07 0 2.152809809815387e-07 0.00021 2.152909809815387e-07 0 2.1562256552657736e-07 0 2.1563256552657737e-07 0.00021 2.1564256552657739e-07 0 2.163467663133475e-07 0 2.163567663133475e-07 0.00021 2.1636676631334752e-07 0 2.1684292717152952e-07 0 2.1685292717152953e-07 0.00021 2.1686292717152955e-07 0 2.1686292717152952e-07 0 2.1687292717152953e-07 0.00021 2.1688292717152954e-07 0 2.1714435837219787e-07 0 2.1715435837219789e-07 0.00021 2.171643583721979e-07 0 2.1721089796553981e-07 0 2.1722089796553983e-07 0.00021 2.1723089796553984e-07 0 2.175737725329741e-07 0 2.175837725329741e-07 0.00021 2.1759377253297412e-07 0 2.1762796240763595e-07 0 2.1763796240763596e-07 0.00021 2.1764796240763597e-07 0 2.1788003339652704e-07 0 2.1789003339652705e-07 0.00021 2.1790003339652707e-07 0 2.1803900178411093e-07 0 2.1804900178411095e-07 0.00021 2.1805900178411096e-07 0 2.1823249005657973e-07 0 2.1824249005657974e-07 0.00021 2.1825249005657975e-07 0 2.1831205994273285e-07 0 2.1832205994273286e-07 0.00021 2.1833205994273288e-07 0 2.1840517301167857e-07 0 2.1841517301167858e-07 0.00021 2.184251730116786e-07 0 2.1893090526646628e-07 0 2.189409052664663e-07 0.00021 2.189509052664663e-07 0 2.1898982698077988e-07 0 2.189998269807799e-07 0.00021 2.190098269807799e-07 0 2.1947258668968499e-07 0 2.19482586689685e-07 0.00021 2.19492586689685e-07 0 2.1957594947540982e-07 0 2.1958594947540983e-07 0.00021 2.1959594947540984e-07 0 2.2004367545066538e-07 0 2.200536754506654e-07 0.00021 2.200636754506654e-07 0 2.2008968787454927e-07 0 2.2009968787454928e-07 0.00021 2.201096878745493e-07 0 2.2090563348589632e-07 0 2.2091563348589633e-07 0.00021 2.2092563348589634e-07 0 2.2104567052357018e-07 0 2.210556705235702e-07 0.00021 2.210656705235702e-07 0 2.2115225803727284e-07 0 2.2116225803727285e-07 0.00021 2.2117225803727286e-07 0 2.2159551591964835e-07 0 2.2160551591964836e-07 0.00021 2.2161551591964837e-07 0 2.2163426398410753e-07 0 2.2164426398410755e-07 0.00021 2.2165426398410756e-07 0 2.2166596764216607e-07 0 2.2167596764216608e-07 0.00021 2.216859676421661e-07 0 2.2194972495489336e-07 0 2.2195972495489337e-07 0.00021 2.2196972495489338e-07 0 2.220202214635718e-07 0 2.220302214635718e-07 0.00021 2.2204022146357182e-07 0 2.220402214635718e-07 0 2.220502214635718e-07 0.00021 2.2206022146357181e-07 0 2.221057691120817e-07 0 2.2211576911208171e-07 0.00021 2.2212576911208172e-07 0 2.2267425193368827e-07 0 2.2268425193368828e-07 0.00021 2.226942519336883e-07 0 2.227867435926642e-07 0 2.2279674359266422e-07 0.00021 2.2280674359266423e-07 0 2.2305601301514373e-07 0 2.2306601301514375e-07 0.00021 2.2307601301514376e-07 0 2.2430568344426956e-07 0 2.2431568344426957e-07 0.00021 2.2432568344426958e-07 0 2.2452507628457048e-07 0 2.245350762845705e-07 0.00021 2.245450762845705e-07 0 2.247217589402508e-07 0 2.247317589402508e-07 0.00021 2.247417589402508e-07 0 2.2475962119193357e-07 0 2.2476962119193358e-07 0.00021 2.247796211919336e-07 0 2.2492859075625832e-07 0 2.2493859075625833e-07 0.00021 2.2494859075625834e-07 0 2.2511278150979746e-07 0 2.2512278150979747e-07 0.00021 2.2513278150979748e-07 0 2.2519481565713471e-07 0 2.2520481565713473e-07 0.00021 2.2521481565713474e-07 0 2.260795001927753e-07 0 2.2608950019277532e-07 0.00021 2.2609950019277533e-07 0 2.2749223376010932e-07 0 2.2750223376010933e-07 0.00021 2.2751223376010935e-07 0 2.2768314594820189e-07 0 2.276931459482019e-07 0.00021 2.277031459482019e-07 0 2.277387974659751e-07 0 2.277487974659751e-07 0.00021 2.277587974659751e-07 0 2.2847756766893398e-07 0 2.28487567668934e-07 0.00021 2.28497567668934e-07 0 2.2913171571402041e-07 0 2.2914171571402043e-07 0.00021 2.2915171571402044e-07 0 2.2934931150953573e-07 0 2.2935931150953574e-07 0.00021 2.2936931150953575e-07 0 2.2969309881358889e-07 0 2.297030988135889e-07 0.00021 2.297130988135889e-07 0 2.297343777640068e-07 0 2.2974437776400682e-07 0.00021 2.2975437776400683e-07 0 2.302865635914221e-07 0 2.302965635914221e-07 0.00021 2.3030656359142212e-07 0 2.3064307694238077e-07 0 2.3065307694238078e-07 0.00021 2.306630769423808e-07 0 2.3074227969885366e-07 0 2.3075227969885367e-07 0.00021 2.3076227969885368e-07 0 2.310060474377009e-07 0 2.310160474377009e-07 0.00021 2.3102604743770092e-07 0 2.310839351262642e-07 0 2.310939351262642e-07 0.00021 2.3110393512626422e-07 0 2.3135101718831173e-07 0 2.3136101718831174e-07 0.00021 2.3137101718831175e-07 0 2.3145600666313797e-07 0 2.3146600666313798e-07 0.00021 2.31476006663138e-07 0 2.317917385000865e-07 0 2.318017385000865e-07 0.00021 2.3181173850008652e-07 0 2.318117385000865e-07 0 2.318217385000865e-07 0.00021 2.3183173850008652e-07 0 2.3190464142273906e-07 0 2.3191464142273907e-07 0.00021 2.3192464142273908e-07 0 2.3192464142273906e-07 0 2.3193464142273907e-07 0.00021 2.3194464142273908e-07 0 2.319636907058297e-07 0 2.3197369070582972e-07 0.00021 2.3198369070582973e-07 0 2.3227177845616723e-07 0 2.3228177845616724e-07 0.00021 2.3229177845616725e-07 0 2.3258179171528488e-07 0 2.325917917152849e-07 0.00021 2.326017917152849e-07 0 2.3260179171528488e-07 0 2.326117917152849e-07 0.00021 2.326217917152849e-07 0 2.3277109418172005e-07 0 2.3278109418172006e-07 0.00021 2.3279109418172007e-07 0 2.3285873805953306e-07 0 2.3286873805953307e-07 0.00021 2.3287873805953308e-07 0 2.3298138396723238e-07 0 2.3299138396723239e-07 0.00021 2.330013839672324e-07 0 2.3302898365821854e-07 0 2.3303898365821855e-07 0.00021 2.3304898365821856e-07 0 2.3338852398012217e-07 0 2.3339852398012218e-07 0.00021 2.334085239801222e-07 0 2.3352877893531727e-07 0 2.3353877893531729e-07 0.00021 2.335487789353173e-07 0 2.3389707227718305e-07 0 2.3390707227718306e-07 0.00021 2.3391707227718307e-07 0 2.340015043763354e-07 0 2.340115043763354e-07 0.00021 2.3402150437633542e-07 0 2.3640605614150109e-07 0 2.364160561415011e-07 0.00021 2.364260561415011e-07 0 2.364520414668647e-07 0 2.3646204146686471e-07 0.00021 2.3647204146686473e-07 0 2.3672979443756764e-07 0 2.3673979443756765e-07 0.00021 2.3674979443756766e-07 0 2.3704703844009703e-07 0 2.3705703844009705e-07 0.00021 2.3706703844009706e-07 0 2.3715252328258168e-07 0 2.3716252328258169e-07 0.00021 2.371725232825817e-07 0 2.3740037423535216e-07 0 2.3741037423535217e-07 0.00021 2.3742037423535218e-07 0 2.3746030275610586e-07 0 2.3747030275610587e-07 0.00021 2.3748030275610588e-07 0 2.376639303972937e-07 0 2.376739303972937e-07 0.00021 2.3768393039729372e-07 0 2.38549170908059e-07 0 2.38559170908059e-07 0.00021 2.3856917090805903e-07 0 2.388536825302809e-07 0 2.388636825302809e-07 0.00021 2.3887368253028094e-07 0 2.392760457998994e-07 0 2.392860457998994e-07 0.00021 2.392960457998994e-07 0 2.3963894304802356e-07 0 2.396489430480236e-07 0.00021 2.396589430480236e-07 0 2.396589430480236e-07 0 2.396689430480236e-07 0.00021 2.396789430480236e-07 0 2.3992455909438315e-07 0 2.3993455909438316e-07 0.00021 2.3994455909438317e-07 0 2.4029803441457394e-07 0 2.4030803441457395e-07 0.00021 2.4031803441457396e-07 0 2.4053497295741847e-07 0 2.405449729574185e-07 0.00021 2.405549729574185e-07 0 2.4071385352132616e-07 0 2.407238535213262e-07 0.00021 2.407338535213262e-07 0 2.407345412164173e-07 0 2.407445412164173e-07 0.00021 2.4075454121641733e-07 0 2.4098746520910533e-07 0 2.4099746520910535e-07 0.00021 2.4100746520910536e-07 0 2.4139291588356924e-07 0 2.4140291588356925e-07 0.00021 2.4141291588356927e-07 0 2.4150038541716696e-07 0 2.4151038541716697e-07 0.00021 2.41520385417167e-07 0 2.415781121059769e-07 0 2.415881121059769e-07 0.00021 2.415981121059769e-07 0 2.416814996217711e-07 0 2.416914996217711e-07 0.00021 2.4170149962177114e-07 0 2.42687420496636e-07 0 2.42697420496636e-07 0.00021 2.42707420496636e-07 0 2.4289857673771827e-07 0 2.429085767377183e-07 0.00021 2.429185767377183e-07 0 2.433882515074954e-07 0 2.4339825150749543e-07 0.00021 2.4340825150749544e-07 0 2.437740962116675e-07 0 2.437840962116675e-07 0.00021 2.437940962116675e-07 0 2.4382435325304494e-07 0 2.4383435325304495e-07 0.00021 2.4384435325304496e-07 0 2.4416373179621994e-07 0 2.4417373179621995e-07 0.00021 2.4418373179621996e-07 0 2.445756843261349e-07 0 2.445856843261349e-07 0.00021 2.445956843261349e-07 0 2.447357942796274e-07 0 2.447457942796274e-07 0.00021 2.447557942796274e-07 0 2.4482039951719245e-07 0 2.4483039951719246e-07 0.00021 2.4484039951719247e-07 0 2.4485438182433493e-07 0 2.4486438182433495e-07 0.00021 2.4487438182433496e-07 0 2.4490818389148043e-07 0 2.4491818389148044e-07 0.00021 2.4492818389148046e-07 0 2.4534613509389717e-07 0 2.453561350938972e-07 0.00021 2.453661350938972e-07 0 2.4540050485805204e-07 0 2.4541050485805205e-07 0.00021 2.4542050485805206e-07 0 2.4547903791848695e-07 0 2.4548903791848696e-07 0.00021 2.45499037918487e-07 0 2.45940382080563e-07 0 2.45950382080563e-07 0.00021 2.45960382080563e-07 0 2.4602174407900615e-07 0 2.4603174407900616e-07 0.00021 2.460417440790062e-07 0 2.460467758163869e-07 0 2.460567758163869e-07 0.00021 2.460667758163869e-07 0 2.4610242549735204e-07 0 2.4611242549735205e-07 0.00021 2.4612242549735206e-07 0 2.4646643390635674e-07 0 2.4647643390635675e-07 0.00021 2.4648643390635676e-07 0 2.4648643390635676e-07 0 2.464964339063568e-07 0.00021 2.465064339063568e-07 0 2.472273987204021e-07 0 2.472373987204021e-07 0.00021 2.4724739872040214e-07 0 2.472961551235684e-07 0 2.4730615512356843e-07 0.00021 2.4731615512356844e-07 0 2.4753999960468343e-07 0 2.4754999960468344e-07 0.00021 2.4755999960468345e-07 0 2.478019630286833e-07 0 2.478119630286833e-07 0.00021 2.478219630286833e-07 0 2.4807050130273957e-07 0 2.480805013027396e-07 0.00021 2.480905013027396e-07 0 2.4843985433522273e-07 0 2.4844985433522274e-07 0.00021 2.4845985433522275e-07 0 2.487505165691963e-07 0 2.487605165691963e-07 0.00021 2.4877051656919634e-07 0 2.4880896748656635e-07 0 2.4881896748656636e-07 0.00021 2.488289674865664e-07 0 2.498440685954751e-07 0 2.4985406859547514e-07 0.00021 2.4986406859547515e-07 0 2.504094302889516e-07 0 2.504194302889516e-07 0.00021 2.5042943028895163e-07 0 2.512386115422292e-07 0 2.512486115422292e-07 0.00021 2.5125861154222923e-07 0 2.514828310209832e-07 0 2.514928310209832e-07 0.00021 2.515028310209832e-07 0 2.5155066401745573e-07 0 2.5156066401745574e-07 0.00021 2.5157066401745576e-07 0 2.5157066401745576e-07 0 2.5158066401745577e-07 0.00021 2.515906640174558e-07 0 2.5170925744422545e-07 0 2.5171925744422546e-07 0.00021 2.5172925744422547e-07 0 2.5178272397110197e-07 0 2.51792723971102e-07 0.00021 2.51802723971102e-07 0 2.518886871658926e-07 0 2.518986871658926e-07 0.00021 2.519086871658926e-07 0 2.5288000052832147e-07 0 2.528900005283215e-07 0.00021 2.529000005283215e-07 0 2.529000005283215e-07 0 2.529100005283215e-07 0.00021 2.529200005283215e-07 0 2.53652597388997e-07 0 2.5366259738899703e-07 0.00021 2.5367259738899704e-07 0 2.5374454069750754e-07 0 2.5375454069750755e-07 0.00021 2.5376454069750757e-07 0 2.539087764639455e-07 0 2.539187764639455e-07 0.00021 2.539287764639455e-07 0 2.540823693663035e-07 0 2.540923693663035e-07 0.00021 2.541023693663035e-07 0 2.543506066807896e-07 0 2.543606066807896e-07 0.00021 2.543706066807896e-07 0 2.545797385072982e-07 0 2.545897385072982e-07 0.00021 2.545997385072982e-07 0 2.547778446522027e-07 0 2.547878446522027e-07 0.00021 2.547978446522027e-07 0 2.548750587378811e-07 0 2.548850587378811e-07 0.00021 2.548950587378811e-07 0 2.5592811947817513e-07 0 2.5593811947817515e-07 0.00021 2.5594811947817516e-07 0 2.559886359655771e-07 0 2.559986359655771e-07 0.00021 2.560086359655771e-07 0 2.5622467791470905e-07 0 2.5623467791470906e-07 0.00021 2.562446779147091e-07 0 2.563420368517531e-07 0 2.563520368517531e-07 0.00021 2.563620368517531e-07 0 2.568577474319746e-07 0 2.568677474319746e-07 0.00021 2.568777474319746e-07 0 2.5733381038978656e-07 0 2.5734381038978657e-07 0.00021 2.573538103897866e-07 0 2.5735589091134497e-07 0 2.57365890911345e-07 0.00021 2.57375890911345e-07 0 2.57375890911345e-07 0 2.57385890911345e-07 0.00021 2.57395890911345e-07 0 2.575759766772455e-07 0 2.575859766772455e-07 0.00021 2.575959766772455e-07 0 2.5793029790488996e-07 0 2.5794029790488997e-07 0.00021 2.5795029790489e-07 0 2.5876499716872043e-07 0 2.5877499716872044e-07 0.00021 2.5878499716872045e-07 0 2.587998252664929e-07 0 2.588098252664929e-07 0.00021 2.588198252664929e-07 0 2.591693880073243e-07 0 2.591793880073243e-07 0.00021 2.5918938800732433e-07 0 2.5952867587027506e-07 0 2.5953867587027507e-07 0.00021 2.595486758702751e-07 0 2.596456755288461e-07 0 2.596556755288461e-07 0.00021 2.596656755288461e-07 0 2.601423990998961e-07 0 2.6015239909989613e-07 0.00021 2.6016239909989614e-07 0 2.6054518404448044e-07 0 2.6055518404448045e-07 0.00021 2.6056518404448046e-07 0 2.6077151725373446e-07 0 2.6078151725373447e-07 0.00021 2.607915172537345e-07 0 2.607915172537345e-07 0 2.608015172537345e-07 0.00021 2.608115172537345e-07 0 2.609502520362048e-07 0 2.609602520362048e-07 0.00021 2.6097025203620484e-07 0 2.609935566386613e-07 0 2.610035566386613e-07 0.00021 2.610135566386613e-07 0 2.617315309885642e-07 0 2.617415309885642e-07 0.00021 2.6175153098856423e-07 0 2.6194124562517743e-07 0 2.6195124562517745e-07 0.00021 2.6196124562517746e-07 0 2.6199519251978713e-07 0 2.6200519251978715e-07 0.00021 2.6201519251978716e-07 0 2.6227695110443196e-07 0 2.6228695110443197e-07 0.00021 2.62296951104432e-07 0 2.6261395369642677e-07 0 2.626239536964268e-07 0.00021 2.626339536964268e-07 0 2.629575740571514e-07 0 2.629675740571514e-07 0.00021 2.629775740571514e-07 0 2.633472726154797e-07 0 2.633572726154797e-07 0.00021 2.633672726154797e-07 0 2.634649485206102e-07 0 2.6347494852061024e-07 0.00021 2.6348494852061025e-07 0 2.635500665188655e-07 0 2.6356006651886553e-07 0.00021 2.6357006651886554e-07 0 2.639129589157729e-07 0 2.6392295891577293e-07 0.00021 2.6393295891577294e-07 0 2.6409193992982605e-07 0 2.6410193992982606e-07 0.00021 2.6411193992982607e-07 0 2.64388254574458e-07 0 2.64398254574458e-07 0.00021 2.64408254574458e-07 0 2.645054977001793e-07 0 2.645154977001793e-07 0.00021 2.645254977001793e-07 0 2.646956384941481e-07 0 2.647056384941481e-07 0.00021 2.647156384941481e-07 0 2.64793132988819e-07 0 2.6480313298881903e-07 0.00021 2.6481313298881904e-07 0 2.649879663978324e-07 0 2.649979663978324e-07 0.00021 2.650079663978324e-07 0 2.6525760140233045e-07 0 2.6526760140233046e-07 0.00021 2.6527760140233047e-07 0 2.655655284123689e-07 0 2.655755284123689e-07 0.00021 2.655855284123689e-07 0 2.6561806177416956e-07 0 2.6562806177416957e-07 0.00021 2.656380617741696e-07 0 2.6568314641219605e-07 0 2.6569314641219606e-07 0.00021 2.6570314641219607e-07 0 2.6579525891814217e-07 0 2.658052589181422e-07 0.00021 2.658152589181422e-07 0 2.6628977726572326e-07 0 2.6629977726572327e-07 0.00021 2.663097772657233e-07 0 2.668358062577789e-07 0 2.6684580625777893e-07 0.00021 2.6685580625777894e-07 0 2.672477570698098e-07 0 2.672577570698098e-07 0.00021 2.672677570698098e-07 0 2.6743226129850595e-07 0 2.6744226129850597e-07 0.00021 2.67452261298506e-07 0 2.6764047053783214e-07 0 2.6765047053783215e-07 0.00021 2.6766047053783216e-07 0 2.6789560015248354e-07 0 2.6790560015248355e-07 0.00021 2.6791560015248357e-07 0 2.6816398313900386e-07 0 2.6817398313900387e-07 0.00021 2.681839831390039e-07 0 2.6869229172674485e-07 0 2.6870229172674486e-07 0.00021 2.6871229172674487e-07 0 2.6902949437851005e-07 0 2.6903949437851006e-07 0.00021 2.690494943785101e-07 0 2.6908076351533187e-07 0 2.690907635153319e-07 0.00021 2.691007635153319e-07 0 2.693686013640426e-07 0 2.693786013640426e-07 0.00021 2.693886013640426e-07 0 2.693886013640426e-07 0 2.693986013640426e-07 0.00021 2.694086013640426e-07 0 2.6990036895963535e-07 0 2.6991036895963536e-07 0.00021 2.6992036895963537e-07 0 2.7023751084879264e-07 0 2.7024751084879265e-07 0.00021 2.7025751084879266e-07 0 2.703130837551909e-07 0 2.703230837551909e-07 0.00021 2.7033308375519094e-07 0 2.7066580058954254e-07 0 2.7067580058954255e-07 0.00021 2.7068580058954256e-07 0 2.7079549406746795e-07 0 2.7080549406746796e-07 0.00021 2.7081549406746797e-07 0 2.709854146596126e-07 0 2.7099541465961263e-07 0.00021 2.7100541465961264e-07 0 2.7152703795677845e-07 0 2.7153703795677846e-07 0.00021 2.7154703795677847e-07 0 2.7160097820131646e-07 0 2.7161097820131647e-07 0.00021 2.716209782013165e-07 0 2.719498524762329e-07 0 2.719598524762329e-07 0.00021 2.719698524762329e-07 0 2.726089308833554e-07 0 2.726189308833554e-07 0.00021 2.726289308833554e-07 0 2.7314299782940105e-07 0 2.7315299782940106e-07 0.00021 2.7316299782940107e-07 0 2.732649363383807e-07 0 2.732749363383807e-07 0.00021 2.732849363383807e-07 0 2.7422133284955694e-07 0 2.7423133284955695e-07 0.00021 2.7424133284955696e-07 0 2.7424133284955696e-07 0 2.7425133284955697e-07 0.00021 2.74261332849557e-07 0 2.743427118488933e-07 0 2.743527118488933e-07 0.00021 2.743627118488933e-07 0 2.746590165331509e-07 0 2.746690165331509e-07 0.00021 2.746790165331509e-07 0 2.7489275924166803e-07 0 2.7490275924166804e-07 0.00021 2.7491275924166805e-07 0 2.754574915867773e-07 0 2.7546749158677733e-07 0.00021 2.7547749158677734e-07 0 2.7577320954932425e-07 0 2.7578320954932426e-07 0.00021 2.7579320954932427e-07 0 2.7601250950403213e-07 0 2.7602250950403215e-07 0.00021 2.7603250950403216e-07 0 2.760442232266769e-07 0 2.7605422322667693e-07 0.00021 2.7606422322667694e-07 0 2.7608964283772385e-07 0 2.7609964283772386e-07 0.00021 2.7610964283772387e-07 0 2.762745902773412e-07 0 2.762845902773412e-07 0.00021 2.762945902773412e-07 0 2.7645042323496336e-07 0 2.7646042323496337e-07 0.00021 2.764704232349634e-07 0 2.7740050756845236e-07 0 2.7741050756845237e-07 0.00021 2.774205075684524e-07 0 2.779758391845753e-07 0 2.779858391845753e-07 0.00021 2.7799583918457533e-07 0 2.795836357937073e-07 0 2.7959363579370733e-07 0.00021 2.7960363579370735e-07 0 2.7961850591560057e-07 0 2.796285059156006e-07 0.00021 2.796385059156006e-07 0 2.8013077895918606e-07 0 2.801407789591861e-07 0.00021 2.801507789591861e-07 0 2.802116986214931e-07 0 2.8022169862149314e-07 0.00021 2.8023169862149315e-07 0 2.803853883704642e-07 0 2.803953883704642e-07 0.00021 2.804053883704642e-07 0 2.805430450165573e-07 0 2.805530450165573e-07 0.00021 2.805630450165573e-07 0 2.807541939685852e-07 0 2.807641939685852e-07 0.00021 2.807741939685852e-07 0 2.808420392308084e-07 0 2.808520392308084e-07 0.00021 2.808620392308084e-07 0 2.8098020503822196e-07 0 2.8099020503822197e-07 0.00021 2.81000205038222e-07 0 2.81000205038222e-07 0 2.81010205038222e-07 0.00021 2.81020205038222e-07 0 2.8166045912886354e-07 0 2.8167045912886355e-07 0.00021 2.8168045912886356e-07 0 2.817785946574519e-07 0 2.817885946574519e-07 0.00021 2.817985946574519e-07 0 2.8279542566260036e-07 0 2.8280542566260037e-07 0.00021 2.828154256626004e-07 0 2.830251357583158e-07 0 2.8303513575831583e-07 0.00021 2.8304513575831585e-07 0 2.8326774753264815e-07 0 2.8327774753264816e-07 0.00021 2.8328774753264817e-07 0 2.8344020116698915e-07 0 2.8345020116698916e-07 0.00021 2.8346020116698917e-07 0 2.835206975830035e-07 0 2.835306975830035e-07 0.00021 2.835406975830035e-07 0 2.8390350990840876e-07 0 2.8391350990840877e-07 0.00021 2.839235099084088e-07 0 2.839689651806783e-07 0 2.839789651806783e-07 0.00021 2.839889651806783e-07 0 2.8447836611611013e-07 0 2.8448836611611014e-07 0.00021 2.8449836611611015e-07 0 2.853784996699617e-07 0 2.853884996699617e-07 0.00021 2.853984996699617e-07 0 2.860473211221039e-07 0 2.860573211221039e-07 0.00021 2.860673211221039e-07 0 2.866290994166463e-07 0 2.866390994166463e-07 0.00021 2.866490994166463e-07 0 2.868062879866055e-07 0 2.868162879866055e-07 0.00021 2.868262879866055e-07 0 2.87035830800067e-07 0 2.87045830800067e-07 0.00021 2.8705583080006703e-07 0 2.87576865695374e-07 0 2.8758686569537403e-07 0.00021 2.8759686569537404e-07 0 2.8770684671228866e-07 0 2.8771684671228867e-07 0.00021 2.877268467122887e-07 0 2.8796382307362293e-07 0 2.8797382307362294e-07 0.00021 2.8798382307362295e-07 0 2.8822725964722263e-07 0 2.8823725964722264e-07 0.00021 2.8824725964722265e-07 0 2.88638069617102e-07 0 2.88648069617102e-07 0.00021 2.88658069617102e-07 0 2.888645550050178e-07 0 2.888745550050178e-07 0.00021 2.888845550050178e-07 0 2.890122019921309e-07 0 2.8902220199213093e-07 0.00021 2.8903220199213094e-07 0 2.891909468862627e-07 0 2.892009468862627e-07 0.00021 2.892109468862627e-07 0 2.895072560417101e-07 0 2.895172560417101e-07 0.00021 2.895272560417101e-07 0 2.8993499910517114e-07 0 2.8994499910517115e-07 0.00021 2.8995499910517116e-07 0 2.8996460170784823e-07 0 2.8997460170784824e-07 0.00021 2.8998460170784825e-07 0 2.9030117891675634e-07 0 2.9031117891675635e-07 0.00021 2.9032117891675637e-07 0 2.907758242799383e-07 0 2.907858242799383e-07 0.00021 2.9079582427993833e-07 0 2.9097589284692135e-07 0 2.9098589284692137e-07 0.00021 2.909958928469214e-07 0 2.9103298277528904e-07 0 2.9104298277528905e-07 0.00021 2.9105298277528906e-07 0 2.913747365724408e-07 0 2.9138473657244083e-07 0.00021 2.9139473657244085e-07 0 2.9160878734499286e-07 0 2.916187873449929e-07 0.00021 2.916287873449929e-07 0 2.9177033860417423e-07 0 2.9178033860417425e-07 0.00021 2.9179033860417426e-07 0 2.9191943471953034e-07 0 2.9192943471953035e-07 0.00021 2.9193943471953037e-07 0 2.920477703433621e-07 0 2.920577703433621e-07 0.00021 2.920677703433621e-07 0 2.9207912360507613e-07 0 2.9208912360507614e-07 0.00021 2.9209912360507616e-07 0 2.9233017169591736e-07 0 2.9234017169591737e-07 0.00021 2.923501716959174e-07 0 2.9255402016381954e-07 0 2.9256402016381955e-07 0.00021 2.9257402016381956e-07 0 2.925864409286611e-07 0 2.925964409286611e-07 0.00021 2.926064409286611e-07 0 2.9266037268710995e-07 0 2.9267037268710996e-07 0.00021 2.9268037268711e-07 0 2.9273278784723195e-07 0 2.9274278784723196e-07 0.00021 2.9275278784723197e-07 0 2.9290633386752625e-07 0 2.9291633386752627e-07 0.00021 2.929263338675263e-07 0 2.929263338675263e-07 0 2.929363338675263e-07 0.00021 2.929463338675263e-07 0 2.9335920659683546e-07 0 2.9336920659683547e-07 0.00021 2.933792065968355e-07 0 2.935391950219689e-07 0 2.9354919502196893e-07 0.00021 2.9355919502196895e-07 0 2.936819824438261e-07 0 2.936919824438261e-07 0.00021 2.9370198244382613e-07 0 2.93825773785903e-07 0 2.93835773785903e-07 0.00021 2.93845773785903e-07 0 2.9424149669002797e-07 0 2.94251496690028e-07 0.00021 2.94261496690028e-07 0 2.9442294886852457e-07 0 2.944329488685246e-07 0.00021 2.944429488685246e-07 0 2.944429488685246e-07 0 2.944529488685246e-07 0.00021 2.944629488685246e-07 0 2.946888243374061e-07 0 2.9469882433740613e-07 0.00021 2.9470882433740614e-07 0 2.9470882433740614e-07 0 2.9471882433740615e-07 0.00021 2.9472882433740617e-07 0 2.9472882433740617e-07 0 2.947388243374062e-07 0.00021 2.947488243374062e-07 0 2.949332233789062e-07 0 2.949432233789062e-07 0.00021 2.9495322337890624e-07 0 2.950265522867884e-07 0 2.9503655228678843e-07 0.00021 2.9504655228678844e-07 0 2.9517860276388707e-07 0 2.951886027638871e-07 0.00021 2.951986027638871e-07 0 2.953738024792217e-07 0 2.953838024792217e-07 0.00021 2.9539380247922173e-07 0 2.9540147252088974e-07 0 2.9541147252088976e-07 0.00021 2.9542147252088977e-07 0 2.9553963522108805e-07 0 2.9554963522108806e-07 0.00021 2.9555963522108807e-07 0 2.965293562184542e-07 0 2.965393562184542e-07 0.00021 2.9654935621845423e-07 0 2.9700044517929903e-07 0 2.9701044517929904e-07 0.00021 2.9702044517929906e-07 0 2.9724739490353403e-07 0 2.9725739490353404e-07 0.00021 2.9726739490353405e-07 0 2.9762777463239016e-07 0 2.976377746323902e-07 0.00021 2.976477746323902e-07 0 2.976546768317473e-07 0 2.976646768317473e-07 0.00021 2.976746768317473e-07 0 2.9775432001621854e-07 0 2.9776432001621855e-07 0.00021 2.9777432001621856e-07 0 2.979665440993433e-07 0 2.979765440993433e-07 0.00021 2.979865440993433e-07 0 2.980926136102757e-07 0 2.981026136102757e-07 0.00021 2.981126136102757e-07 0 2.9817629758943403e-07 0 2.9818629758943404e-07 0.00021 2.9819629758943405e-07 0 2.983234336094982e-07 0 2.983334336094982e-07 0.00021 2.983434336094982e-07 0 2.987185584677289e-07 0 2.9872855846772893e-07 0.00021 2.9873855846772894e-07 0 2.9912637947682566e-07 0 2.9913637947682567e-07 0.00021 2.991463794768257e-07 0 2.9929135286067013e-07 0 2.9930135286067015e-07 0.00021 2.9931135286067016e-07 0 2.99951389349161e-07 0 2.99961389349161e-07 0.00021 2.99971389349161e-07 0 3.0017511019772266e-07 0 3.001851101977227e-07 0.00021 3.001951101977227e-07 0 3.010500228682154e-07 0 3.010600228682154e-07 0.00021 3.010700228682154e-07 0 3.014945768540735e-07 0 3.015045768540735e-07 0.00021 3.015145768540735e-07 0 3.0165676891785045e-07 0 3.0166676891785046e-07 0.00021 3.016767689178505e-07 0 3.017883866232356e-07 0 3.017983866232356e-07 0.00021 3.018083866232356e-07 0 3.020504721471848e-07 0 3.020604721471848e-07 0.00021 3.020704721471848e-07 0 3.0320928132171186e-07 0 3.0321928132171187e-07 0.00021 3.032292813217119e-07 0 3.0327387664744797e-07 0 3.03283876647448e-07 0.00021 3.03293876647448e-07 0 3.0330840447395354e-07 0 3.0331840447395355e-07 0.00021 3.0332840447395356e-07 0 3.0340752278028675e-07 0 3.0341752278028676e-07 0.00021 3.0342752278028677e-07 0 3.0346003531589926e-07 0 3.0347003531589927e-07 0.00021 3.034800353158993e-07 0 3.035407529632069e-07 0 3.035507529632069e-07 0.00021 3.0356075296320693e-07 0 3.03587953184305e-07 0 3.0359795318430503e-07 0.00021 3.0360795318430504e-07 0 3.0435562234425516e-07 0 3.0436562234425517e-07 0.00021 3.043756223442552e-07 0 3.047930122793673e-07 0 3.048030122793673e-07 0.00021 3.048130122793673e-07 0 3.0502209069317436e-07 0 3.0503209069317437e-07 0.00021 3.050420906931744e-07 0 3.0512650334300017e-07 0 3.051365033430002e-07 0.00021 3.051465033430002e-07 0 3.052029634752708e-07 0 3.052129634752708e-07 0.00021 3.052229634752708e-07 0 3.0553801995290797e-07 0 3.05548019952908e-07 0.00021 3.05558019952908e-07 0 3.056914394499333e-07 0 3.0570143944993334e-07 0.00021 3.0571143944993335e-07 0 3.0579762568294807e-07 0 3.058076256829481e-07 0.00021 3.058176256829481e-07 0 3.060314978227903e-07 0 3.060414978227903e-07 0.00021 3.0605149782279033e-07 0 3.063054162229903e-07 0 3.063154162229903e-07 0.00021 3.0632541622299033e-07 0 3.0686804272514584e-07 0 3.0687804272514586e-07 0.00021 3.0688804272514587e-07 0 3.068893860466576e-07 0 3.068993860466576e-07 0.00021 3.0690938604665763e-07 0 3.0738195093292455e-07 0 3.0739195093292456e-07 0.00021 3.0740195093292457e-07 0 3.074039039899248e-07 0 3.074139039899248e-07 0.00021 3.074239039899248e-07 0 3.0786933993839493e-07 0 3.0787933993839494e-07 0.00021 3.0788933993839495e-07 0 3.0788933993839495e-07 0 3.0789933993839496e-07 0.00021 3.0790933993839497e-07 0 3.081729310428637e-07 0 3.081829310428637e-07 0.00021 3.0819293104286373e-07 0 3.0897069283535815e-07 0 3.0898069283535816e-07 0.00021 3.0899069283535817e-07 0 3.0900421051896147e-07 0 3.090142105189615e-07 0.00021 3.090242105189615e-07 0 3.0923299104028173e-07 0 3.0924299104028174e-07 0.00021 3.0925299104028175e-07 0 3.0943395329132886e-07 0 3.0944395329132887e-07 0.00021 3.094539532913289e-07 0 3.1020232937598664e-07 0 3.1021232937598665e-07 0.00021 3.1022232937598666e-07 0 3.110133968429221e-07 0 3.110233968429221e-07 0.00021 3.110333968429221e-07 0 3.1240160558127214e-07 0 3.1241160558127215e-07 0.00021 3.1242160558127216e-07 0 3.126569296125805e-07 0 3.126669296125805e-07 0.00021 3.126769296125805e-07 0 3.126769296125805e-07 0 3.1268692961258053e-07 0.00021 3.1269692961258055e-07 0 3.131757882309878e-07 0 3.131857882309878e-07 0.00021 3.1319578823098784e-07 0 3.1320103258644544e-07 0 3.1321103258644545e-07 0.00021 3.1322103258644546e-07 0 3.141133146959538e-07 0 3.1412331469595384e-07 0.00021 3.1413331469595385e-07 0 3.1445613263552487e-07 0 3.144661326355249e-07 0.00021 3.144761326355249e-07 0 3.153058027226771e-07 0 3.153158027226771e-07 0.00021 3.153258027226771e-07 0 3.1533638881559076e-07 0 3.1534638881559077e-07 0.00021 3.153563888155908e-07 0 3.1536096269413454e-07 0 3.1537096269413455e-07 0.00021 3.1538096269413456e-07 0 3.164633959852345e-07 0 3.1647339598523453e-07 0.00021 3.1648339598523454e-07 0 3.165852262020451e-07 0 3.165952262020451e-07 0.00021 3.166052262020451e-07 0 3.166746034750948e-07 0 3.166846034750948e-07 0.00021 3.1669460347509483e-07 0 3.1750536625973727e-07 0 3.175153662597373e-07 0.00021 3.175253662597373e-07 0 3.178621816851049e-07 0 3.178721816851049e-07 0.00021 3.178821816851049e-07 0 3.18255526540574e-07 0 3.18265526540574e-07 0.00021 3.1827552654057403e-07 0 3.1863107876181787e-07 0 3.186410787618179e-07 0.00021 3.186510787618179e-07 0 3.187916395547498e-07 0 3.188016395547498e-07 0.00021 3.188116395547498e-07 0 3.193016528117196e-07 0 3.193116528117196e-07 0.00021 3.193216528117196e-07 0 3.196453698759209e-07 0 3.1965536987592093e-07 0.00021 3.1966536987592094e-07 0 3.202537030447732e-07 0 3.2026370304477323e-07 0.00021 3.2027370304477324e-07 0 3.203117838966942e-07 0 3.2032178389669423e-07 0.00021 3.2033178389669424e-07 0 3.204013196453401e-07 0 3.204113196453401e-07 0.00021 3.2042131964534014e-07 0 3.2046215605204693e-07 0 3.2047215605204694e-07 0.00021 3.2048215605204695e-07 0 3.2075813094376555e-07 0 3.2076813094376556e-07 0.00021 3.207781309437656e-07 0 3.207781309437656e-07 0 3.207881309437656e-07 0.00021 3.207981309437656e-07 0 3.208650233637205e-07 0 3.208750233637205e-07 0.00021 3.208850233637205e-07 0 3.210026059348395e-07 0 3.210126059348395e-07 0.00021 3.2102260593483953e-07 0 3.214186196300227e-07 0 3.214286196300227e-07 0.00021 3.214386196300227e-07 0 3.216807125328002e-07 0 3.216907125328002e-07 0.00021 3.217007125328002e-07 0 3.218930975257778e-07 0 3.219030975257778e-07 0.00021 3.219130975257778e-07 0 3.2197601030526094e-07 0 3.2198601030526095e-07 0.00021 3.2199601030526096e-07 0 3.2232141394785267e-07 0 3.223314139478527e-07 0.00021 3.223414139478527e-07 0 3.2236391113045465e-07 0 3.2237391113045466e-07 0.00021 3.2238391113045467e-07 0 3.2238391113045467e-07 0 3.223939111304547e-07 0.00021 3.224039111304547e-07 0 3.235717295240978e-07 0 3.235817295240978e-07 0.00021 3.235917295240978e-07 0 3.238373244888749e-07 0 3.238473244888749e-07 0.00021 3.2385732448887494e-07 0 3.2386888606853755e-07 0 3.2387888606853756e-07 0.00021 3.2388888606853757e-07 0 3.2412089545378206e-07 0 3.2413089545378207e-07 0.00021 3.241408954537821e-07 0 3.241429023460704e-07 0 3.241529023460704e-07 0.00021 3.241629023460704e-07 0 3.241699159116101e-07 0 3.241799159116101e-07 0.00021 3.241899159116101e-07 0 3.2464408473396693e-07 0 3.2465408473396694e-07 0.00021 3.2466408473396695e-07 0 3.2493546270311024e-07 0 3.2494546270311025e-07 0.00021 3.2495546270311027e-07 0 3.250002255255578e-07 0 3.2501022552555784e-07 0.00021 3.2502022552555785e-07 0 3.2542499891789216e-07 0 3.2543499891789217e-07 0.00021 3.254449989178922e-07 0 3.2563206966359735e-07 0 3.2564206966359736e-07 0.00021 3.2565206966359737e-07 0 3.2570156101280254e-07 0 3.2571156101280255e-07 0.00021 3.2572156101280256e-07 0 3.2572156101280256e-07 0 3.257315610128026e-07 0.00021 3.257415610128026e-07 0 3.260221276438599e-07 0 3.260321276438599e-07 0.00021 3.2604212764385993e-07 0 3.2639074671484314e-07 0 3.2640074671484315e-07 0.00021 3.2641074671484316e-07 0 3.2694440660667426e-07 0 3.2695440660667427e-07 0.00021 3.269644066066743e-07 0 3.271934235471507e-07 0 3.272034235471507e-07 0.00021 3.2721342354715073e-07 0 3.273716216543102e-07 0 3.273816216543102e-07 0.00021 3.273916216543102e-07 0 3.2768395493955243e-07 0 3.2769395493955244e-07 0.00021 3.2770395493955245e-07 0 3.278954968698405e-07 0 3.279054968698405e-07 0.00021 3.2791549686984053e-07 0 3.2824786102432834e-07 0 3.2825786102432835e-07 0.00021 3.2826786102432836e-07 0 3.2848777693588287e-07 0 3.284977769358829e-07 0.00021 3.285077769358829e-07 0 3.2873075282807866e-07 0 3.2874075282807867e-07 0.00021 3.287507528280787e-07 0 3.28867656141338e-07 0 3.28877656141338e-07 0.00021 3.2888765614133803e-07 0 3.28932732729395e-07 0 3.28942732729395e-07 0.00021 3.28952732729395e-07 0 3.293388003015577e-07 0 3.293488003015577e-07 0.00021 3.293588003015577e-07 0 3.296173331390471e-07 0 3.296273331390471e-07 0.00021 3.296373331390471e-07 0 3.300151497454767e-07 0 3.300251497454767e-07 0.00021 3.300351497454767e-07 0 3.3094644138446237e-07 0 3.309564413844624e-07 0.00021 3.309664413844624e-07 0 3.313559207232718e-07 0 3.313659207232718e-07 0.00021 3.313759207232718e-07 0 3.3145533807281234e-07 0 3.3146533807281235e-07 0.00021 3.3147533807281236e-07 0 3.3147533807281236e-07 0 3.3148533807281237e-07 0.00021 3.314953380728124e-07 0 3.315916785833024e-07 0 3.316016785833024e-07 0.00021 3.316116785833024e-07 0 3.316688791381501e-07 0 3.316788791381501e-07 0.00021 3.316888791381501e-07 0 3.32022513411701e-07 0 3.32032513411701e-07 0.00021 3.32042513411701e-07 0 3.3243768515676245e-07 0 3.3244768515676246e-07 0.00021 3.3245768515676247e-07 0 3.3247215024106603e-07 0 3.3248215024106604e-07 0.00021 3.3249215024106605e-07 0 3.325297669834195e-07 0 3.3253976698341953e-07 0.00021 3.3254976698341954e-07 0 3.3306230153390035e-07 0 3.3307230153390036e-07 0.00021 3.330823015339004e-07 0 3.3318979138231464e-07 0 3.3319979138231465e-07 0.00021 3.3320979138231466e-07 0 3.333863062711958e-07 0 3.333963062711958e-07 0.00021 3.334063062711958e-07 0 3.3358015294624446e-07 0 3.3359015294624447e-07 0.00021 3.336001529462445e-07 0 3.336001529462445e-07 0 3.336101529462445e-07 0.00021 3.336201529462445e-07 0 3.341561311161324e-07 0 3.3416613111613243e-07 0.00021 3.3417613111613244e-07 0 3.342637380080656e-07 0 3.342737380080656e-07 0.00021 3.342837380080656e-07 0 3.342837380080656e-07 0 3.342937380080656e-07 0.00021 3.3430373800806564e-07 0 3.344599888523244e-07 0 3.3446998885232443e-07 0.00021 3.3447998885232444e-07 0 3.347080136689236e-07 0 3.3471801366892364e-07 0.00021 3.3472801366892365e-07 0 3.3522999377350646e-07 0 3.3523999377350647e-07 0.00021 3.352499937735065e-07 0 3.3525241982516973e-07 0 3.3526241982516974e-07 0.00021 3.3527241982516975e-07 0 3.3531385887816053e-07 0 3.3532385887816054e-07 0.00021 3.3533385887816055e-07 0 3.3556807415790323e-07 0 3.3557807415790324e-07 0.00021 3.3558807415790325e-07 0 3.358731356882599e-07 0 3.358831356882599e-07 0.00021 3.358931356882599e-07 0 3.358931356882599e-07 0 3.3590313568825993e-07 0.00021 3.3591313568825994e-07 0 3.3645307338087133e-07 0 3.3646307338087134e-07 0.00021 3.3647307338087135e-07 0 3.3677457914800864e-07 0 3.3678457914800865e-07 0.00021 3.3679457914800866e-07 0 3.3688985978146006e-07 0 3.368998597814601e-07 0.00021 3.369098597814601e-07 0 3.380736193334367e-07 0 3.380836193334367e-07 0.00021 3.380936193334367e-07 0 3.3904906821990094e-07 0 3.3905906821990095e-07 0.00021 3.3906906821990096e-07 0 3.4048845193044017e-07 0 3.404984519304402e-07 0.00021 3.405084519304402e-07 0 3.40554202137741e-07 0 3.4056420213774103e-07 0.00021 3.4057420213774104e-07 0 3.406419700350069e-07 0 3.406519700350069e-07 0.00021 3.406619700350069e-07 0 3.4207215295721093e-07 0 3.4208215295721094e-07 0.00021 3.4209215295721096e-07 0 3.425958529874126e-07 0 3.4260585298741263e-07 0.00021 3.4261585298741264e-07 0 3.4289511343940796e-07 0 3.42905113439408e-07 0.00021 3.42915113439408e-07 0 3.4375469874087985e-07 0 3.4376469874087986e-07 0.00021 3.437746987408799e-07 0 3.4413576378139175e-07 0 3.4414576378139176e-07 0.00021 3.441557637813918e-07 0 3.44422413560925e-07 0 3.44432413560925e-07 0.00021 3.44442413560925e-07 0 3.448828807758363e-07 0 3.448928807758363e-07 0.00021 3.449028807758363e-07 0 3.451155199870236e-07 0 3.4512551998702364e-07 0.00021 3.4513551998702365e-07 0 3.452656578738965e-07 0 3.452756578738965e-07 0.00021 3.452856578738965e-07 0 3.455748531641877e-07 0 3.4558485316418773e-07 0.00021 3.4559485316418774e-07 0 3.460834907018498e-07 0 3.460934907018498e-07 0.00021 3.461034907018498e-07 0 3.475133558431156e-07 0 3.475233558431156e-07 0.00021 3.475333558431156e-07 0 3.4754167776585886e-07 0 3.475516777658589e-07 0.00021 3.475616777658589e-07 0 3.477008582123986e-07 0 3.477108582123986e-07 0.00021 3.4772085821239863e-07 0 3.478680938607793e-07 0 3.478780938607793e-07 0.00021 3.4788809386077933e-07 0 3.4829503615888793e-07 0 3.4830503615888794e-07 0.00021 3.4831503615888795e-07 0 3.4831503615888795e-07 0 3.4832503615888796e-07 0.00021 3.48335036158888e-07 0 3.488318378645117e-07 0 3.488418378645117e-07 0.00021 3.4885183786451173e-07 0 3.489393608643074e-07 0 3.489493608643074e-07 0.00021 3.489593608643074e-07 0 3.4933198614086367e-07 0 3.493419861408637e-07 0.00021 3.493519861408637e-07 0 3.4943037009233077e-07 0 3.494403700923308e-07 0.00021 3.494503700923308e-07 0 3.4948483724864695e-07 0 3.4949483724864696e-07 0.00021 3.4950483724864697e-07 0 3.495667438784299e-07 0 3.495767438784299e-07 0.00021 3.495867438784299e-07 0 3.4978649119286383e-07 0 3.4979649119286384e-07 0.00021 3.4980649119286385e-07 0 3.503763590564311e-07 0 3.503863590564311e-07 0.00021 3.503963590564311e-07 0 3.507078284615203e-07 0 3.507178284615203e-07 0.00021 3.5072782846152033e-07 0 3.508494407947714e-07 0 3.508594407947714e-07 0.00021 3.5086944079477144e-07 0 3.5188543759220015e-07 0 3.5189543759220016e-07 0.00021 3.5190543759220017e-07 0 3.5195793783360294e-07 0 3.5196793783360295e-07 0.00021 3.5197793783360296e-07 0 3.5227506519975204e-07 0 3.5228506519975205e-07 0.00021 3.5229506519975206e-07 0 3.524812198200187e-07 0 3.524912198200187e-07 0.00021 3.525012198200187e-07 0 3.526659511744783e-07 0 3.526759511744783e-07 0.00021 3.526859511744783e-07 0 3.5351546226300993e-07 0 3.5352546226300994e-07 0.00021 3.5353546226300995e-07 0 3.5363999227479025e-07 0 3.5364999227479026e-07 0.00021 3.536599922747903e-07 0 3.5396305841737083e-07 0 3.5397305841737084e-07 0.00021 3.5398305841737085e-07 0 3.54150054430694e-07 0 3.54160054430694e-07 0.00021 3.54170054430694e-07 0 3.543284602998203e-07 0 3.543384602998203e-07 0.00021 3.543484602998203e-07 0 3.5468729820661405e-07 0 3.5469729820661406e-07 0.00021 3.5470729820661407e-07 0 3.548977817014737e-07 0 3.549077817014737e-07 0.00021 3.549177817014737e-07 0 3.5491803814664505e-07 0 3.5492803814664506e-07 0.00021 3.5493803814664507e-07 0 3.549645618477972e-07 0 3.549745618477972e-07 0.00021 3.5498456184779723e-07 0 3.5529252297050355e-07 0 3.5530252297050357e-07 0.00021 3.553125229705036e-07 0 3.559032084735334e-07 0 3.559132084735334e-07 0.00021 3.559232084735334e-07 0 3.5609161443731606e-07 0 3.5610161443731607e-07 0.00021 3.561116144373161e-07 0 3.5630018745021206e-07 0 3.563101874502121e-07 0.00021 3.563201874502121e-07 0 3.563233187826837e-07 0 3.5633331878268373e-07 0.00021 3.5634331878268374e-07 0 3.5660354130649965e-07 0 3.5661354130649966e-07 0.00021 3.5662354130649967e-07 0 3.5713875932483367e-07 0 3.571487593248337e-07 0.00021 3.571587593248337e-07 0 3.5736657366466727e-07 0 3.573765736646673e-07 0.00021 3.573865736646673e-07 0 3.580981121599872e-07 0 3.581081121599872e-07 0.00021 3.581181121599872e-07 0 3.581418550460294e-07 0 3.5815185504602943e-07 0.00021 3.5816185504602944e-07 0 3.581867173825909e-07 0 3.5819671738259093e-07 0.00021 3.5820671738259094e-07 0 3.584688659627614e-07 0 3.584788659627614e-07 0.00021 3.584888659627614e-07 0 3.5910442004721295e-07 0 3.5911442004721297e-07 0.00021 3.59124420047213e-07 0 3.591961587931804e-07 0 3.5920615879318043e-07 0.00021 3.5921615879318044e-07 0 3.6020245975065906e-07 0 3.6021245975065907e-07 0.00021 3.602224597506591e-07 0 3.6038626230609415e-07 0 3.6039626230609417e-07 0.00021 3.604062623060942e-07 0 3.607366587865673e-07 0 3.607466587865673e-07 0.00021 3.607566587865673e-07 0 3.6085568977711863e-07 0 3.6086568977711864e-07 0.00021 3.6087568977711865e-07 0 3.610588800946298e-07 0 3.6106888009462984e-07 0.00021 3.6107888009462985e-07 0 3.6172975611372943e-07 0 3.6173975611372944e-07 0.00021 3.6174975611372945e-07 0 3.6211698283167987e-07 0 3.621269828316799e-07 0.00021 3.621369828316799e-07 0 3.621507447753627e-07 0 3.621607447753627e-07 0.00021 3.621707447753627e-07 0 3.623105463183461e-07 0 3.623205463183461e-07 0.00021 3.623305463183461e-07 0 3.6254826302207445e-07 0 3.6255826302207446e-07 0.00021 3.6256826302207447e-07 0 3.626874521713685e-07 0 3.6269745217136854e-07 0.00021 3.6270745217136855e-07 0 3.6326684658142543e-07 0 3.6327684658142544e-07 0.00021 3.6328684658142545e-07 0 3.633956798419507e-07 0 3.634056798419507e-07 0.00021 3.634156798419507e-07 0 3.635277102634316e-07 0 3.6353771026343163e-07 0.00021 3.6354771026343164e-07 0 3.6354771026343164e-07 0 3.6355771026343165e-07 0.00021 3.6356771026343166e-07 0 3.639185726346273e-07 0 3.639285726346273e-07 0.00021 3.6393857263462734e-07 0 3.6411834963857687e-07 0 3.641283496385769e-07 0.00021 3.641383496385769e-07 0 3.6423859049135016e-07 0 3.6424859049135017e-07 0.00021 3.642585904913502e-07 0 3.6454422224487624e-07 0 3.6455422224487625e-07 0.00021 3.6456422224487626e-07 0 3.6495637339562863e-07 0 3.6496637339562865e-07 0.00021 3.6497637339562866e-07 0 3.6513244861588187e-07 0 3.651424486158819e-07 0.00021 3.651524486158819e-07 0 3.6518358538380135e-07 0 3.6519358538380136e-07 0.00021 3.6520358538380137e-07 0 3.654310262276261e-07 0 3.654410262276261e-07 0.00021 3.654510262276261e-07 0 3.654510262276261e-07 0 3.6546102622762614e-07 0.00021 3.6547102622762615e-07 0 3.6547102622762615e-07 0 3.6548102622762616e-07 0.00021 3.6549102622762617e-07 0 3.6550828977114635e-07 0 3.6551828977114636e-07 0.00021 3.6552828977114637e-07 0 3.6553124040289267e-07 0 3.655412404028927e-07 0.00021 3.655512404028927e-07 0 3.6571850536036164e-07 0 3.6572850536036165e-07 0.00021 3.6573850536036167e-07 0 3.6602898300743025e-07 0 3.6603898300743026e-07 0.00021 3.6604898300743027e-07 0 3.6614141378084813e-07 0 3.6615141378084815e-07 0.00021 3.6616141378084816e-07 0 3.6616141378084816e-07 0 3.6617141378084817e-07 0.00021 3.661814137808482e-07 0 3.6712411295312775e-07 0 3.6713411295312776e-07 0.00021 3.6714411295312777e-07 0 3.6726623888165695e-07 0 3.6727623888165696e-07 0.00021 3.6728623888165697e-07 0 3.6735865981087066e-07 0 3.6736865981087067e-07 0.00021 3.673786598108707e-07 0 3.674634722318382e-07 0 3.674734722318382e-07 0.00021 3.674834722318382e-07 0 3.679186117937499e-07 0 3.679286117937499e-07 0.00021 3.679386117937499e-07 0 3.6805329185056184e-07 0 3.6806329185056185e-07 0.00021 3.6807329185056186e-07 0 3.688229805573257e-07 0 3.688329805573257e-07 0.00021 3.6884298055732573e-07 0 3.697039194577694e-07 0 3.697139194577694e-07 0.00021 3.697239194577694e-07 0 3.709404567734134e-07 0 3.7095045677341343e-07 0.00021 3.7096045677341344e-07 0 3.714748060260195e-07 0 3.7148480602601953e-07 0.00021 3.7149480602601955e-07 0 3.720299655276053e-07 0 3.720399655276053e-07 0.00021 3.720499655276053e-07 0 3.7217038342162536e-07 0 3.7218038342162537e-07 0.00021 3.721903834216254e-07 0 3.7241431136333976e-07 0 3.724243113633398e-07 0.00021 3.724343113633398e-07 0 3.724343113633398e-07 0 3.724443113633398e-07 0.00021 3.724543113633398e-07 0 3.7294952354833867e-07 0 3.729595235483387e-07 0.00021 3.729695235483387e-07 0 3.729695235483387e-07 0 3.729795235483387e-07 0.00021 3.729895235483387e-07 0 3.733387631092178e-07 0 3.733487631092178e-07 0.00021 3.733587631092178e-07 0 3.735278862887553e-07 0 3.7353788628875533e-07 0.00021 3.7354788628875535e-07 0 3.735482367298708e-07 0 3.735582367298708e-07 0.00021 3.735682367298708e-07 0 3.736394098793354e-07 0 3.7364940987933544e-07 0.00021 3.7365940987933545e-07 0 3.7415890712429755e-07 0 3.7416890712429756e-07 0.00021 3.7417890712429757e-07 0 3.742473107825097e-07 0 3.7425731078250974e-07 0.00021 3.7426731078250975e-07 0 3.7454049596548634e-07 0 3.7455049596548635e-07 0.00021 3.7456049596548636e-07 0 3.748420544169059e-07 0 3.748520544169059e-07 0.00021 3.748620544169059e-07 0 3.749513267653908e-07 0 3.749613267653908e-07 0.00021 3.749713267653908e-07 0 3.7630135071433187e-07 0 3.763113507143319e-07 0.00021 3.763213507143319e-07 0 3.7643740073574673e-07 0 3.7644740073574675e-07 0.00021 3.7645740073574676e-07 0 3.766230532726258e-07 0 3.7663305327262583e-07 0.00021 3.7664305327262584e-07 0 3.7675294366188093e-07 0 3.7676294366188094e-07 0.00021 3.7677294366188095e-07 0 3.771134636953556e-07 0 3.771234636953556e-07 0.00021 3.771334636953556e-07 0 3.7782611591329335e-07 0 3.7783611591329336e-07 0.00021 3.7784611591329337e-07 0 3.7784611591329337e-07 0 3.778561159132934e-07 0.00021 3.778661159132934e-07 0 3.779355036952461e-07 0 3.7794550369524614e-07 0.00021 3.7795550369524615e-07 0 3.7835025952259083e-07 0 3.7836025952259084e-07 0.00021 3.7837025952259085e-07 0 3.783920118136604e-07 0 3.784020118136604e-07 0.00021 3.7841201181366043e-07 0 3.7853355406725316e-07 0 3.7854355406725317e-07 0.00021 3.785535540672532e-07 0 3.7893832729600207e-07 0 3.789483272960021e-07 0.00021 3.789583272960021e-07 0 3.7906876006484087e-07 0 3.790787600648409e-07 0.00021 3.790887600648409e-07 0 3.79364407521486e-07 0 3.79374407521486e-07 0.00021 3.79384407521486e-07 0 3.7973381971219336e-07 0 3.7974381971219337e-07 0.00021 3.797538197121934e-07 0 3.8035164865752053e-07 0 3.8036164865752054e-07 0.00021 3.8037164865752056e-07 0 3.807098707064855e-07 0 3.807198707064855e-07 0.00021 3.807298707064855e-07 0 3.8100732536675296e-07 0 3.81017325366753e-07 0.00021 3.81027325366753e-07 0 3.811035652613591e-07 0 3.8111356526135913e-07 0.00021 3.8112356526135914e-07 0 3.811659998998444e-07 0 3.811759998998444e-07 0.00021 3.811859998998444e-07 0 3.8119981934698226e-07 0 3.8120981934698227e-07 0.00021 3.812198193469823e-07 0 3.814597303882819e-07 0 3.8146973038828193e-07 0.00021 3.8147973038828194e-07 0 3.816268568440626e-07 0 3.816368568440626e-07 0.00021 3.816468568440626e-07 0 3.816468568440626e-07 0 3.8165685684406264e-07 0.00021 3.8166685684406265e-07 0 3.820362724977367e-07 0 3.820462724977367e-07 0.00021 3.8205627249773673e-07 0 3.825680333376026e-07 0 3.825780333376026e-07 0.00021 3.825880333376026e-07 0 3.831024222106482e-07 0 3.831124222106482e-07 0.00021 3.831224222106482e-07 0 3.831680074008597e-07 0 3.831780074008597e-07 0.00021 3.831880074008597e-07 0 3.838734118018987e-07 0 3.838834118018987e-07 0.00021 3.838934118018987e-07 0 3.843628427155366e-07 0 3.843728427155366e-07 0.00021 3.8438284271553663e-07 0 3.8453897460306047e-07 0 3.845489746030605e-07 0.00021 3.845589746030605e-07 0 3.8467885217329907e-07 0 3.846888521732991e-07 0.00021 3.846988521732991e-07 0 3.8490132494754044e-07 0 3.8491132494754046e-07 0.00021 3.8492132494754047e-07 0 3.8492290030818766e-07 0 3.849329003081877e-07 0.00021 3.849429003081877e-07 0 3.849429003081877e-07 0 3.849529003081877e-07 0.00021 3.849629003081877e-07 0 3.849629003081877e-07 0 3.849729003081877e-07 0.00021 3.8498290030818773e-07 0 3.850379995730421e-07 0 3.850479995730421e-07 0.00021 3.850579995730421e-07 0 3.850714920708659e-07 0 3.850814920708659e-07 0.00021 3.8509149207086593e-07 0 3.851653336542462e-07 0 3.851753336542462e-07 0.00021 3.851853336542462e-07 0 3.8526853385531305e-07 0 3.8527853385531306e-07 0.00021 3.8528853385531307e-07 0 3.8562024059877104e-07 0 3.8563024059877105e-07 0.00021 3.8564024059877106e-07 0 3.8575820865935315e-07 0 3.8576820865935316e-07 0.00021 3.8577820865935317e-07 0 3.8577820865935317e-07 0 3.857882086593532e-07 0.00021 3.857982086593532e-07 0 3.857982086593532e-07 0 3.858082086593532e-07 0.00021 3.858182086593532e-07 0 3.860096085259615e-07 0 3.8601960852596153e-07 0.00021 3.8602960852596154e-07 0 3.860365785272042e-07 0 3.8604657852720423e-07 0.00021 3.8605657852720424e-07 0 3.864323097126827e-07 0 3.864423097126827e-07 0.00021 3.864523097126827e-07 0 3.867835868919855e-07 0 3.867935868919855e-07 0.00021 3.868035868919855e-07 0 3.869945329812734e-07 0 3.870045329812734e-07 0.00021 3.8701453298127343e-07 0 3.8711548482726015e-07 0 3.8712548482726016e-07 0.00021 3.8713548482726017e-07 0 3.875947127540717e-07 0 3.876047127540717e-07 0.00021 3.876147127540717e-07 0 3.8773084299234783e-07 0 3.8774084299234784e-07 0.00021 3.8775084299234785e-07 0 3.8783838489176065e-07 0 3.8784838489176066e-07 0.00021 3.878583848917607e-07 0 3.8795460070627856e-07 0 3.8796460070627857e-07 0.00021 3.879746007062786e-07 0 3.8816193103197673e-07 0 3.8817193103197674e-07 0.00021 3.8818193103197675e-07 0 3.882457440704989e-07 0 3.882557440704989e-07 0.00021 3.882657440704989e-07 0 3.883246377790685e-07 0 3.8833463777906853e-07 0.00021 3.8834463777906854e-07 0 3.8961850350368246e-07 0 3.896285035036825e-07 0.00021 3.896385035036825e-07 0 3.896385035036825e-07 0 3.896485035036825e-07 0.00021 3.896585035036825e-07 0 3.896585035036825e-07 0 3.896685035036825e-07 0.00021 3.8967850350368253e-07 0 3.8975610202279235e-07 0 3.8976610202279236e-07 0.00021 3.8977610202279237e-07 0 3.9007200656279947e-07 0 3.900820065627995e-07 0.00021 3.900920065627995e-07 0 3.902516200451364e-07 0 3.9026162004513643e-07 0.00021 3.9027162004513644e-07 0 3.9028594092581694e-07 0 3.9029594092581695e-07 0.00021 3.9030594092581696e-07 0 3.907228382168185e-07 0 3.907328382168185e-07 0.00021 3.907428382168185e-07 0 3.907428382168185e-07 0 3.907528382168185e-07 0.00021 3.9076283821681853e-07 0 3.9079661815413315e-07 0 3.9080661815413316e-07 0.00021 3.9081661815413317e-07 0 3.910156708360381e-07 0 3.9102567083603813e-07 0.00021 3.9103567083603814e-07 0 3.9107987800891625e-07 0 3.9108987800891626e-07 0.00021 3.910998780089163e-07 0 3.9117322834761685e-07 0 3.9118322834761686e-07 0.00021 3.911932283476169e-07 0 3.9200524548016523e-07 0 3.9201524548016524e-07 0.00021 3.9202524548016525e-07 0 3.9311799425103716e-07 0 3.9312799425103717e-07 0.00021 3.931379942510372e-07 0 3.9319538326443186e-07 0 3.9320538326443187e-07 0.00021 3.932153832644319e-07 0 3.936463951038155e-07 0 3.936563951038155e-07 0.00021 3.9366639510381554e-07 0 3.9391358209952874e-07 0 3.9392358209952875e-07 0.00021 3.9393358209952876e-07 0 3.943375972588832e-07 0 3.9434759725888323e-07 0.00021 3.9435759725888324e-07 0 3.945351744653401e-07 0 3.945451744653401e-07 0.00021 3.945551744653401e-07 0 3.9462848712218413e-07 0 3.9463848712218414e-07 0.00021 3.9464848712218415e-07 0 3.951352063846798e-07 0 3.951452063846798e-07 0.00021 3.9515520638467983e-07 0 3.962514867340157e-07 0 3.962614867340157e-07 0.00021 3.962714867340157e-07 0 3.9656292718566674e-07 0 3.9657292718566675e-07 0.00021 3.9658292718566676e-07 0 3.97108171989165e-07 0 3.97118171989165e-07 0.00021 3.97128171989165e-07 0 3.97128171989165e-07 0 3.9713817198916503e-07 0.00021 3.9714817198916504e-07 0 3.97359292033399e-07 0 3.9736929203339903e-07 0.00021 3.9737929203339904e-07 0 3.9748675392802594e-07 0 3.9749675392802595e-07 0.00021 3.9750675392802596e-07 0 3.980417782184033e-07 0 3.980517782184033e-07 0.00021 3.980617782184033e-07 0 3.980617782184033e-07 0 3.980717782184033e-07 0.00021 3.9808177821840334e-07 0 3.982833909062994e-07 0 3.9829339090629944e-07 0.00021 3.9830339090629945e-07 0 3.984360185023315e-07 0 3.984460185023315e-07 0.00021 3.984560185023315e-07 0 3.985823357151283e-07 0 3.985923357151283e-07 0.00021 3.986023357151283e-07 0 3.990463583027971e-07 0 3.990563583027971e-07 0.00021 3.9906635830279714e-07 0 3.9910076417302203e-07 0 3.9911076417302204e-07 0.00021 3.9912076417302205e-07 0 3.998465720193696e-07 0 3.998565720193696e-07 0.00021 3.9986657201936963e-07 0 3.9988670500950675e-07 0 3.9989670500950677e-07 0.00021 3.999067050095068e-07 0 4.0015913738053786e-07 0 4.0016913738053787e-07 0.00021 4.001791373805379e-07 0 4.0064832131052003e-07 0 4.0065832131052004e-07 0.00021 4.0066832131052005e-07 0 4.0092838460408774e-07 0 4.0093838460408775e-07 0.00021 4.0094838460408777e-07 0 4.026632617892313e-07 0 4.0267326178923133e-07 0.00021 4.0268326178923134e-07 0 4.0324204457412227e-07 0 4.032520445741223e-07 0.00021 4.032620445741223e-07 0 4.035893648368243e-07 0 4.035993648368243e-07 0.00021 4.036093648368243e-07 0 4.0372503468643017e-07 0 4.037350346864302e-07 0.00021 4.037450346864302e-07 0 4.0392185372637764e-07 0 4.0393185372637765e-07 0.00021 4.0394185372637766e-07 0 4.043405553119958e-07 0 4.043505553119958e-07 0.00021 4.043605553119958e-07 0 4.044435309875235e-07 0 4.044535309875235e-07 0.00021 4.0446353098752353e-07 0 4.0459067281761714e-07 0 4.0460067281761715e-07 0.00021 4.0461067281761716e-07 0 4.0515508073151926e-07 0 4.0516508073151927e-07 0.00021 4.051750807315193e-07 0 4.05618514282634e-07 0 4.05628514282634e-07 0.00021 4.05638514282634e-07 0 4.063812982696381e-07 0 4.063912982696381e-07 0.00021 4.064012982696381e-07 0 4.0721268742732114e-07 0 4.0722268742732116e-07 0.00021 4.0723268742732117e-07 0 4.0748067788463535e-07 0 4.0749067788463536e-07 0.00021 4.0750067788463537e-07 0 4.0803519670801407e-07 0 4.080451967080141e-07 0.00021 4.080551967080141e-07 0 4.096564870334751e-07 0 4.096664870334751e-07 0.00021 4.0967648703347513e-07 0 4.097634668839689e-07 0 4.097734668839689e-07 0.00021 4.097834668839689e-07 0 4.098811339393813e-07 0 4.098911339393813e-07 0.00021 4.099011339393813e-07 0 4.100052325222226e-07 0 4.1001523252222263e-07 0.00021 4.1002523252222264e-07 0 4.1031719189392724e-07 0 4.1032719189392726e-07 0.00021 4.1033719189392727e-07 0 4.1058585970677333e-07 0 4.1059585970677334e-07 0.00021 4.1060585970677335e-07 0 4.107442326395768e-07 0 4.107542326395768e-07 0.00021 4.107642326395768e-07 0 4.1078567090711866e-07 0 4.107956709071187e-07 0.00021 4.108056709071187e-07 0 4.122377012778896e-07 0 4.122477012778896e-07 0.00021 4.1225770127788963e-07 0 4.123311102593022e-07 0 4.123411102593022e-07 0.00021 4.123511102593022e-07 0 4.125192994665327e-07 0 4.125292994665327e-07 0.00021 4.1253929946653274e-07 0 4.130091564874211e-07 0 4.130191564874211e-07 0.00021 4.1302915648742113e-07 0 4.139741745142419e-07 0 4.139841745142419e-07 0.00021 4.139941745142419e-07 0 4.141752626726561e-07 0 4.141852626726561e-07 0.00021 4.1419526267265614e-07 0 4.1435799756643867e-07 0 4.143679975664387e-07 0.00021 4.143779975664387e-07 0 4.1439692571848227e-07 0 4.144069257184823e-07 0.00021 4.144169257184823e-07 0 4.1471319276842646e-07 0 4.1472319276842647e-07 0.00021 4.147331927684265e-07 0 4.149082073556053e-07 0 4.149182073556053e-07 0.00021 4.149282073556053e-07 0 4.150078022359189e-07 0 4.150178022359189e-07 0.00021 4.150278022359189e-07 0 4.15527204504495e-07 0 4.15537204504495e-07 0.00021 4.15547204504495e-07 0 4.1588804125076605e-07 0 4.1589804125076606e-07 0.00021 4.159080412507661e-07 0 4.162280129253333e-07 0 4.162380129253333e-07 0.00021 4.1624801292533333e-07 0 4.1639607628480414e-07 0 4.1640607628480415e-07 0.00021 4.1641607628480416e-07 0 4.1672854271207657e-07 0 4.167385427120766e-07 0.00021 4.167485427120766e-07 0 4.188149852682774e-07 0 4.1882498526827743e-07 0.00021 4.1883498526827744e-07 0 4.1888371283651356e-07 0 4.1889371283651357e-07 0.00021 4.189037128365136e-07 0 4.1955520586054657e-07 0 4.195652058605466e-07 0.00021 4.195752058605466e-07 0 4.1971264271775094e-07 0 4.1972264271775095e-07 0.00021 4.1973264271775096e-07 0 4.1989267014154406e-07 0 4.1990267014154407e-07 0.00021 4.199126701415441e-07 0 4.1991784851604714e-07 0 4.1992784851604715e-07 0.00021 4.1993784851604716e-07 0 4.2048747320290835e-07 0 4.2049747320290836e-07 0.00021 4.205074732029084e-07 0 4.205074732029084e-07 0 4.205174732029084e-07 0.00021 4.205274732029084e-07 0 4.205274732029084e-07 0 4.205374732029084e-07 0.00021 4.205474732029084e-07 0 4.2091138605623486e-07 0 4.2092138605623487e-07 0.00021 4.209313860562349e-07 0 4.209721388178145e-07 0 4.209821388178145e-07 0.00021 4.2099213881781453e-07 0 4.21445514867073e-07 0 4.21455514867073e-07 0.00021 4.21465514867073e-07 0 4.2154359568371363e-07 0 4.2155359568371364e-07 0.00021 4.2156359568371365e-07 0 4.2252769070003864e-07 0 4.2253769070003865e-07 0.00021 4.2254769070003866e-07 0 4.2254769070003866e-07 0 4.2255769070003867e-07 0.00021 4.225676907000387e-07 0 4.2260045477442205e-07 0 4.2261045477442206e-07 0.00021 4.2262045477442207e-07 0 4.227612900405623e-07 0 4.2277129004056233e-07 0.00021 4.2278129004056234e-07 0 4.229006183232194e-07 0 4.229106183232194e-07 0.00021 4.229206183232194e-07 0 4.2303929266610214e-07 0 4.2304929266610215e-07 0.00021 4.2305929266610216e-07 0 4.2305929266610216e-07 0 4.2306929266610217e-07 0.00021 4.230792926661022e-07 0 4.232773925130586e-07 0 4.232873925130586e-07 0.00021 4.232973925130586e-07 0 4.2341282230855496e-07 0 4.23422822308555e-07 0.00021 4.23432822308555e-07 0 4.2370186012192477e-07 0 4.237118601219248e-07 0.00021 4.237218601219248e-07 0 4.2480301856735176e-07 0 4.2481301856735177e-07 0.00021 4.248230185673518e-07 0 4.248230185673518e-07 0 4.248330185673518e-07 0.00021 4.248430185673518e-07 0 4.250003569447549e-07 0 4.250103569447549e-07 0.00021 4.250203569447549e-07 0 4.2502236548312e-07 0 4.2503236548312e-07 0.00021 4.2504236548312e-07 0 4.2590409750554977e-07 0 4.259140975055498e-07 0.00021 4.259240975055498e-07 0 4.259240975055498e-07 0 4.259340975055498e-07 0.00021 4.259440975055498e-07 0 4.259882208032294e-07 0 4.259982208032294e-07 0.00021 4.260082208032294e-07 0 4.263390077129977e-07 0 4.263490077129977e-07 0.00021 4.263590077129977e-07 0 4.263590077129977e-07 0 4.2636900771299774e-07 0.00021 4.2637900771299775e-07 0 4.2648122112047786e-07 0 4.264912211204779e-07 0.00021 4.265012211204779e-07 0 4.2681797923047087e-07 0 4.268279792304709e-07 0.00021 4.268379792304709e-07 0 4.268379792304709e-07 0 4.268479792304709e-07 0.00021 4.268579792304709e-07 0 4.2690771943674987e-07 0 4.269177194367499e-07 0.00021 4.269277194367499e-07 0 4.2719849645301954e-07 0 4.2720849645301955e-07 0.00021 4.2721849645301956e-07 0 4.2754626258519344e-07 0 4.2755626258519346e-07 0.00021 4.2756626258519347e-07 0 4.2779603780719024e-07 0 4.2780603780719025e-07 0.00021 4.2781603780719026e-07 0 4.280250560489181e-07 0 4.2803505604891814e-07 0.00021 4.2804505604891815e-07 0 4.282326593158257e-07 0 4.282426593158257e-07 0.00021 4.282526593158257e-07 0 4.28320963838239e-07 0 4.28330963838239e-07 0.00021 4.2834096383823903e-07 0 4.2841049110047784e-07 0 4.2842049110047786e-07 0.00021 4.2843049110047787e-07 0 4.2861397389261744e-07 0 4.2862397389261745e-07 0.00021 4.2863397389261746e-07 0 4.289189554194883e-07 0 4.289289554194883e-07 0.00021 4.289389554194883e-07 0 4.2965710400915614e-07 0 4.2966710400915615e-07 0.00021 4.2967710400915616e-07 0 4.2973289489057863e-07 0 4.2974289489057864e-07 0.00021 4.2975289489057866e-07 0 4.3040217933925306e-07 0 4.3041217933925307e-07 0.00021 4.304221793392531e-07 0 4.308880346092158e-07 0 4.3089803460921584e-07 0.00021 4.3090803460921585e-07 0 4.3108674489405267e-07 0 4.310967448940527e-07 0.00021 4.311067448940527e-07 0 4.3165734915546994e-07 0 4.3166734915546995e-07 0.00021 4.3167734915546996e-07 0 4.3167734915546996e-07 0 4.3168734915547e-07 0.00021 4.3169734915547e-07 0 4.317933800651789e-07 0 4.318033800651789e-07 0.00021 4.318133800651789e-07 0 4.318445473254547e-07 0 4.318545473254547e-07 0.00021 4.318645473254547e-07 0 4.318978095223858e-07 0 4.319078095223858e-07 0.00021 4.319178095223858e-07 0 4.3211399759118e-07 0 4.3212399759118e-07 0.00021 4.3213399759118e-07 0 4.3338030023243173e-07 0 4.3339030023243174e-07 0.00021 4.3340030023243175e-07 0 4.336719235582534e-07 0 4.336819235582534e-07 0.00021 4.336919235582534e-07 0 4.3402641365561614e-07 0 4.3403641365561615e-07 0.00021 4.3404641365561616e-07 0 4.3411277734618965e-07 0 4.3412277734618966e-07 0.00021 4.3413277734618967e-07 0 4.350016049984736e-07 0 4.350116049984736e-07 0.00021 4.3502160499847363e-07 0 4.350771261357041e-07 0 4.350871261357041e-07 0.00021 4.3509712613570413e-07 0 4.36562384894783e-07 0 4.36572384894783e-07 0.00021 4.3658238489478303e-07 0 4.366879541073265e-07 0 4.366979541073265e-07 0.00021 4.367079541073265e-07 0 4.368039289354783e-07 0 4.368139289354783e-07 0.00021 4.368239289354783e-07 0 4.368239289354783e-07 0 4.368339289354783e-07 0.00021 4.368439289354783e-07 0 4.3684981058915493e-07 0 4.3685981058915494e-07 0.00021 4.3686981058915495e-07 0 4.3686981058915495e-07 0 4.3687981058915496e-07 0.00021 4.3688981058915497e-07 0 4.3692241314430476e-07 0 4.3693241314430477e-07 0.00021 4.369424131443048e-07 0 4.369424131443048e-07 0 4.369524131443048e-07 0.00021 4.369624131443048e-07 0 4.3703022671068014e-07 0 4.3704022671068015e-07 0.00021 4.3705022671068016e-07 0 4.379300043634824e-07 0 4.379400043634824e-07 0.00021 4.379500043634824e-07 0 4.3798193858286756e-07 0 4.3799193858286757e-07 0.00021 4.380019385828676e-07 0 4.380446035244036e-07 0 4.380546035244036e-07 0.00021 4.380646035244036e-07 0 4.3818458448260764e-07 0 4.3819458448260765e-07 0.00021 4.3820458448260766e-07 0 4.382871667036199e-07 0 4.3829716670361994e-07 0.00021 4.3830716670361995e-07 0 4.3853418947206914e-07 0 4.3854418947206915e-07 0.00021 4.3855418947206916e-07 0 4.3860948822742017e-07 0 4.386194882274202e-07 0.00021 4.386294882274202e-07 0 4.3910966408462343e-07 0 4.3911966408462344e-07 0.00021 4.3912966408462345e-07 0 4.394934738538855e-07 0 4.3950347385388553e-07 0.00021 4.3951347385388554e-07 0 4.395813914036778e-07 0 4.395913914036778e-07 0.00021 4.396013914036778e-07 0 4.4012863260675794e-07 0 4.4013863260675795e-07 0.00021 4.4014863260675796e-07 0 4.4024578879384855e-07 0 4.4025578879384856e-07 0.00021 4.402657887938486e-07 0 4.406320038656068e-07 0 4.406420038656068e-07 0.00021 4.406520038656068e-07 0 4.408475650041964e-07 0 4.408575650041964e-07 0.00021 4.408675650041964e-07 0 4.4090937969753266e-07 0 4.4091937969753267e-07 0.00021 4.409293796975327e-07 0 4.410240369571435e-07 0 4.4103403695714353e-07 0.00021 4.4104403695714354e-07 0 4.4124946942776e-07 0 4.4125946942776e-07 0.00021 4.4126946942776e-07 0 4.4134612599050407e-07 0 4.413561259905041e-07 0.00021 4.413661259905041e-07 0 4.4138304079859364e-07 0 4.4139304079859365e-07 0.00021 4.4140304079859366e-07 0 4.421491898546963e-07 0 4.421591898546963e-07 0.00021 4.4216918985469634e-07 0 4.423489769622041e-07 0 4.423589769622041e-07 0.00021 4.423689769622041e-07 0 4.433384936370968e-07 0 4.4334849363709683e-07 0.00021 4.4335849363709684e-07 0 4.434900929021541e-07 0 4.4350009290215413e-07 0.00021 4.4351009290215414e-07 0 4.4358363727593386e-07 0 4.435936372759339e-07 0.00021 4.436036372759339e-07 0 4.439877288400728e-07 0 4.439977288400728e-07 0.00021 4.440077288400728e-07 0 4.441542002861264e-07 0 4.441642002861264e-07 0.00021 4.4417420028612643e-07 0 4.444328377150217e-07 0 4.444428377150217e-07 0.00021 4.444528377150217e-07 0 4.445381544133211e-07 0 4.4454815441332113e-07 0.00021 4.4455815441332114e-07 0 4.4475669985493625e-07 0 4.4476669985493626e-07 0.00021 4.447766998549363e-07 0 4.4481315222351344e-07 0 4.4482315222351345e-07 0.00021 4.4483315222351346e-07 0 4.455009075060275e-07 0 4.455109075060275e-07 0.00021 4.4552090750602753e-07 0 4.4566429399847115e-07 0 4.4567429399847116e-07 0.00021 4.456842939984712e-07 0 4.457472250467545e-07 0 4.457572250467545e-07 0.00021 4.457672250467545e-07 0 4.4666540918248296e-07 0 4.46675409182483e-07 0.00021 4.46685409182483e-07 0 4.46685409182483e-07 0 4.46695409182483e-07 0.00021 4.46705409182483e-07 0 4.468539458268005e-07 0 4.468639458268005e-07 0.00021 4.468739458268005e-07 0 4.468740095939157e-07 0 4.468840095939157e-07 0.00021 4.468940095939157e-07 0 4.469896466303517e-07 0 4.469996466303517e-07 0.00021 4.470096466303517e-07 0 4.4803303472946696e-07 0 4.4804303472946697e-07 0.00021 4.48053034729467e-07 0 4.480800530002449e-07 0 4.480900530002449e-07 0.00021 4.4810005300024493e-07 0 4.483503139286025e-07 0 4.4836031392860253e-07 0.00021 4.4837031392860255e-07 0 4.489238108626758e-07 0 4.4893381086267583e-07 0.00021 4.4894381086267584e-07 0 4.4987407400560826e-07 0 4.4988407400560827e-07 0.00021 4.498940740056083e-07 0 4.5038802697299197e-07 0 4.50398026972992e-07 0.00021 4.50408026972992e-07 0 4.5056639233760227e-07 0 4.505763923376023e-07 0.00021 4.505863923376023e-07 0 4.5129231963441e-07 0 4.5130231963441e-07 0.00021 4.5131231963441e-07 0 4.5131231963441e-07 0 4.5132231963441004e-07 0.00021 4.5133231963441005e-07 0 4.514571882470199e-07 0 4.514671882470199e-07 0.00021 4.5147718824701993e-07 0 4.5152848154900913e-07 0 4.5153848154900914e-07 0.00021 4.5154848154900916e-07 0 4.519253804686229e-07 0 4.519353804686229e-07 0.00021 4.5194538046862293e-07 0 4.522854386960826e-07 0 4.522954386960826e-07 0.00021 4.523054386960826e-07 0 4.5270236689683386e-07 0 4.5271236689683387e-07 0.00021 4.527223668968339e-07 0 4.527223668968339e-07 0 4.527323668968339e-07 0.00021 4.527423668968339e-07 0 4.527469492298446e-07 0 4.527569492298446e-07 0.00021 4.527669492298446e-07 0 4.530946173327818e-07 0 4.531046173327818e-07 0.00021 4.531146173327818e-07 0 4.534356515015183e-07 0 4.5344565150151834e-07 0.00021 4.5345565150151835e-07 0 4.537053359526363e-07 0 4.5371533595263634e-07 0.00021 4.5372533595263635e-07 0 4.5400620596309697e-07 0 4.54016205963097e-07 0.00021 4.54026205963097e-07 0 4.544362265008238e-07 0 4.544462265008238e-07 0.00021 4.544562265008238e-07 0 4.544827591999326e-07 0 4.544927591999326e-07 0.00021 4.545027591999326e-07 0 4.5529258240490043e-07 0 4.5530258240490044e-07 0.00021 4.5531258240490045e-07 0 4.5588385284736766e-07 0 4.5589385284736767e-07 0.00021 4.559038528473677e-07 0 4.5605334970894507e-07 0 4.560633497089451e-07 0.00021 4.560733497089451e-07 0 4.562925174572422e-07 0 4.563025174572422e-07 0.00021 4.563125174572422e-07 0 4.567090565984467e-07 0 4.567190565984467e-07 0.00021 4.5672905659844673e-07 0 4.569449291224082e-07 0 4.5695492912240824e-07 0.00021 4.5696492912240825e-07 0 4.573200884966156e-07 0 4.573300884966156e-07 0.00021 4.573400884966156e-07 0 4.5735052552679504e-07 0 4.5736052552679505e-07 0.00021 4.5737052552679507e-07 0 4.574054706676316e-07 0 4.574154706676316e-07 0.00021 4.574254706676316e-07 0 4.575014607924342e-07 0 4.5751146079243424e-07 0.00021 4.5752146079243425e-07 0 4.575239793234853e-07 0 4.575339793234853e-07 0.00021 4.575439793234853e-07 0 4.5782739009304686e-07 0 4.5783739009304687e-07 0.00021 4.578473900930469e-07 0 4.57954975357757e-07 0 4.57964975357757e-07 0.00021 4.5797497535775703e-07 0 4.581060492322486e-07 0 4.581160492322486e-07 0.00021 4.581260492322486e-07 0 4.5847514818173154e-07 0 4.5848514818173155e-07 0.00021 4.5849514818173157e-07 0 4.589520258260975e-07 0 4.5896202582609754e-07 0.00021 4.5897202582609755e-07 0 4.5931628300995796e-07 0 4.5932628300995797e-07 0.00021 4.59336283009958e-07 0 4.5934693573418454e-07 0 4.5935693573418455e-07 0.00021 4.5936693573418456e-07 0 4.59443114797088e-07 0 4.59453114797088e-07 0.00021 4.59463114797088e-07 0 4.5964408594907765e-07 0 4.5965408594907767e-07 0.00021 4.596640859490777e-07 0 4.6095897694699253e-07 0 4.6096897694699255e-07 0.00021 4.6097897694699256e-07 0 4.612512066206351e-07 0 4.612612066206351e-07 0.00021 4.612712066206351e-07 0 4.615662042208458e-07 0 4.615762042208458e-07 0.00021 4.6158620422084583e-07 0 4.619078142638533e-07 0 4.619178142638533e-07 0.00021 4.619278142638533e-07 0 4.623317565834698e-07 0 4.623417565834698e-07 0.00021 4.6235175658346983e-07 0 4.626299951184905e-07 0 4.626399951184905e-07 0.00021 4.626499951184905e-07 0 4.627223467926769e-07 0 4.627323467926769e-07 0.00021 4.627423467926769e-07 0 4.6296711768317537e-07 0 4.629771176831754e-07 0.00021 4.629871176831754e-07 0 4.6360279550027536e-07 0 4.636127955002754e-07 0.00021 4.636227955002754e-07 0 4.6376481706737773e-07 0 4.6377481706737775e-07 0.00021 4.6378481706737776e-07 0 4.640664772488492e-07 0 4.640764772488492e-07 0.00021 4.6408647724884923e-07 0 4.649391181143578e-07 0 4.6494911811435783e-07 0.00021 4.6495911811435784e-07 0 4.6509332285021183e-07 0 4.6510332285021184e-07 0.00021 4.6511332285021186e-07 0 4.6534134988849275e-07 0 4.6535134988849277e-07 0.00021 4.653613498884928e-07 0 4.662271176088386e-07 0 4.662371176088386e-07 0.00021 4.662471176088386e-07 0 4.665627722903516e-07 0 4.665727722903516e-07 0.00021 4.665827722903516e-07 0 4.6694589044385967e-07 0 4.669558904438597e-07 0.00021 4.669658904438597e-07 0 4.669658904438597e-07 0 4.669758904438597e-07 0.00021 4.669858904438597e-07 0 4.6720418909508697e-07 0 4.67214189095087e-07 0.00021 4.67224189095087e-07 0 4.677814983665679e-07 0 4.677914983665679e-07 0.00021 4.6780149836656794e-07 0 4.683197236158039e-07 0 4.683297236158039e-07 0.00021 4.6833972361580394e-07 0 4.687627772370598e-07 0 4.687727772370598e-07 0.00021 4.687827772370598e-07 0 4.6889698146795397e-07 0 4.68906981467954e-07 0.00021 4.68916981467954e-07 0 4.691708380395315e-07 0 4.691808380395315e-07 0.00021 4.691908380395315e-07 0 4.695137528503142e-07 0 4.6952375285031424e-07 0.00021 4.6953375285031425e-07 0 4.695340895614082e-07 0 4.695440895614082e-07 0.00021 4.695540895614082e-07 0 4.695540895614082e-07 0 4.6956408956140824e-07 0.00021 4.6957408956140825e-07 0 4.6958478310732144e-07 0 4.6959478310732145e-07 0.00021 4.6960478310732147e-07 0 4.7014153638406757e-07 0 4.701515363840676e-07 0.00021 4.701615363840676e-07 0 4.7021216341211725e-07 0 4.7022216341211726e-07 0.00021 4.7023216341211727e-07 0 4.7023216341211727e-07 0 4.702421634121173e-07 0.00021 4.702521634121173e-07 0 4.7026201041584327e-07 0 4.702720104158433e-07 0.00021 4.702820104158433e-07 0 4.705700168461013e-07 0 4.705800168461013e-07 0.00021 4.705900168461013e-07 0 4.7074415890950416e-07 0 4.7075415890950417e-07 0.00021 4.707641589095042e-07 0 4.71103536418319e-07 0 4.7111353641831903e-07 0.00021 4.7112353641831904e-07 0 4.7115546937805555e-07 0 4.7116546937805556e-07 0.00021 4.7117546937805557e-07 0 4.7143588652738076e-07 0 4.714458865273808e-07 0.00021 4.714558865273808e-07 0 4.714558865273808e-07 0 4.714658865273808e-07 0.00021 4.714758865273808e-07 0 4.7153708491064254e-07 0 4.7154708491064255e-07 0.00021 4.7155708491064256e-07 0 4.718593650147797e-07 0 4.718693650147797e-07 0.00021 4.718793650147797e-07 0 4.724304240541137e-07 0 4.724404240541137e-07 0.00021 4.7245042405411373e-07 0 4.724770855108986e-07 0 4.724870855108986e-07 0.00021 4.724970855108986e-07 0 4.72831425518793e-07 0 4.72841425518793e-07 0.00021 4.72851425518793e-07 0 4.731524344308531e-07 0 4.7316243443085313e-07 0.00021 4.7317243443085314e-07 0 4.7321832267548977e-07 0 4.732283226754898e-07 0.00021 4.732383226754898e-07 0 4.73315811153403e-07 0 4.7332581115340303e-07 0.00021 4.7333581115340304e-07 0 4.733704037260307e-07 0 4.733804037260307e-07 0.00021 4.733904037260307e-07 0 4.734970001452139e-07 0 4.7350700014521393e-07 0.00021 4.7351700014521394e-07 0 4.736635869136172e-07 0 4.736735869136172e-07 0.00021 4.7368358691361723e-07 0 4.738039732694646e-07 0 4.738139732694646e-07 0.00021 4.7382397326946464e-07 0 4.74231033622954e-07 0 4.74241033622954e-07 0.00021 4.74251033622954e-07 0 4.742755029938838e-07 0 4.742855029938838e-07 0.00021 4.7429550299388384e-07 0 4.743639804557804e-07 0 4.743739804557804e-07 0.00021 4.743839804557804e-07 0 4.750246826594924e-07 0 4.750346826594924e-07 0.00021 4.7504468265949243e-07 0 4.750688974685074e-07 0 4.7507889746850743e-07 0.00021 4.7508889746850745e-07 0 4.752216065981671e-07 0 4.752316065981671e-07 0.00021 4.752416065981671e-07 0 4.757253754777663e-07 0 4.757353754777663e-07 0.00021 4.757453754777663e-07 0 4.7669387650575156e-07 0 4.7670387650575157e-07 0.00021 4.767138765057516e-07 0 4.768846265719447e-07 0 4.768946265719446e-07 0.00021 4.769046265719446e-07 0 4.772488497424296e-07 0 4.772588497424295e-07 0.00021 4.772688497424295e-07 0 4.776886082513029e-07 0 4.776986082513028e-07 0.00021 4.777086082513028e-07 0 4.780013672273088e-07 0 4.780113672273088e-07 0.00021 4.780213672273087e-07 0 4.781929715076805e-07 0 4.782029715076804e-07 0.00021 4.782129715076804e-07 0 4.787897670647835e-07 0 4.787997670647835e-07 0.00021 4.788097670647834e-07 0 4.788515169808351e-07 0 4.788615169808351e-07 0.00021 4.78871516980835e-07 0 4.791935277998672e-07 0 4.792035277998672e-07 0.00021 4.792135277998671e-07 0 4.79236948262981e-07 0 4.792469482629809e-07 0.00021 4.792569482629809e-07 0 4.797769864872765e-07 0 4.797869864872764e-07 0.00021 4.797969864872764e-07 0 4.800907788074458e-07 0 4.801007788074457e-07 0.00021 4.801107788074457e-07 0 4.802544314288775e-07 0 4.802644314288775e-07 0.00021 4.802744314288774e-07 0 4.808439931030103e-07 0 4.808539931030102e-07 0.00021 4.808639931030102e-07 0 4.811491348023759e-07 0 4.811591348023758e-07 0.00021 4.811691348023758e-07 0 4.811983923413637e-07 0 4.812083923413637e-07 0.00021 4.812183923413637e-07 0 4.816911391027744e-07 0 4.817011391027744e-07 0.00021 4.817111391027744e-07 0 4.818043553769669e-07 0 4.818143553769669e-07 0.00021 4.818243553769669e-07 0 4.818305630110473e-07 0 4.818405630110473e-07 0.00021 4.818505630110472e-07 0 4.822244897553812e-07 0 4.822344897553812e-07 0.00021 4.822444897553812e-07 0 4.826173781083898e-07 0 4.826273781083898e-07 0.00021 4.826373781083897e-07 0 4.836917481364188e-07 0 4.837017481364188e-07 0.00021 4.837117481364188e-07 0 4.843628724184154e-07 0 4.843728724184154e-07 0.00021 4.843828724184153e-07 0 4.846372588397164e-07 0 4.846472588397164e-07 0.00021 4.846572588397163e-07 0 4.84807122303654e-07 0 4.84817122303654e-07 0.00021 4.848271223036539e-07 0 4.856521528962729e-07 0 4.856621528962729e-07 0.00021 4.856721528962728e-07 0 4.857158915630952e-07 0 4.857258915630952e-07 0.00021 4.857358915630951e-07 0 4.857358915630953e-07 0 4.857458915630952e-07 0.00021 4.857558915630952e-07 0 4.858581751592848e-07 0 4.858681751592848e-07 0.00021 4.858781751592848e-07 0 4.858781751592849e-07 0 4.858881751592848e-07 0.00021 4.858981751592848e-07 0 4.861597619621707e-07 0 4.861697619621707e-07 0.00021 4.861797619621706e-07 0 4.867888617049226e-07 0 4.867988617049226e-07 0.00021 4.868088617049225e-07 0 4.869658812370704e-07 0 4.869758812370704e-07 0.00021 4.869858812370703e-07 0 4.872280456194767e-07 0 4.872380456194766e-07 0.00021 4.872480456194766e-07 0 4.872480456194767e-07 0 4.872580456194766e-07 0.00021 4.872680456194766e-07 0 4.877406191615737e-07 0 4.877506191615737e-07 0.00021 4.877606191615736e-07 0 4.877798935037194e-07 0 4.877898935037194e-07 0.00021 4.877998935037193e-07 0 4.879053228596402e-07 0 4.879153228596402e-07 0.00021 4.879253228596402e-07 0 4.880559528875213e-07 0 4.880659528875212e-07 0.00021 4.880759528875212e-07 0 4.884253480361048e-07 0 4.884353480361047e-07 0.00021 4.884453480361047e-07 0 4.885253798752868e-07 0 4.885353798752868e-07 0.00021 4.885453798752867e-07 0 4.903998709800316e-07 0 4.904098709800315e-07 0.00021 4.904198709800315e-07 0 4.90658178589429e-07 0 4.906681785894289e-07 0.00021 4.906781785894289e-07 0 4.907367308291656e-07 0 4.907467308291655e-07 0.00021 4.907567308291655e-07 0 4.923490179386468e-07 0 4.923590179386468e-07 0.00021 4.923690179386467e-07 0 4.925703300031505e-07 0 4.925803300031505e-07 0.00021 4.925903300031505e-07 0 4.928899144788151e-07 0 4.928999144788151e-07 0.00021 4.929099144788151e-07 0 4.932245127451942e-07 0 4.932345127451941e-07 0.00021 4.932445127451941e-07 0 4.939024665365563e-07 0 4.939124665365563e-07 0.00021 4.939224665365562e-07 0 4.942935932911579e-07 0 4.943035932911578e-07 0.00021 4.943135932911578e-07 0 4.944204936453671e-07 0 4.944304936453671e-07 0.00021 4.94440493645367e-07 0 4.945996336570633e-07 0 4.946096336570633e-07 0.00021 4.946196336570632e-07 0 4.946488520763541e-07 0 4.94658852076354e-07 0.00021 4.94668852076354e-07 0 4.949141155360775e-07 0 4.949241155360775e-07 0.00021 4.949341155360774e-07 0 4.959394506370397e-07 0 4.959494506370396e-07 0.00021 4.959594506370396e-07 0 4.9683703940216e-07 0 4.968470394021599e-07 0.00021 4.968570394021599e-07 0 4.97112539569715e-07 0 4.97122539569715e-07 0.00021 4.971325395697149e-07 0 4.97132539569715e-07 0 4.97142539569715e-07 0.00021 4.97152539569715e-07 0 4.973391122238177e-07 0 4.973491122238177e-07 0.00021 4.973591122238177e-07 0 4.974585190066764e-07 0 4.974685190066764e-07 0.00021 4.974785190066763e-07 0 4.977598858269512e-07 0 4.977698858269511e-07 0.00021 4.977798858269511e-07 0 4.986734880719046e-07 0 4.986834880719045e-07 0.00021 4.986934880719045e-07 0 4.987596244794398e-07 0 4.987696244794397e-07 0.00021 4.987796244794397e-07 0 4.991036165133273e-07 0 4.991136165133272e-07 0.00021 4.991236165133272e-07 0 4.996867138642288e-07 0 4.996967138642288e-07 0.00021 4.997067138642287e-07 0 4.999427019178125e-07 0 4.999527019178124e-07 0.00021 4.999627019178124e-07 0 4.999627019178125e-07 0 4.999727019178125e-07 0.00021 4.999827019178124e-07 0 )
VIN4 4 0 pwl(0 0 3.163673139050766e-10 0 3.263673139050766e-10 0.00021 3.363673139050766e-10 0 8.057739226086916e-10 0 8.157739226086915e-10 0.00021 8.257739226086915e-10 0 8.257739226086916e-10 0 8.357739226086916e-10 0.00021 8.457739226086915e-10 0 8.457739226086917e-10 0 8.557739226086916e-10 0.00021 8.657739226086916e-10 0 1.0805349763251708e-09 0 1.0905349763251707e-09 0.00021 1.1005349763251707e-09 0 1.8629063849611954e-09 0 1.8729063849611955e-09 0.00021 1.8829063849611957e-09 0 2.1862262022414666e-09 0 2.1962262022414667e-09 0.00021 2.206226202241467e-09 0 2.5487708539976542e-09 0 2.5587708539976544e-09 0.00021 2.5687708539976546e-09 0 3.900828123954003e-09 0 3.9108281239540025e-09 0.00021 3.920828123954002e-09 0 6.808549602566437e-09 0 6.818549602566437e-09 0.00021 6.828549602566437e-09 0 8.386035166355434e-09 0 8.396035166355434e-09 0.00021 8.406035166355433e-09 0 8.406035166355433e-09 0 8.416035166355433e-09 0.00021 8.426035166355433e-09 0 9.475818725364264e-09 0 9.485818725364264e-09 0.00021 9.495818725364264e-09 0 9.510617614125812e-09 0 9.520617614125812e-09 0.00021 9.530617614125811e-09 0 1.0023929759166125e-08 0 1.0033929759166125e-08 0.00021 1.0043929759166124e-08 0 1.0431417613347502e-08 0 1.0441417613347502e-08 0.00021 1.0451417613347502e-08 0 1.1943373766661979e-08 0 1.1953373766661979e-08 0.00021 1.1963373766661979e-08 0 1.2113298586914739e-08 0 1.2123298586914739e-08 0.00021 1.2133298586914738e-08 0 1.2260711933936346e-08 0 1.2270711933936346e-08 0.00021 1.2280711933936345e-08 0 1.2976977252236837e-08 0 1.2986977252236836e-08 0.00021 1.2996977252236836e-08 0 1.2996977252236836e-08 0 1.3006977252236836e-08 0.00021 1.3016977252236836e-08 0 1.3059698057518226e-08 0 1.3069698057518226e-08 0.00021 1.3079698057518226e-08 0 1.3554193148711398e-08 0 1.3564193148711398e-08 0.00021 1.3574193148711397e-08 0 1.3925976293338532e-08 0 1.3935976293338531e-08 0.00021 1.3945976293338531e-08 0 1.4760061978158046e-08 0 1.4770061978158045e-08 0.00021 1.4780061978158045e-08 0 1.49586236193587e-08 0 1.4968623619358702e-08 0.00021 1.4978623619358704e-08 0 1.5173764785765802e-08 0 1.5183764785765803e-08 0.00021 1.5193764785765805e-08 0 1.6062769115196344e-08 0 1.6072769115196345e-08 0.00021 1.6082769115196347e-08 0 1.689087164805539e-08 0 1.690087164805539e-08 0.00021 1.6910871648055392e-08 0 1.7046132099359676e-08 0 1.7056132099359678e-08 0.00021 1.706613209935968e-08 0 1.7147297581381256e-08 0 1.7157297581381258e-08 0.00021 1.716729758138126e-08 0 1.7734478682070364e-08 0 1.7744478682070366e-08 0.00021 1.7754478682070367e-08 0 1.799287429964015e-08 0 1.800287429964015e-08 0.00021 1.8012874299640152e-08 0 1.8403123144624482e-08 0 1.8413123144624484e-08 0.00021 1.8423123144624485e-08 0 1.8906509805553986e-08 0 1.8916509805553988e-08 0.00021 1.892650980555399e-08 0 1.949795171462491e-08 0 1.9507951714624912e-08 0.00021 1.9517951714624913e-08 0 2.090347298501518e-08 0 2.0913472985015182e-08 0.00021 2.0923472985015183e-08 0 2.097724358913749e-08 0 2.098724358913749e-08 0.00021 2.099724358913749e-08 0 2.168082994842668e-08 0 2.1690829948426683e-08 0.00021 2.1700829948426684e-08 0 2.222046396237992e-08 0 2.2230463962379922e-08 0.00021 2.2240463962379923e-08 0 2.3131528163178108e-08 0 2.314152816317811e-08 0.00021 2.315152816317811e-08 0 2.3419044310768286e-08 0 2.3429044310768287e-08 0.00021 2.343904431076829e-08 0 2.3644012949641834e-08 0 2.3654012949641835e-08 0.00021 2.3664012949641837e-08 0 2.4036224461551068e-08 0 2.404622446155107e-08 0.00021 2.405622446155107e-08 0 2.4163169715160956e-08 0 2.4173169715160957e-08 0.00021 2.418316971516096e-08 0 2.452116450988346e-08 0 2.4531164509883463e-08 0.00021 2.4541164509883464e-08 0 2.4572074296753202e-08 0 2.4582074296753204e-08 0.00021 2.4592074296753205e-08 0 2.5362609045714962e-08 0 2.5372609045714963e-08 0.00021 2.5382609045714965e-08 0 2.645664336615303e-08 0 2.646664336615303e-08 0.00021 2.647664336615303e-08 0 2.6721652553931222e-08 0 2.6731652553931224e-08 0.00021 2.6741652553931225e-08 0 2.823976341123225e-08 0 2.824976341123225e-08 0.00021 2.8259763411232253e-08 0 2.8291460674327647e-08 0 2.830146067432765e-08 0.00021 2.831146067432765e-08 0 2.8425641213875896e-08 0 2.8435641213875897e-08 0.00021 2.84456412138759e-08 0 2.8568320581731456e-08 0 2.8578320581731457e-08 0.00021 2.858832058173146e-08 0 2.893482791145716e-08 0 2.894482791145716e-08 0.00021 2.8954827911457163e-08 0 2.9383985636496842e-08 0 2.9393985636496844e-08 0.00021 2.9403985636496845e-08 0 2.9641238185672888e-08 0 2.965123818567289e-08 0.00021 2.966123818567289e-08 0 2.9701024122041966e-08 0 2.9711024122041968e-08 0.00021 2.972102412204197e-08 0 3.0660059973195454e-08 0 3.067005997319545e-08 0.00021 3.068005997319545e-08 0 3.089884265261547e-08 0 3.0908842652615465e-08 0.00021 3.091884265261546e-08 0 3.0953356211652523e-08 0 3.096335621165252e-08 0.00021 3.097335621165252e-08 0 3.1323549696870644e-08 0 3.133354969687064e-08 0.00021 3.134354969687064e-08 0 3.146586952530982e-08 0 3.147586952530982e-08 0.00021 3.148586952530982e-08 0 3.166551214536639e-08 0 3.167551214536639e-08 0.00021 3.1685512145366385e-08 0 3.178641016585337e-08 0 3.1796410165853366e-08 0.00021 3.1806410165853364e-08 0 3.203369004217584e-08 0 3.204369004217584e-08 0.00021 3.205369004217584e-08 0 3.251258827866336e-08 0 3.252258827866336e-08 0.00021 3.2532588278663356e-08 0 3.255906435989197e-08 0 3.256906435989197e-08 0.00021 3.257906435989197e-08 0 3.3126678486609846e-08 0 3.3136678486609844e-08 0.00021 3.314667848660984e-08 0 3.450912781272917e-08 0 3.451912781272917e-08 0.00021 3.452912781272917e-08 0 3.4924204634998235e-08 0 3.493420463499823e-08 0.00021 3.494420463499823e-08 0 3.669901792440164e-08 0 3.6709017924401635e-08 0.00021 3.671901792440163e-08 0 3.694232856430814e-08 0 3.695232856430814e-08 0.00021 3.6962328564308135e-08 0 3.7559535497510176e-08 0 3.7569535497510174e-08 0.00021 3.757953549751017e-08 0 3.852857107881666e-08 0 3.853857107881666e-08 0.00021 3.8548571078816656e-08 0 3.893464710103129e-08 0 3.894464710103129e-08 0.00021 3.895464710103129e-08 0 3.929179818643846e-08 0 3.9301798186438455e-08 0.00021 3.9311798186438453e-08 0 3.95801449449893e-08 0 3.9590144944989295e-08 0.00021 3.9600144944989294e-08 0 3.961502999910152e-08 0 3.962502999910152e-08 0.00021 3.9635029999101517e-08 0 4.175227035940458e-08 0 4.176227035940458e-08 0.00021 4.1772270359404575e-08 0 4.25540240724267e-08 0 4.25640240724267e-08 0.00021 4.25740240724267e-08 0 4.2804551500982544e-08 0 4.281455150098254e-08 0.00021 4.282455150098254e-08 0 4.364696704766944e-08 0 4.365696704766944e-08 0.00021 4.3666967047669435e-08 0 4.413412405727627e-08 0 4.414412405727627e-08 0.00021 4.415412405727627e-08 0 4.4154124057276275e-08 0 4.416412405727627e-08 0.00021 4.417412405727627e-08 0 4.479766314517822e-08 0 4.480766314517822e-08 0.00021 4.481766314517822e-08 0 4.547622625079742e-08 0 4.5486226250797417e-08 0.00021 4.5496226250797415e-08 0 4.57186964313892e-08 0 4.5728696431389196e-08 0.00021 4.5738696431389194e-08 0 4.57386964313892e-08 0 4.57486964313892e-08 0.00021 4.57586964313892e-08 0 4.703674925796774e-08 0 4.7046749257967736e-08 0.00021 4.7056749257967734e-08 0 4.803864563167536e-08 0 4.804864563167536e-08 0.00021 4.805864563167536e-08 0 4.9864821657417915e-08 0 4.987482165741791e-08 0.00021 4.988482165741791e-08 0 4.9886803000826633e-08 0 4.989680300082663e-08 0.00021 4.990680300082663e-08 0 5.127400251824004e-08 0 5.128400251824004e-08 0.00021 5.129400251824004e-08 0 5.254326182444157e-08 0 5.255326182444157e-08 0.00021 5.2563261824441565e-08 0 5.4072252535775686e-08 0 5.4082252535775684e-08 0.00021 5.409225253577568e-08 0 5.5122789523947786e-08 0 5.5132789523947784e-08 0.00021 5.514278952394778e-08 0 5.528886639074186e-08 0 5.529886639074186e-08 0.00021 5.5308866390741857e-08 0 5.6412984778961474e-08 0 5.642298477896147e-08 0.00021 5.643298477896147e-08 0 5.6660830980436275e-08 0 5.667083098043627e-08 0.00021 5.668083098043627e-08 0 5.6953290078869296e-08 0 5.6963290078869294e-08 0.00021 5.697329007886929e-08 0 5.7643360832365167e-08 0 5.7653360832365165e-08 0.00021 5.766336083236516e-08 0 5.804575985504123e-08 0 5.8055759855041227e-08 0.00021 5.8065759855041225e-08 0 5.846070583466492e-08 0 5.847070583466492e-08 0.00021 5.848070583466492e-08 0 5.8510576868974526e-08 0 5.8520576868974524e-08 0.00021 5.853057686897452e-08 0 5.88518508911295e-08 0 5.8861850891129495e-08 0.00021 5.8871850891129494e-08 0 6.066375988096946e-08 0 6.067375988096946e-08 0.00021 6.068375988096946e-08 0 6.070683965476421e-08 0 6.071683965476421e-08 0.00021 6.072683965476421e-08 0 6.14520419817177e-08 0 6.14620419817177e-08 0.00021 6.14720419817177e-08 0 6.14720419817177e-08 0 6.14820419817177e-08 0.00021 6.149204198171769e-08 0 6.228037107128275e-08 0 6.229037107128275e-08 0.00021 6.230037107128275e-08 0 6.257492938404908e-08 0 6.258492938404907e-08 0.00021 6.259492938404907e-08 0 6.307971122529782e-08 0 6.308971122529782e-08 0.00021 6.309971122529782e-08 0 6.315396931575009e-08 0 6.316396931575009e-08 0.00021 6.317396931575009e-08 0 6.363288396506925e-08 0 6.364288396506925e-08 0.00021 6.365288396506925e-08 0 6.37279997447616e-08 0 6.37379997447616e-08 0.00021 6.37479997447616e-08 0 6.402096035456097e-08 0 6.403096035456096e-08 0.00021 6.404096035456096e-08 0 6.44477163481298e-08 0 6.44577163481298e-08 0.00021 6.44677163481298e-08 0 6.466635557010633e-08 0 6.467635557010633e-08 0.00021 6.468635557010633e-08 0 6.475523463048061e-08 0 6.476523463048061e-08 0.00021 6.477523463048061e-08 0 6.506293995779575e-08 0 6.507293995779575e-08 0.00021 6.508293995779574e-08 0 6.520945263083162e-08 0 6.521945263083162e-08 0.00021 6.522945263083162e-08 0 6.525459962535687e-08 0 6.526459962535686e-08 0.00021 6.527459962535686e-08 0 6.645826992805129e-08 0 6.646826992805128e-08 0.00021 6.647826992805128e-08 0 6.721477934913444e-08 0 6.722477934913443e-08 0.00021 6.723477934913443e-08 0 6.759230503400685e-08 0 6.760230503400684e-08 0.00021 6.761230503400684e-08 0 6.858140365422227e-08 0 6.859140365422227e-08 0.00021 6.860140365422227e-08 0 6.881676988953624e-08 0 6.882676988953623e-08 0.00021 6.883676988953623e-08 0 6.895419402478928e-08 0 6.896419402478928e-08 0.00021 6.897419402478927e-08 0 6.91615135929143e-08 0 6.91715135929143e-08 0.00021 6.91815135929143e-08 0 7.051880880745371e-08 0 7.05288088074537e-08 0.00021 7.05388088074537e-08 0 7.072912326216655e-08 0 7.073912326216655e-08 0.00021 7.074912326216655e-08 0 7.159445304255803e-08 0 7.160445304255803e-08 0.00021 7.161445304255803e-08 0 7.213063275943886e-08 0 7.214063275943886e-08 0.00021 7.215063275943886e-08 0 7.228216342889511e-08 0 7.229216342889511e-08 0.00021 7.230216342889511e-08 0 7.254992032482313e-08 0 7.255992032482313e-08 0.00021 7.256992032482313e-08 0 7.270734334801442e-08 0 7.271734334801442e-08 0.00021 7.272734334801442e-08 0 7.284646760482139e-08 0 7.285646760482139e-08 0.00021 7.286646760482139e-08 0 7.345817242924604e-08 0 7.346817242924604e-08 0.00021 7.347817242924604e-08 0 7.425552060425945e-08 0 7.426552060425945e-08 0.00021 7.427552060425945e-08 0 7.427552060425945e-08 0 7.428552060425945e-08 0.00021 7.429552060425945e-08 0 7.533119177985668e-08 0 7.534119177985667e-08 0.00021 7.535119177985667e-08 0 7.577766573030635e-08 0 7.578766573030635e-08 0.00021 7.579766573030635e-08 0 7.684017622003586e-08 0 7.685017622003586e-08 0.00021 7.686017622003586e-08 0 7.686026044817451e-08 0 7.68702604481745e-08 0.00021 7.68802604481745e-08 0 7.752247245852995e-08 0 7.753247245852994e-08 0.00021 7.754247245852994e-08 0 7.756600627928756e-08 0 7.757600627928756e-08 0.00021 7.758600627928755e-08 0 7.801066065239602e-08 0 7.802066065239602e-08 0.00021 7.803066065239602e-08 0 7.915387558660874e-08 0 7.916387558660874e-08 0.00021 7.917387558660874e-08 0 7.963649411514325e-08 0 7.964649411514325e-08 0.00021 7.965649411514325e-08 0 8.136955337466822e-08 0 8.137955337466821e-08 0.00021 8.138955337466821e-08 0 8.150095187520046e-08 0 8.151095187520046e-08 0.00021 8.152095187520046e-08 0 8.339366946417599e-08 0 8.340366946417599e-08 0.00021 8.341366946417599e-08 0 8.347166586036655e-08 0 8.348166586036655e-08 0.00021 8.349166586036655e-08 0 8.45467444592866e-08 0 8.45567444592866e-08 0.00021 8.45667444592866e-08 0 8.488618429802493e-08 0 8.489618429802493e-08 0.00021 8.490618429802493e-08 0 8.526938111919446e-08 0 8.527938111919446e-08 0.00021 8.528938111919446e-08 0 8.560135527913431e-08 0 8.561135527913431e-08 0.00021 8.562135527913431e-08 0 8.590684960012352e-08 0 8.591684960012351e-08 0.00021 8.592684960012351e-08 0 8.726851860088737e-08 0 8.727851860088737e-08 0.00021 8.728851860088736e-08 0 8.784495119386075e-08 0 8.785495119386074e-08 0.00021 8.786495119386074e-08 0 8.809352364289086e-08 0 8.810352364289086e-08 0.00021 8.811352364289085e-08 0 8.823454447664107e-08 0 8.824454447664106e-08 0.00021 8.825454447664106e-08 0 8.82814139626035e-08 0 8.82914139626035e-08 0.00021 8.830141396260349e-08 0 8.950471420464291e-08 0 8.951471420464291e-08 0.00021 8.95247142046429e-08 0 9.076185050410331e-08 0 9.07718505041033e-08 0.00021 9.07818505041033e-08 0 9.109035202781333e-08 0 9.110035202781333e-08 0.00021 9.111035202781333e-08 0 9.155192044208463e-08 0 9.156192044208462e-08 0.00021 9.157192044208462e-08 0 9.249029577881977e-08 0 9.250029577881977e-08 0.00021 9.251029577881977e-08 0 9.333742145155973e-08 0 9.334742145155972e-08 0.00021 9.335742145155972e-08 0 9.376958862299416e-08 0 9.377958862299416e-08 0.00021 9.378958862299416e-08 0 9.395466164994331e-08 0 9.39646616499433e-08 0.00021 9.39746616499433e-08 0 9.428950257411223e-08 0 9.429950257411223e-08 0.00021 9.430950257411223e-08 0 9.546319218809742e-08 0 9.547319218809742e-08 0.00021 9.548319218809742e-08 0 9.626622189436518e-08 0 9.627622189436518e-08 0.00021 9.628622189436518e-08 0 9.636044621510074e-08 0 9.637044621510073e-08 0.00021 9.638044621510073e-08 0 9.66277843686558e-08 0 9.66377843686558e-08 0.00021 9.66477843686558e-08 0 9.858529088520607e-08 0 9.859529088520607e-08 0.00021 9.860529088520607e-08 0 9.886141595323955e-08 0 9.887141595323955e-08 0.00021 9.888141595323954e-08 0 9.946064484800418e-08 0 9.947064484800417e-08 0.00021 9.948064484800417e-08 0 9.978271385869289e-08 0 9.979271385869289e-08 0.00021 9.980271385869289e-08 0 1.0007122289588045e-07 0 1.0008122289588044e-07 0.00021 1.0009122289588044e-07 0 1.0030182273890081e-07 0 1.0031182273890081e-07 0.00021 1.0032182273890081e-07 0 1.005981292684046e-07 0 1.006081292684046e-07 0.00021 1.006181292684046e-07 0 1.0170983060938488e-07 0 1.0171983060938488e-07 0.00021 1.0172983060938487e-07 0 1.0224839866986652e-07 0 1.0225839866986652e-07 0.00021 1.0226839866986652e-07 0 1.0226839866986652e-07 0 1.0227839866986652e-07 0.00021 1.0228839866986651e-07 0 1.028081913404571e-07 0 1.028181913404571e-07 0.00021 1.028281913404571e-07 0 1.033701638336264e-07 0 1.033801638336264e-07 0.00021 1.033901638336264e-07 0 1.0380175075517884e-07 0 1.0381175075517884e-07 0.00021 1.0382175075517884e-07 0 1.0440373365403442e-07 0 1.0441373365403442e-07 0.00021 1.0442373365403442e-07 0 1.0474804546973837e-07 0 1.0475804546973837e-07 0.00021 1.0476804546973837e-07 0 1.0535483401169408e-07 0 1.0536483401169408e-07 0.00021 1.0537483401169408e-07 0 1.0556609634404662e-07 0 1.0557609634404662e-07 0.00021 1.0558609634404662e-07 0 1.0575057366353901e-07 0 1.0576057366353901e-07 0.00021 1.0577057366353901e-07 0 1.0647498089099918e-07 0 1.0648498089099918e-07 0.00021 1.0649498089099918e-07 0 1.0728785156487317e-07 0 1.0729785156487317e-07 0.00021 1.0730785156487317e-07 0 1.0739182276874909e-07 0 1.0740182276874909e-07 0.00021 1.0741182276874909e-07 0 1.0793720724216131e-07 0 1.0794720724216131e-07 0.00021 1.0795720724216131e-07 0 1.0839203566140057e-07 0 1.0840203566140057e-07 0.00021 1.0841203566140057e-07 0 1.0873015077077692e-07 0 1.0874015077077692e-07 0.00021 1.0875015077077692e-07 0 1.0930356690645233e-07 0 1.0931356690645233e-07 0.00021 1.0932356690645233e-07 0 1.0949914811183613e-07 0 1.0950914811183613e-07 0.00021 1.0951914811183613e-07 0 1.099544184794601e-07 0 1.099644184794601e-07 0.00021 1.099744184794601e-07 0 1.1009288217209859e-07 0 1.1010288217209859e-07 0.00021 1.1011288217209859e-07 0 1.1012419763825666e-07 0 1.1013419763825666e-07 0.00021 1.1014419763825666e-07 0 1.1064430525094834e-07 0 1.1065430525094833e-07 0.00021 1.1066430525094833e-07 0 1.1079512838788347e-07 0 1.1080512838788347e-07 0.00021 1.1081512838788347e-07 0 1.1131463276976418e-07 0 1.1132463276976418e-07 0.00021 1.1133463276976418e-07 0 1.1296173878628941e-07 0 1.1297173878628941e-07 0.00021 1.1298173878628941e-07 0 1.1380584821398023e-07 0 1.1381584821398023e-07 0.00021 1.1382584821398022e-07 0 1.1388507599492662e-07 0 1.1389507599492662e-07 0.00021 1.1390507599492661e-07 0 1.1393279337736212e-07 0 1.1394279337736212e-07 0.00021 1.1395279337736212e-07 0 1.140130115577194e-07 0 1.140230115577194e-07 0.00021 1.140330115577194e-07 0 1.1488735292903829e-07 0 1.1489735292903829e-07 0.00021 1.1490735292903829e-07 0 1.155638830250576e-07 0 1.155738830250576e-07 0.00021 1.155838830250576e-07 0 1.1593860220002026e-07 0 1.1594860220002025e-07 0.00021 1.1595860220002025e-07 0 1.1600728061172154e-07 0 1.1601728061172154e-07 0.00021 1.1602728061172154e-07 0 1.1614619170716297e-07 0 1.1615619170716297e-07 0.00021 1.1616619170716297e-07 0 1.162459939560518e-07 0 1.162559939560518e-07 0.00021 1.162659939560518e-07 0 1.164109413414706e-07 0 1.164209413414706e-07 0.00021 1.164309413414706e-07 0 1.1665392467440783e-07 0 1.1666392467440783e-07 0.00021 1.1667392467440782e-07 0 1.1705171748951757e-07 0 1.1706171748951757e-07 0.00021 1.1707171748951757e-07 0 1.1734212626548338e-07 0 1.1735212626548338e-07 0.00021 1.1736212626548338e-07 0 1.1752924866347745e-07 0 1.1753924866347744e-07 0.00021 1.1754924866347744e-07 0 1.1791407914780578e-07 0 1.1792407914780578e-07 0.00021 1.1793407914780578e-07 0 1.1816265567983863e-07 0 1.1817265567983862e-07 0.00021 1.1818265567983862e-07 0 1.186523527761326e-07 0 1.186623527761326e-07 0.00021 1.186723527761326e-07 0 1.1892300425338024e-07 0 1.1893300425338024e-07 0.00021 1.1894300425338024e-07 0 1.2002577029077207e-07 0 1.2003577029077208e-07 0.00021 1.200457702907721e-07 0 1.2010636620797802e-07 0 1.2011636620797803e-07 0.00021 1.2012636620797804e-07 0 1.2085556420942152e-07 0 1.2086556420942154e-07 0.00021 1.2087556420942155e-07 0 1.2311689681469082e-07 0 1.2312689681469083e-07 0.00021 1.2313689681469084e-07 0 1.2349987148653892e-07 0 1.2350987148653894e-07 0.00021 1.2351987148653895e-07 0 1.2450137908876334e-07 0 1.2451137908876336e-07 0.00021 1.2452137908876337e-07 0 1.2539216219725062e-07 0 1.2540216219725063e-07 0.00021 1.2541216219725064e-07 0 1.267551631679675e-07 0 1.267651631679675e-07 0.00021 1.267751631679675e-07 0 1.2766795158768534e-07 0 1.2767795158768535e-07 0.00021 1.2768795158768536e-07 0 1.2768843516686283e-07 0 1.2769843516686284e-07 0.00021 1.2770843516686285e-07 0 1.285165487403923e-07 0 1.2852654874039232e-07 0.00021 1.2853654874039233e-07 0 1.2890077479587411e-07 0 1.2891077479587413e-07 0.00021 1.2892077479587414e-07 0 1.2923562473466912e-07 0 1.2924562473466913e-07 0.00021 1.2925562473466915e-07 0 1.3022146747806154e-07 0 1.3023146747806155e-07 0.00021 1.3024146747806157e-07 0 1.31215977639598e-07 0 1.31225977639598e-07 0.00021 1.3123597763959801e-07 0 1.3134425724840575e-07 0 1.3135425724840576e-07 0.00021 1.3136425724840577e-07 0 1.3159727214108558e-07 0 1.316072721410856e-07 0.00021 1.316172721410856e-07 0 1.3292033885394144e-07 0 1.3293033885394145e-07 0.00021 1.3294033885394146e-07 0 1.33387800910085e-07 0 1.33397800910085e-07 0.00021 1.33407800910085e-07 0 1.3349599062693653e-07 0 1.3350599062693654e-07 0.00021 1.3351599062693655e-07 0 1.368216536126893e-07 0 1.3683165361268932e-07 0.00021 1.3684165361268933e-07 0 1.368948442817753e-07 0 1.3690484428177531e-07 0.00021 1.3691484428177533e-07 0 1.371143877574536e-07 0 1.371243877574536e-07 0.00021 1.3713438775745362e-07 0 1.3728753279874582e-07 0 1.3729753279874583e-07 0.00021 1.3730753279874585e-07 0 1.3765940175145259e-07 0 1.376694017514526e-07 0.00021 1.376794017514526e-07 0 1.3787714478974438e-07 0 1.378871447897444e-07 0.00021 1.378971447897444e-07 0 1.381566580181769e-07 0 1.381666580181769e-07 0.00021 1.3817665801817691e-07 0 1.381766580181769e-07 0 1.381866580181769e-07 0.00021 1.381966580181769e-07 0 1.3820595139252798e-07 0 1.38215951392528e-07 0.00021 1.38225951392528e-07 0 1.3973300189254813e-07 0 1.3974300189254814e-07 0.00021 1.3975300189254815e-07 0 1.3983307886085435e-07 0 1.3984307886085436e-07 0.00021 1.3985307886085437e-07 0 1.4069947994876555e-07 0 1.4070947994876556e-07 0.00021 1.4071947994876557e-07 0 1.4240781199310848e-07 0 1.424178119931085e-07 0.00021 1.424278119931085e-07 0 1.4301315957627845e-07 0 1.4302315957627846e-07 0.00021 1.4303315957627847e-07 0 1.4422715802968965e-07 0 1.4423715802968966e-07 0.00021 1.4424715802968967e-07 0 1.4473729721577725e-07 0 1.4474729721577726e-07 0.00021 1.4475729721577727e-07 0 1.4543748048754303e-07 0 1.4544748048754305e-07 0.00021 1.4545748048754306e-07 0 1.4649993017803826e-07 0 1.4650993017803827e-07 0.00021 1.4651993017803828e-07 0 1.4740280836944015e-07 0 1.4741280836944016e-07 0.00021 1.4742280836944017e-07 0 1.4805339442411398e-07 0 1.48063394424114e-07 0.00021 1.48073394424114e-07 0 1.4876433081752378e-07 0 1.487743308175238e-07 0.00021 1.487843308175238e-07 0 1.4931154701482345e-07 0 1.4932154701482346e-07 0.00021 1.4933154701482347e-07 0 1.505878970027284e-07 0 1.505978970027284e-07 0.00021 1.5060789700272842e-07 0 1.509185772670578e-07 0 1.509285772670578e-07 0.00021 1.5093857726705782e-07 0 1.5101404907157703e-07 0 1.5102404907157705e-07 0.00021 1.5103404907157706e-07 0 1.5155838281931077e-07 0 1.5156838281931078e-07 0.00021 1.515783828193108e-07 0 1.5260630510907493e-07 0 1.5261630510907494e-07 0.00021 1.5262630510907495e-07 0 1.526646643528212e-07 0 1.526746643528212e-07 0.00021 1.5268466435282122e-07 0 1.5298796499982567e-07 0 1.5299796499982568e-07 0.00021 1.530079649998257e-07 0 1.5315903021943866e-07 0 1.5316903021943867e-07 0.00021 1.5317903021943868e-07 0 1.5348084858907992e-07 0 1.5349084858907993e-07 0.00021 1.5350084858907994e-07 0 1.536384490242235e-07 0 1.5364844902422352e-07 0.00021 1.5365844902422353e-07 0 1.5429420737506878e-07 0 1.543042073750688e-07 0.00021 1.543142073750688e-07 0 1.5497311414512354e-07 0 1.5498311414512355e-07 0.00021 1.5499311414512356e-07 0 1.5505874369561872e-07 0 1.5506874369561873e-07 0.00021 1.5507874369561874e-07 0 1.5587695524977303e-07 0 1.5588695524977304e-07 0.00021 1.5589695524977305e-07 0 1.5649865931071388e-07 0 1.565086593107139e-07 0.00021 1.565186593107139e-07 0 1.5744539725973066e-07 0 1.5745539725973068e-07 0.00021 1.574653972597307e-07 0 1.5898165016979505e-07 0 1.5899165016979506e-07 0.00021 1.5900165016979507e-07 0 1.5914832717695758e-07 0 1.591583271769576e-07 0.00021 1.591683271769576e-07 0 1.591817969316468e-07 0 1.5919179693164682e-07 0.00021 1.5920179693164683e-07 0 1.5946582799447535e-07 0 1.5947582799447536e-07 0.00021 1.5948582799447537e-07 0 1.6029912493750006e-07 0 1.6030912493750007e-07 0.00021 1.6031912493750008e-07 0 1.6077360261041392e-07 0 1.6078360261041393e-07 0.00021 1.6079360261041394e-07 0 1.616564779914918e-07 0 1.6166647799149182e-07 0.00021 1.6167647799149183e-07 0 1.617554953512982e-07 0 1.6176549535129822e-07 0.00021 1.6177549535129823e-07 0 1.6565729741849521e-07 0 1.6566729741849523e-07 0.00021 1.6567729741849524e-07 0 1.656811469429661e-07 0 1.6569114694296612e-07 0.00021 1.6570114694296613e-07 0 1.6605301353223305e-07 0 1.6606301353223306e-07 0.00021 1.6607301353223307e-07 0 1.6654963974328394e-07 0 1.6655963974328395e-07 0.00021 1.6656963974328396e-07 0 1.6682278190733776e-07 0 1.6683278190733777e-07 0.00021 1.6684278190733778e-07 0 1.6743689512961717e-07 0 1.6744689512961718e-07 0.00021 1.674568951296172e-07 0 1.6765271063539653e-07 0 1.6766271063539654e-07 0.00021 1.6767271063539655e-07 0 1.678516649548352e-07 0 1.6786166495483522e-07 0.00021 1.6787166495483524e-07 0 1.6860782169979565e-07 0 1.6861782169979567e-07 0.00021 1.6862782169979568e-07 0 1.69297277687303e-07 0 1.6930727768730302e-07 0.00021 1.6931727768730303e-07 0 1.6954054966891484e-07 0 1.6955054966891485e-07 0.00021 1.6956054966891486e-07 0 1.6962250457354592e-07 0 1.6963250457354594e-07 0.00021 1.6964250457354595e-07 0 1.7005913062107825e-07 0 1.7006913062107826e-07 0.00021 1.7007913062107827e-07 0 1.7042769022078248e-07 0 1.704376902207825e-07 0.00021 1.704476902207825e-07 0 1.7069164166461373e-07 0 1.7070164166461374e-07 0.00021 1.7071164166461376e-07 0 1.710131631626927e-07 0 1.710231631626927e-07 0.00021 1.7103316316269272e-07 0 1.7111890217299997e-07 0 1.7112890217299998e-07 0.00021 1.71138902173e-07 0 1.7135840224800947e-07 0 1.7136840224800948e-07 0.00021 1.713784022480095e-07 0 1.7234871055433532e-07 0 1.7235871055433533e-07 0.00021 1.7236871055433535e-07 0 1.7236871055433532e-07 0 1.7237871055433533e-07 0.00021 1.7238871055433534e-07 0 1.724103036649497e-07 0 1.724203036649497e-07 0.00021 1.7243030366494972e-07 0 1.7250048510331843e-07 0 1.7251048510331845e-07 0.00021 1.7252048510331846e-07 0 1.7301243915036134e-07 0 1.7302243915036135e-07 0.00021 1.7303243915036136e-07 0 1.7346561802760376e-07 0 1.7347561802760377e-07 0.00021 1.7348561802760378e-07 0 1.7373115470547713e-07 0 1.7374115470547714e-07 0.00021 1.7375115470547715e-07 0 1.7382236557206345e-07 0 1.7383236557206347e-07 0.00021 1.7384236557206348e-07 0 1.7384236557206345e-07 0 1.7385236557206346e-07 0.00021 1.7386236557206347e-07 0 1.74407694342239e-07 0 1.74417694342239e-07 0.00021 1.74427694342239e-07 0 1.7461249762124192e-07 0 1.7462249762124193e-07 0.00021 1.7463249762124194e-07 0 1.7522142638276618e-07 0 1.752314263827662e-07 0.00021 1.752414263827662e-07 0 1.7640347424436836e-07 0 1.7641347424436838e-07 0.00021 1.7642347424436839e-07 0 1.7642347424436836e-07 0 1.7643347424436837e-07 0.00021 1.7644347424436838e-07 0 1.7659946639067862e-07 0 1.7660946639067863e-07 0.00021 1.7661946639067865e-07 0 1.7790497981291423e-07 0 1.7791497981291424e-07 0.00021 1.7792497981291425e-07 0 1.779781316643126e-07 0 1.779881316643126e-07 0.00021 1.7799813166431262e-07 0 1.7887318666748968e-07 0 1.788831866674897e-07 0.00021 1.788931866674897e-07 0 1.800848210208607e-07 0 1.800948210208607e-07 0.00021 1.8010482102086072e-07 0 1.8018589474057897e-07 0 1.8019589474057898e-07 0.00021 1.80205894740579e-07 0 1.8165319392807463e-07 0 1.8166319392807464e-07 0.00021 1.8167319392807465e-07 0 1.8185212940241447e-07 0 1.8186212940241448e-07 0.00021 1.818721294024145e-07 0 1.8199054028577672e-07 0 1.8200054028577673e-07 0.00021 1.8201054028577674e-07 0 1.8201114233667295e-07 0 1.8202114233667296e-07 0.00021 1.8203114233667297e-07 0 1.8243740985279908e-07 0 1.824474098527991e-07 0.00021 1.824574098527991e-07 0 1.8299298926909958e-07 0 1.830029892690996e-07 0.00021 1.830129892690996e-07 0 1.838661702563269e-07 0 1.8387617025632692e-07 0.00021 1.8388617025632693e-07 0 1.8425452475706595e-07 0 1.8426452475706596e-07 0.00021 1.8427452475706597e-07 0 1.8477434174480637e-07 0 1.8478434174480638e-07 0.00021 1.847943417448064e-07 0 1.854171979887959e-07 0 1.854271979887959e-07 0.00021 1.8543719798879592e-07 0 1.8585991754823534e-07 0 1.8586991754823535e-07 0.00021 1.8587991754823536e-07 0 1.859417158167346e-07 0 1.859517158167346e-07 0.00021 1.859617158167346e-07 0 1.8596330184896335e-07 0 1.8597330184896336e-07 0.00021 1.8598330184896337e-07 0 1.8598330184896335e-07 0 1.8599330184896336e-07 0.00021 1.8600330184896337e-07 0 1.8679366901602866e-07 0 1.8680366901602867e-07 0.00021 1.8681366901602868e-07 0 1.868355805852018e-07 0 1.8684558058520182e-07 0.00021 1.8685558058520183e-07 0 1.8754380481386576e-07 0 1.8755380481386577e-07 0.00021 1.8756380481386579e-07 0 1.8757137493514993e-07 0 1.8758137493514994e-07 0.00021 1.8759137493514995e-07 0 1.876552720486825e-07 0 1.8766527204868252e-07 0.00021 1.8767527204868253e-07 0 1.879623047117898e-07 0 1.8797230471178982e-07 0.00021 1.8798230471178983e-07 0 1.8838888761561306e-07 0 1.8839888761561307e-07 0.00021 1.8840888761561308e-07 0 1.888786228832008e-07 0 1.888886228832008e-07 0.00021 1.888986228832008e-07 0 1.891853290679785e-07 0 1.8919532906797852e-07 0.00021 1.8920532906797853e-07 0 1.9048630332952937e-07 0 1.9049630332952938e-07 0.00021 1.905063033295294e-07 0 1.9064641703176763e-07 0 1.9065641703176764e-07 0.00021 1.9066641703176765e-07 0 1.9112452127569143e-07 0 1.9113452127569144e-07 0.00021 1.9114452127569145e-07 0 1.9125786915897912e-07 0 1.9126786915897913e-07 0.00021 1.9127786915897914e-07 0 1.9153466649205304e-07 0 1.9154466649205305e-07 0.00021 1.9155466649205306e-07 0 1.9155466649205304e-07 0 1.9156466649205305e-07 0.00021 1.9157466649205306e-07 0 1.9159576848351584e-07 0 1.9160576848351585e-07 0.00021 1.9161576848351586e-07 0 1.9273249739822255e-07 0 1.9274249739822256e-07 0.00021 1.9275249739822257e-07 0 1.9285423588852662e-07 0 1.9286423588852663e-07 0.00021 1.9287423588852665e-07 0 1.9403855363594726e-07 0 1.9404855363594727e-07 0.00021 1.9405855363594728e-07 0 1.9474845267101586e-07 0 1.9475845267101588e-07 0.00021 1.947684526710159e-07 0 1.9496509395592744e-07 0 1.9497509395592745e-07 0.00021 1.9498509395592747e-07 0 1.952162853771148e-07 0 1.9522628537711482e-07 0.00021 1.9523628537711483e-07 0 1.9582387561703075e-07 0 1.9583387561703076e-07 0.00021 1.9584387561703077e-07 0 1.961307471961654e-07 0 1.961407471961654e-07 0.00021 1.9615074719616542e-07 0 1.970437090560278e-07 0 1.970537090560278e-07 0.00021 1.9706370905602782e-07 0 1.982389027046124e-07 0 1.982489027046124e-07 0.00021 1.9825890270461242e-07 0 1.9849312584733262e-07 0 1.9850312584733263e-07 0.00021 1.9851312584733264e-07 0 1.988385043323976e-07 0 1.988485043323976e-07 0.00021 1.9885850433239761e-07 0 1.997912742389584e-07 0 1.9980127423895842e-07 0.00021 1.9981127423895843e-07 0 2.0016382006355429e-07 0 2.001738200635543e-07 0.00021 2.001838200635543e-07 0 2.0065320772809684e-07 0 2.0066320772809685e-07 0.00021 2.0067320772809687e-07 0 2.0076598925926733e-07 0 2.0077598925926735e-07 0.00021 2.0078598925926736e-07 0 2.014378252774438e-07 0 2.014478252774438e-07 0.00021 2.0145782527744382e-07 0 2.0275968200924418e-07 0 2.027696820092442e-07 0.00021 2.027796820092442e-07 0 2.0281744922130093e-07 0 2.0282744922130094e-07 0.00021 2.0283744922130096e-07 0 2.0463092636018562e-07 0 2.0464092636018563e-07 0.00021 2.0465092636018564e-07 0 2.0467511289634163e-07 0 2.0468511289634164e-07 0.00021 2.0469511289634165e-07 0 2.0469511289634162e-07 0 2.0470511289634164e-07 0.00021 2.0471511289634165e-07 0 2.0523028187405553e-07 0 2.0524028187405554e-07 0.00021 2.0525028187405555e-07 0 2.071459265170559e-07 0 2.071559265170559e-07 0.00021 2.0716592651705592e-07 0 2.0753321063412548e-07 0 2.075432106341255e-07 0.00021 2.075532106341255e-07 0 2.0785109126348668e-07 0 2.078610912634867e-07 0.00021 2.078710912634867e-07 0 2.0789756835003914e-07 0 2.0790756835003915e-07 0.00021 2.0791756835003916e-07 0 2.0830004270474338e-07 0 2.083100427047434e-07 0.00021 2.083200427047434e-07 0 2.0951421137198776e-07 0 2.0952421137198777e-07 0.00021 2.0953421137198778e-07 0 2.0988513794792584e-07 0 2.0989513794792586e-07 0.00021 2.0990513794792587e-07 0 2.0999176223426989e-07 0 2.100017622342699e-07 0.00021 2.100117622342699e-07 0 2.1194694985326924e-07 0 2.1195694985326925e-07 0.00021 2.1196694985326926e-07 0 2.127132707554252e-07 0 2.1272327075542521e-07 0.00021 2.1273327075542523e-07 0 2.136212803573715e-07 0 2.136312803573715e-07 0.00021 2.1364128035737152e-07 0 2.1491089748621907e-07 0 2.1492089748621909e-07 0.00021 2.149308974862191e-07 0 2.1576681360249468e-07 0 2.157768136024947e-07 0.00021 2.157868136024947e-07 0 2.162706927260587e-07 0 2.1628069272605872e-07 0.00021 2.1629069272605873e-07 0 2.166364658597898e-07 0 2.166464658597898e-07 0.00021 2.1665646585978982e-07 0 2.167385782887995e-07 0 2.1674857828879952e-07 0.00021 2.1675857828879953e-07 0 2.1961130554946875e-07 0 2.1962130554946876e-07 0.00021 2.1963130554946878e-07 0 2.1968972692699568e-07 0 2.196997269269957e-07 0.00021 2.197097269269957e-07 0 2.2028342159936068e-07 0 2.202934215993607e-07 0.00021 2.203034215993607e-07 0 2.2042723987390598e-07 0 2.20437239873906e-07 0.00021 2.20447239873906e-07 0 2.2083793941058874e-07 0 2.2084793941058875e-07 0.00021 2.2085793941058876e-07 0 2.2139436040884506e-07 0 2.2140436040884507e-07 0.00021 2.2141436040884508e-07 0 2.2152153566114182e-07 0 2.2153153566114183e-07 0.00021 2.2154153566114185e-07 0 2.2208538993220672e-07 0 2.2209538993220673e-07 0.00021 2.2210538993220674e-07 0 2.2254368615755798e-07 0 2.22553686157558e-07 0.00021 2.22563686157558e-07 0 2.230938198565468e-07 0 2.231038198565468e-07 0.00021 2.2311381985654682e-07 0 2.2349248477796377e-07 0 2.2350248477796378e-07 0.00021 2.235124847779638e-07 0 2.240859718170173e-07 0 2.240959718170173e-07 0.00021 2.241059718170173e-07 0 2.242783351080309e-07 0 2.242883351080309e-07 0.00021 2.242983351080309e-07 0 2.256469310802569e-07 0 2.256569310802569e-07 0.00021 2.2566693108025692e-07 0 2.2597774258617311e-07 0 2.2598774258617313e-07 0.00021 2.2599774258617314e-07 0 2.2615760318494514e-07 0 2.2616760318494515e-07 0.00021 2.2617760318494516e-07 0 2.2627501623584337e-07 0 2.2628501623584338e-07 0.00021 2.262950162358434e-07 0 2.2654169724848382e-07 0 2.2655169724848383e-07 0.00021 2.2656169724848384e-07 0 2.2673649455032516e-07 0 2.2674649455032517e-07 0.00021 2.2675649455032518e-07 0 2.2696115454234682e-07 0 2.2697115454234684e-07 0.00021 2.2698115454234685e-07 0 2.2780031676326004e-07 0 2.2781031676326005e-07 0.00021 2.2782031676326006e-07 0 2.2877447252468273e-07 0 2.2878447252468274e-07 0.00021 2.2879447252468275e-07 0 2.2931689628934318e-07 0 2.293268962893432e-07 0.00021 2.293368962893432e-07 0 2.2976521910811898e-07 0 2.29775219108119e-07 0.00021 2.29785219108119e-07 0 2.3011567546402244e-07 0 2.3012567546402245e-07 0.00021 2.3013567546402247e-07 0 2.308318633364625e-07 0 2.308418633364625e-07 0.00021 2.3085186333646252e-07 0 2.3091291665915266e-07 0 2.3092291665915267e-07 0.00021 2.3093291665915268e-07 0 2.311036432664849e-07 0 2.3111364326648492e-07 0.00021 2.3112364326648493e-07 0 2.3118350092355295e-07 0 2.3119350092355296e-07 0.00021 2.3120350092355297e-07 0 2.3162469002439026e-07 0 2.3163469002439027e-07 0.00021 2.3164469002439028e-07 0 2.3200699478209207e-07 0 2.3201699478209208e-07 0.00021 2.320269947820921e-07 0 2.322227240683107e-07 0 2.322327240683107e-07 0.00021 2.3224272406831072e-07 0 2.3254446187923656e-07 0 2.3255446187923657e-07 0.00021 2.3256446187923658e-07 0 2.3269566391631606e-07 0 2.3270566391631607e-07 0.00021 2.3271566391631609e-07 0 2.330049829820662e-07 0 2.330149829820662e-07 0.00021 2.3302498298206622e-07 0 2.3304848756188198e-07 0 2.33058487561882e-07 0.00021 2.33068487561882e-07 0 2.3308355287780503e-07 0 2.3309355287780504e-07 0.00021 2.3310355287780506e-07 0 2.3402612085812912e-07 0 2.3403612085812914e-07 0.00021 2.3404612085812915e-07 0 2.3486944585195417e-07 0 2.3487944585195418e-07 0.00021 2.348894458519542e-07 0 2.3491051325927473e-07 0 2.3492051325927474e-07 0.00021 2.3493051325927475e-07 0 2.350151392571971e-07 0 2.350251392571971e-07 0.00021 2.3503513925719712e-07 0 2.3543821960103443e-07 0 2.3544821960103444e-07 0.00021 2.3545821960103445e-07 0 2.3628610681200738e-07 0 2.362961068120074e-07 0.00021 2.363061068120074e-07 0 2.3741409408053913e-07 0 2.3742409408053914e-07 0.00021 2.3743409408053915e-07 0 2.375521019562806e-07 0 2.375621019562806e-07 0.00021 2.375721019562806e-07 0 2.37653683109549e-07 0 2.37663683109549e-07 0.00021 2.3767368310954902e-07 0 2.3824851237457394e-07 0 2.3825851237457395e-07 0.00021 2.3826851237457396e-07 0 2.389789563796279e-07 0 2.389889563796279e-07 0.00021 2.389989563796279e-07 0 2.3913777671622924e-07 0 2.3914777671622925e-07 0.00021 2.3915777671622926e-07 0 2.3917164854214104e-07 0 2.3918164854214105e-07 0.00021 2.3919164854214106e-07 0 2.3986613426044976e-07 0 2.3987613426044977e-07 0.00021 2.398861342604498e-07 0 2.3997833101302106e-07 0 2.3998833101302107e-07 0.00021 2.399983310130211e-07 0 2.4004234490670817e-07 0 2.400523449067082e-07 0.00021 2.400623449067082e-07 0 2.407606572839784e-07 0 2.407706572839784e-07 0.00021 2.407806572839784e-07 0 2.4244275635248544e-07 0 2.4245275635248545e-07 0.00021 2.4246275635248546e-07 0 2.431485179303226e-07 0 2.4315851793032263e-07 0.00021 2.4316851793032264e-07 0 2.432391766319889e-07 0 2.432491766319889e-07 0.00021 2.432591766319889e-07 0 2.433440115800382e-07 0 2.433540115800382e-07 0.00021 2.4336401158003823e-07 0 2.4454665868687924e-07 0 2.4455665868687925e-07 0.00021 2.4456665868687927e-07 0 2.4494609902503106e-07 0 2.4495609902503107e-07 0.00021 2.449660990250311e-07 0 2.45497003591244e-07 0 2.45507003591244e-07 0.00021 2.45517003591244e-07 0 2.460417552340137e-07 0 2.4605175523401373e-07 0.00021 2.4606175523401374e-07 0 2.46621079774238e-07 0 2.46631079774238e-07 0.00021 2.46641079774238e-07 0 2.4681029283484343e-07 0 2.4682029283484344e-07 0.00021 2.4683029283484345e-07 0 2.47169418205832e-07 0 2.47179418205832e-07 0.00021 2.47189418205832e-07 0 2.4765752859487544e-07 0 2.4766752859487545e-07 0.00021 2.4767752859487546e-07 0 2.4794200286144176e-07 0 2.479520028614418e-07 0.00021 2.479620028614418e-07 0 2.486121225358739e-07 0 2.486221225358739e-07 0.00021 2.486321225358739e-07 0 2.4933175029621686e-07 0 2.493417502962169e-07 0.00021 2.493517502962169e-07 0 2.497461452057535e-07 0 2.497561452057535e-07 0.00021 2.497661452057535e-07 0 2.502349666771774e-07 0 2.502449666771774e-07 0.00021 2.502549666771774e-07 0 2.5037704999399426e-07 0 2.5038704999399427e-07 0.00021 2.503970499939943e-07 0 2.507601409992945e-07 0 2.507701409992945e-07 0.00021 2.5078014099929454e-07 0 2.508284439820982e-07 0 2.5083844398209823e-07 0.00021 2.5084844398209824e-07 0 2.5102749573682344e-07 0 2.5103749573682345e-07 0.00021 2.5104749573682346e-07 0 2.521188547970837e-07 0 2.521288547970837e-07 0.00021 2.5213885479708374e-07 0 2.5307307387170475e-07 0 2.5308307387170476e-07 0.00021 2.5309307387170477e-07 0 2.5392761828112355e-07 0 2.5393761828112356e-07 0.00021 2.539476182811236e-07 0 2.5397476012445815e-07 0 2.5398476012445816e-07 0.00021 2.5399476012445817e-07 0 2.552017011428431e-07 0 2.552117011428431e-07 0.00021 2.552217011428431e-07 0 2.5554802455628917e-07 0 2.555580245562892e-07 0.00021 2.555680245562892e-07 0 2.5578257337253726e-07 0 2.5579257337253727e-07 0.00021 2.558025733725373e-07 0 2.558025733725373e-07 0 2.558125733725373e-07 0.00021 2.558225733725373e-07 0 2.5666807002777063e-07 0 2.5667807002777064e-07 0.00021 2.5668807002777065e-07 0 2.5677782166615275e-07 0 2.5678782166615276e-07 0.00021 2.567978216661528e-07 0 2.572008767931298e-07 0 2.572108767931298e-07 0.00021 2.572208767931298e-07 0 2.575022287634656e-07 0 2.575122287634656e-07 0.00021 2.575222287634656e-07 0 2.5880430256134234e-07 0 2.5881430256134235e-07 0.00021 2.5882430256134237e-07 0 2.592358880527381e-07 0 2.5924588805273813e-07 0.00021 2.5925588805273814e-07 0 2.597543018127635e-07 0 2.597643018127635e-07 0.00021 2.597743018127635e-07 0 2.599475195970116e-07 0 2.599575195970116e-07 0.00021 2.599675195970116e-07 0 2.601029523464873e-07 0 2.6011295234648733e-07 0.00021 2.6012295234648734e-07 0 2.6066790322469675e-07 0 2.6067790322469676e-07 0.00021 2.606879032246968e-07 0 2.613303951374363e-07 0 2.613403951374363e-07 0.00021 2.6135039513743633e-07 0 2.615921983501705e-07 0 2.616021983501705e-07 0.00021 2.616121983501705e-07 0 2.6273522244070517e-07 0 2.627452224407052e-07 0.00021 2.627552224407052e-07 0 2.630765330109981e-07 0 2.630865330109981e-07 0.00021 2.6309653301099813e-07 0 2.6309653301099813e-07 0 2.6310653301099814e-07 0.00021 2.6311653301099815e-07 0 2.635601092812891e-07 0 2.635701092812891e-07 0.00021 2.635801092812891e-07 0 2.637529355247014e-07 0 2.637629355247014e-07 0.00021 2.6377293552470143e-07 0 2.6386002100986836e-07 0 2.638700210098684e-07 0.00021 2.638800210098684e-07 0 2.638800210098684e-07 0 2.638900210098684e-07 0.00021 2.639000210098684e-07 0 2.6401271470967553e-07 0 2.6402271470967555e-07 0.00021 2.6403271470967556e-07 0 2.6485655363462635e-07 0 2.6486655363462636e-07 0.00021 2.648765536346264e-07 0 2.651775534860328e-07 0 2.651875534860328e-07 0.00021 2.6519755348603284e-07 0 2.6530017819518835e-07 0 2.6531017819518836e-07 0.00021 2.6532017819518837e-07 0 2.6650267715214044e-07 0 2.6651267715214045e-07 0.00021 2.6652267715214046e-07 0 2.667860770928479e-07 0 2.6679607709284793e-07 0.00021 2.6680607709284794e-07 0 2.671520128436498e-07 0 2.671620128436498e-07 0.00021 2.671720128436498e-07 0 2.6734339516913346e-07 0 2.673533951691335e-07 0.00021 2.673633951691335e-07 0 2.674808036133404e-07 0 2.674908036133404e-07 0.00021 2.675008036133404e-07 0 2.676998250762861e-07 0 2.677098250762861e-07 0.00021 2.6771982507628613e-07 0 2.680087647367892e-07 0 2.6801876473678923e-07 0.00021 2.6802876473678924e-07 0 2.686491739266089e-07 0 2.6865917392660893e-07 0.00021 2.6866917392660894e-07 0 2.687498885789243e-07 0 2.687598885789243e-07 0.00021 2.687698885789243e-07 0 2.6970262666736014e-07 0 2.6971262666736015e-07 0.00021 2.6972262666736017e-07 0 2.6989864447688586e-07 0 2.6990864447688587e-07 0.00021 2.699186444768859e-07 0 2.699186444768859e-07 0 2.699286444768859e-07 0.00021 2.699386444768859e-07 0 2.7024667378613316e-07 0 2.7025667378613317e-07 0.00021 2.702666737861332e-07 0 2.7058716253813387e-07 0 2.705971625381339e-07 0.00021 2.706071625381339e-07 0 2.706726495989503e-07 0 2.706826495989503e-07 0.00021 2.706926495989503e-07 0 2.7098360579670956e-07 0 2.709936057967096e-07 0.00021 2.710036057967096e-07 0 2.714110067909204e-07 0 2.7142100679092043e-07 0.00021 2.7143100679092044e-07 0 2.7191993060881883e-07 0 2.7192993060881884e-07 0.00021 2.7193993060881885e-07 0 2.7359314625939874e-07 0 2.7360314625939875e-07 0.00021 2.7361314625939876e-07 0 2.737927526722529e-07 0 2.738027526722529e-07 0.00021 2.738127526722529e-07 0 2.7386231269808714e-07 0 2.7387231269808715e-07 0.00021 2.7388231269808716e-07 0 2.739973448473657e-07 0 2.7400734484736573e-07 0.00021 2.7401734484736574e-07 0 2.740921132402572e-07 0 2.7410211324025723e-07 0.00021 2.7411211324025724e-07 0 2.7540509326874433e-07 0 2.7541509326874434e-07 0.00021 2.7542509326874435e-07 0 2.7566569705979617e-07 0 2.756756970597962e-07 0.00021 2.756856970597962e-07 0 2.758132081584364e-07 0 2.7582320815843644e-07 0.00021 2.7583320815843645e-07 0 2.760627994204541e-07 0 2.7607279942045413e-07 0.00021 2.7608279942045414e-07 0 2.771355574593685e-07 0 2.771455574593685e-07 0.00021 2.771555574593685e-07 0 2.775709211602395e-07 0 2.775809211602395e-07 0.00021 2.775909211602395e-07 0 2.7822208367866286e-07 0 2.7823208367866287e-07 0.00021 2.782420836786629e-07 0 2.786441331694389e-07 0 2.786541331694389e-07 0.00021 2.7866413316943893e-07 0 2.787462418691699e-07 0 2.787562418691699e-07 0.00021 2.787662418691699e-07 0 2.788672616731282e-07 0 2.788772616731282e-07 0.00021 2.7888726167312824e-07 0 2.789679592665186e-07 0 2.7897795926651863e-07 0.00021 2.7898795926651865e-07 0 2.79106623478252e-07 0 2.79116623478252e-07 0.00021 2.79126623478252e-07 0 2.791855613572e-07 0 2.791955613572e-07 0.00021 2.792055613572e-07 0 2.793297216282913e-07 0 2.793397216282913e-07 0.00021 2.793497216282913e-07 0 2.799672309076422e-07 0 2.7997723090764224e-07 0.00021 2.7998723090764225e-07 0 2.7998723090764225e-07 0 2.7999723090764226e-07 0.00021 2.8000723090764227e-07 0 2.800852756079646e-07 0 2.800952756079646e-07 0.00021 2.801052756079646e-07 0 2.806544720175995e-07 0 2.806644720175995e-07 0.00021 2.806744720175995e-07 0 2.807891239139933e-07 0 2.807991239139933e-07 0.00021 2.808091239139933e-07 0 2.8122726510588665e-07 0 2.8123726510588666e-07 0.00021 2.812472651058867e-07 0 2.8141964106573644e-07 0 2.8142964106573645e-07 0.00021 2.8143964106573646e-07 0 2.815202972205637e-07 0 2.815302972205637e-07 0.00021 2.815402972205637e-07 0 2.8388853012140666e-07 0 2.8389853012140667e-07 0.00021 2.839085301214067e-07 0 2.8468442183747156e-07 0 2.8469442183747157e-07 0.00021 2.847044218374716e-07 0 2.85035117903283e-07 0 2.85045117903283e-07 0.00021 2.8505511790328304e-07 0 2.8595479528248514e-07 0 2.8596479528248515e-07 0.00021 2.8597479528248516e-07 0 2.871181153555135e-07 0 2.871281153555135e-07 0.00021 2.871381153555135e-07 0 2.881116801224457e-07 0 2.8812168012244573e-07 0.00021 2.8813168012244574e-07 0 2.8816081333184463e-07 0 2.8817081333184464e-07 0.00021 2.8818081333184465e-07 0 2.889302931466255e-07 0 2.8894029314662553e-07 0.00021 2.8895029314662554e-07 0 2.895610924513177e-07 0 2.895710924513177e-07 0.00021 2.895810924513177e-07 0 2.9114293982148036e-07 0 2.911529398214804e-07 0.00021 2.911629398214804e-07 0 2.912089848008682e-07 0 2.912189848008682e-07 0.00021 2.9122898480086824e-07 0 2.912542242973272e-07 0 2.912642242973272e-07 0.00021 2.912742242973272e-07 0 2.912742242973272e-07 0 2.912842242973272e-07 0.00021 2.9129422429732723e-07 0 2.9164726938012164e-07 0 2.9165726938012165e-07 0.00021 2.9166726938012166e-07 0 2.927460499286513e-07 0 2.927560499286513e-07 0.00021 2.927660499286513e-07 0 2.9317559169384484e-07 0 2.9318559169384486e-07 0.00021 2.9319559169384487e-07 0 2.934761969035085e-07 0 2.9348619690350853e-07 0.00021 2.9349619690350854e-07 0 2.93610162267255e-07 0 2.93620162267255e-07 0.00021 2.93630162267255e-07 0 2.9432189769846983e-07 0 2.9433189769846984e-07 0.00021 2.9434189769846985e-07 0 2.9519152399682035e-07 0 2.9520152399682036e-07 0.00021 2.952115239968204e-07 0 2.955986436281611e-07 0 2.956086436281611e-07 0.00021 2.956186436281611e-07 0 2.9649417688224234e-07 0 2.9650417688224236e-07 0.00021 2.9651417688224237e-07 0 2.968024874708703e-07 0 2.968124874708703e-07 0.00021 2.9682248747087033e-07 0 2.9696490111188826e-07 0 2.9697490111188827e-07 0.00021 2.969849011118883e-07 0 2.969849011118883e-07 0 2.969949011118883e-07 0.00021 2.970049011118883e-07 0 2.972038454658286e-07 0 2.972138454658286e-07 0.00021 2.972238454658286e-07 0 2.9771834341298554e-07 0 2.9772834341298556e-07 0.00021 2.9773834341298557e-07 0 2.9807863616741395e-07 0 2.9808863616741396e-07 0.00021 2.98098636167414e-07 0 2.99835038858131e-07 0 2.99845038858131e-07 0.00021 2.99855038858131e-07 0 3.0011738150565976e-07 0 3.001273815056598e-07 0.00021 3.001373815056598e-07 0 3.002508688235686e-07 0 3.002608688235686e-07 0.00021 3.002708688235686e-07 0 3.007253937933291e-07 0 3.007353937933291e-07 0.00021 3.007453937933291e-07 0 3.007453937933291e-07 0 3.007553937933291e-07 0.00021 3.0076539379332913e-07 0 3.009607364697237e-07 0 3.009707364697237e-07 0.00021 3.009807364697237e-07 0 3.011959410915696e-07 0 3.0120594109156964e-07 0.00021 3.0121594109156965e-07 0 3.013083506603504e-07 0 3.0131835066035043e-07 0.00021 3.0132835066035044e-07 0 3.013868065645428e-07 0 3.013968065645428e-07 0.00021 3.014068065645428e-07 0 3.0193349824234924e-07 0 3.0194349824234925e-07 0.00021 3.0195349824234927e-07 0 3.0216613180320345e-07 0 3.0217613180320346e-07 0.00021 3.0218613180320347e-07 0 3.0226743101548134e-07 0 3.0227743101548136e-07 0.00021 3.0228743101548137e-07 0 3.038777912793194e-07 0 3.038877912793194e-07 0.00021 3.0389779127931943e-07 0 3.0414318052214914e-07 0 3.0415318052214915e-07 0.00021 3.0416318052214916e-07 0 3.043072359217391e-07 0 3.043172359217391e-07 0.00021 3.0432723592173914e-07 0 3.050392422921188e-07 0 3.050492422921188e-07 0.00021 3.050592422921188e-07 0 3.0592353601407085e-07 0 3.0593353601407086e-07 0.00021 3.0594353601407087e-07 0 3.0657564087037034e-07 0 3.0658564087037035e-07 0.00021 3.0659564087037036e-07 0 3.0665635533272876e-07 0 3.066663553327288e-07 0.00021 3.066763553327288e-07 0 3.0705851994073303e-07 0 3.0706851994073304e-07 0.00021 3.0707851994073305e-07 0 3.0767802250877186e-07 0 3.0768802250877187e-07 0.00021 3.076980225087719e-07 0 3.0779062697598834e-07 0 3.0780062697598835e-07 0.00021 3.0781062697598836e-07 0 3.086593585960156e-07 0 3.086693585960156e-07 0.00021 3.086793585960156e-07 0 3.08882413142757e-07 0 3.08892413142757e-07 0.00021 3.08902413142757e-07 0 3.0931374898091053e-07 0 3.0932374898091054e-07 0.00021 3.0933374898091055e-07 0 3.0958615746146063e-07 0 3.0959615746146064e-07 0.00021 3.0960615746146065e-07 0 3.096735700473919e-07 0 3.096835700473919e-07 0.00021 3.096935700473919e-07 0 3.1000358842137633e-07 0 3.1001358842137634e-07 0.00021 3.1002358842137635e-07 0 3.100537593062238e-07 0 3.100637593062238e-07 0.00021 3.100737593062238e-07 0 3.1012367830798317e-07 0 3.101336783079832e-07 0.00021 3.101436783079832e-07 0 3.108759050308026e-07 0 3.108859050308026e-07 0.00021 3.108959050308026e-07 0 3.1237540738154865e-07 0 3.1238540738154866e-07 0.00021 3.1239540738154867e-07 0 3.132305867095333e-07 0 3.132405867095333e-07 0.00021 3.1325058670953333e-07 0 3.1367793442030543e-07 0 3.1368793442030545e-07 0.00021 3.1369793442030546e-07 0 3.1373501880210286e-07 0 3.1374501880210287e-07 0.00021 3.137550188021029e-07 0 3.1444285878735783e-07 0 3.1445285878735784e-07 0.00021 3.1446285878735785e-07 0 3.145403151805513e-07 0 3.145503151805513e-07 0.00021 3.1456031518055133e-07 0 3.147461534743714e-07 0 3.147561534743714e-07 0.00021 3.147661534743714e-07 0 3.153179346726312e-07 0 3.153279346726312e-07 0.00021 3.1533793467263123e-07 0 3.1589090278463054e-07 0 3.1590090278463055e-07 0.00021 3.1591090278463057e-07 0 3.164037667470018e-07 0 3.164137667470018e-07 0.00021 3.164237667470018e-07 0 3.1798721881644846e-07 0 3.179972188164485e-07 0.00021 3.180072188164485e-07 0 3.194551721862555e-07 0 3.194651721862555e-07 0.00021 3.194751721862555e-07 0 3.1961699117370093e-07 0 3.1962699117370094e-07 0.00021 3.1963699117370095e-07 0 3.206003215481816e-07 0 3.2061032154818163e-07 0.00021 3.2062032154818164e-07 0 3.209685299697857e-07 0 3.209785299697857e-07 0.00021 3.2098852996978573e-07 0 3.210415527546232e-07 0 3.210515527546232e-07 0.00021 3.210615527546232e-07 0 3.214203616854081e-07 0 3.2143036168540813e-07 0.00021 3.2144036168540814e-07 0 3.218164583054477e-07 0 3.2182645830544774e-07 0.00021 3.2183645830544775e-07 0 3.219857420535778e-07 0 3.219957420535778e-07 0.00021 3.220057420535778e-07 0 3.233558097416822e-07 0 3.233658097416822e-07 0.00021 3.2337580974168224e-07 0 3.241348332691199e-07 0 3.241448332691199e-07 0.00021 3.241548332691199e-07 0 3.2420705623027277e-07 0 3.242170562302728e-07 0.00021 3.242270562302728e-07 0 3.242270562302728e-07 0 3.242370562302728e-07 0.00021 3.242470562302728e-07 0 3.2454954571559627e-07 0 3.245595457155963e-07 0.00021 3.245695457155963e-07 0 3.2476313141275506e-07 0 3.2477313141275507e-07 0.00021 3.247831314127551e-07 0 3.2538218017995627e-07 0 3.253921801799563e-07 0.00021 3.254021801799563e-07 0 3.254578128187747e-07 0 3.2546781281877473e-07 0.00021 3.2547781281877474e-07 0 3.2776203755659763e-07 0 3.2777203755659764e-07 0.00021 3.2778203755659765e-07 0 3.2797393014948253e-07 0 3.2798393014948254e-07 0.00021 3.2799393014948255e-07 0 3.280533151381678e-07 0 3.280633151381678e-07 0.00021 3.280733151381678e-07 0 3.284586076602599e-07 0 3.284686076602599e-07 0.00021 3.284786076602599e-07 0 3.287504684040298e-07 0 3.2876046840402984e-07 0.00021 3.2877046840402985e-07 0 3.287939247169165e-07 0 3.2880392471691654e-07 0.00021 3.2881392471691655e-07 0 3.289993701534532e-07 0 3.290093701534532e-07 0.00021 3.290193701534532e-07 0 3.2915380019740947e-07 0 3.291638001974095e-07 0.00021 3.291738001974095e-07 0 3.300673970471662e-07 0 3.300773970471662e-07 0.00021 3.3008739704716623e-07 0 3.302836783083021e-07 0 3.3029367830830213e-07 0.00021 3.3030367830830214e-07 0 3.317003930328006e-07 0 3.317103930328006e-07 0.00021 3.317203930328006e-07 0 3.317203930328006e-07 0 3.317303930328006e-07 0.00021 3.3174039303280064e-07 0 3.3174039303280064e-07 0 3.3175039303280065e-07 0.00021 3.3176039303280066e-07 0 3.3176039303280066e-07 0 3.3177039303280067e-07 0.00021 3.317803930328007e-07 0 3.322604177816964e-07 0 3.322704177816964e-07 0.00021 3.322804177816964e-07 0 3.323642231801057e-07 0 3.323742231801057e-07 0.00021 3.323842231801057e-07 0 3.3343592691568745e-07 0 3.3344592691568746e-07 0.00021 3.3345592691568747e-07 0 3.3390114860409037e-07 0 3.339111486040904e-07 0.00021 3.339211486040904e-07 0 3.339940556061204e-07 0 3.340040556061204e-07 0.00021 3.340140556061204e-07 0 3.341724142640251e-07 0 3.341824142640251e-07 0.00021 3.341924142640251e-07 0 3.349351166173379e-07 0 3.349451166173379e-07 0.00021 3.3495511661733794e-07 0 3.356198116243852e-07 0 3.356298116243852e-07 0.00021 3.356398116243852e-07 0 3.358872818332036e-07 0 3.358972818332036e-07 0.00021 3.3590728183320363e-07 0 3.3601886667962226e-07 0 3.3602886667962227e-07 0.00021 3.360388666796223e-07 0 3.362623305064437e-07 0 3.362723305064437e-07 0.00021 3.362823305064437e-07 0 3.3737286526685283e-07 0 3.3738286526685284e-07 0.00021 3.3739286526685286e-07 0 3.3797461821184455e-07 0 3.3798461821184456e-07 0.00021 3.379946182118446e-07 0 3.3807978892007206e-07 0 3.3808978892007207e-07 0.00021 3.380997889200721e-07 0 3.3810604068199025e-07 0 3.3811604068199027e-07 0.00021 3.381260406819903e-07 0 3.3826479052879486e-07 0 3.3827479052879487e-07 0.00021 3.382847905287949e-07 0 3.3929561252204826e-07 0 3.3930561252204827e-07 0.00021 3.393156125220483e-07 0 3.400811932251041e-07 0 3.400911932251041e-07 0.00021 3.401011932251041e-07 0 3.404243784257283e-07 0 3.404343784257283e-07 0.00021 3.4044437842572834e-07 0 3.407811505578511e-07 0 3.407911505578511e-07 0.00021 3.408011505578511e-07 0 3.410183840530396e-07 0 3.410283840530396e-07 0.00021 3.410383840530396e-07 0 3.410470823434266e-07 0 3.410570823434266e-07 0.00021 3.410670823434266e-07 0 3.4213511376313155e-07 0 3.4214511376313156e-07 0.00021 3.421551137631316e-07 0 3.4334559451262764e-07 0 3.4335559451262765e-07 0.00021 3.4336559451262766e-07 0 3.4381780567272373e-07 0 3.4382780567272374e-07 0.00021 3.4383780567272375e-07 0 3.4383780567272375e-07 0 3.4384780567272376e-07 0.00021 3.4385780567272377e-07 0 3.4418219759768633e-07 0 3.4419219759768634e-07 0.00021 3.4420219759768635e-07 0 3.4436184232447895e-07 0 3.4437184232447896e-07 0.00021 3.44381842324479e-07 0 3.448023115252641e-07 0 3.4481231152526413e-07 0.00021 3.4482231152526414e-07 0 3.450610048330693e-07 0 3.450710048330693e-07 0.00021 3.450810048330693e-07 0 3.4634210846951877e-07 0 3.463521084695188e-07 0.00021 3.463621084695188e-07 0 3.465082538004782e-07 0 3.465182538004782e-07 0.00021 3.465282538004782e-07 0 3.4715366224410757e-07 0 3.471636622441076e-07 0.00021 3.471736622441076e-07 0 3.4790060412525405e-07 0 3.4791060412525406e-07 0.00021 3.4792060412525407e-07 0 3.4819341343054355e-07 0 3.4820341343054357e-07 0.00021 3.482134134305436e-07 0 3.484688209514399e-07 0 3.4847882095143994e-07 0.00021 3.4848882095143995e-07 0 3.4894989361467613e-07 0 3.4895989361467614e-07 0.00021 3.4896989361467616e-07 0 3.4956579452960197e-07 0 3.49575794529602e-07 0.00021 3.49585794529602e-07 0 3.501605078999831e-07 0 3.501705078999831e-07 0.00021 3.501805078999831e-07 0 3.50277697868266e-07 0 3.50287697868266e-07 0.00021 3.50297697868266e-07 0 3.508497676364645e-07 0 3.5085976763646454e-07 0.00021 3.5086976763646455e-07 0 3.520281282386668e-07 0 3.520381282386668e-07 0.00021 3.520481282386668e-07 0 3.528354408214714e-07 0 3.528454408214714e-07 0.00021 3.528554408214714e-07 0 3.528554408214714e-07 0 3.5286544082147144e-07 0.00021 3.5287544082147145e-07 0 3.533259051479826e-07 0 3.533359051479826e-07 0.00021 3.5334590514798263e-07 0 3.5343417296087794e-07 0 3.5344417296087795e-07 0.00021 3.5345417296087796e-07 0 3.5402461293500827e-07 0 3.540346129350083e-07 0.00021 3.540446129350083e-07 0 3.541127862903903e-07 0 3.541227862903903e-07 0.00021 3.541327862903903e-07 0 3.545229356960436e-07 0 3.545329356960436e-07 0.00021 3.545429356960436e-07 0 3.5478159612329875e-07 0 3.5479159612329876e-07 0.00021 3.5480159612329877e-07 0 3.550964244988412e-07 0 3.551064244988412e-07 0.00021 3.551164244988412e-07 0 3.552258941441073e-07 0 3.5523589414410733e-07 0.00021 3.5524589414410735e-07 0 3.5537740015459525e-07 0 3.5538740015459527e-07 0.00021 3.553974001545953e-07 0 3.5623282890814817e-07 0 3.562428289081482e-07 0.00021 3.562528289081482e-07 0 3.5632870152804824e-07 0 3.5633870152804825e-07 0.00021 3.5634870152804826e-07 0 3.571142088510125e-07 0 3.571242088510125e-07 0.00021 3.571342088510125e-07 0 3.5728239236676815e-07 0 3.5729239236676816e-07 0.00021 3.573023923667682e-07 0 3.580434380214213e-07 0 3.580534380214213e-07 0.00021 3.580634380214213e-07 0 3.5811830569418154e-07 0 3.5812830569418155e-07 0.00021 3.5813830569418156e-07 0 3.594459460109496e-07 0 3.594559460109496e-07 0.00021 3.5946594601094963e-07 0 3.596738028858088e-07 0 3.596838028858088e-07 0.00021 3.5969380288580883e-07 0 3.598472334165792e-07 0 3.5985723341657924e-07 0.00021 3.5986723341657925e-07 0 3.6056846658112246e-07 0 3.605784665811225e-07 0.00021 3.605884665811225e-07 0 3.6063151427922553e-07 0 3.6064151427922554e-07 0.00021 3.6065151427922555e-07 0 3.6068309989233776e-07 0 3.606930998923378e-07 0.00021 3.607030998923378e-07 0 3.611448067062669e-07 0 3.611548067062669e-07 0.00021 3.6116480670626693e-07 0 3.612595128898793e-07 0 3.612695128898793e-07 0.00021 3.612795128898793e-07 0 3.612829558146457e-07 0 3.612929558146457e-07 0.00021 3.613029558146457e-07 0 3.613987090637259e-07 0 3.614087090637259e-07 0.00021 3.6141870906372593e-07 0 3.623236980615942e-07 0 3.6233369806159423e-07 0.00021 3.6234369806159425e-07 0 3.625067353372161e-07 0 3.625167353372161e-07 0.00021 3.625267353372161e-07 0 3.629448686348099e-07 0 3.6295486863480994e-07 0.00021 3.6296486863480995e-07 0 3.6497823068898074e-07 0 3.6498823068898075e-07 0.00021 3.6499823068898077e-07 0 3.6533520886980934e-07 0 3.6534520886980935e-07 0.00021 3.6535520886980936e-07 0 3.656552348858316e-07 0 3.656652348858316e-07 0.00021 3.656752348858316e-07 0 3.65716841261451e-07 0 3.65726841261451e-07 0.00021 3.6573684126145103e-07 0 3.659917747898438e-07 0 3.660017747898438e-07 0.00021 3.6601177478984383e-07 0 3.662914749989923e-07 0 3.663014749989923e-07 0.00021 3.663114749989923e-07 0 3.6642495428957493e-07 0 3.6643495428957495e-07 0.00021 3.6644495428957496e-07 0 3.6786444099163426e-07 0 3.6787444099163427e-07 0.00021 3.678844409916343e-07 0 3.701631261181438e-07 0 3.7017312611814383e-07 0.00021 3.7018312611814385e-07 0 3.7047376289876903e-07 0 3.7048376289876904e-07 0.00021 3.7049376289876905e-07 0 3.705643145209085e-07 0 3.7057431452090853e-07 0.00021 3.7058431452090854e-07 0 3.7176638129182466e-07 0 3.717763812918247e-07 0.00021 3.717863812918247e-07 0 3.728307577719653e-07 0 3.7284075777196533e-07 0.00021 3.7285075777196534e-07 0 3.73184811947719e-07 0 3.73194811947719e-07 0.00021 3.7320481194771903e-07 0 3.7374419467973767e-07 0 3.737541946797377e-07 0.00021 3.737641946797377e-07 0 3.738113604295702e-07 0 3.738213604295702e-07 0.00021 3.7383136042957023e-07 0 3.7470983228434766e-07 0 3.7471983228434767e-07 0.00021 3.747298322843477e-07 0 3.752899218045516e-07 0 3.752999218045516e-07 0.00021 3.753099218045516e-07 0 3.7545133645915154e-07 0 3.7546133645915155e-07 0.00021 3.7547133645915156e-07 0 3.7588051786473347e-07 0 3.758905178647335e-07 0.00021 3.759005178647335e-07 0 3.7600725037493815e-07 0 3.7601725037493816e-07 0.00021 3.7602725037493817e-07 0 3.7644182457759177e-07 0 3.764518245775918e-07 0.00021 3.764618245775918e-07 0 3.7661265490951245e-07 0 3.7662265490951247e-07 0.00021 3.766326549095125e-07 0 3.7715893044081856e-07 0 3.7716893044081857e-07 0.00021 3.771789304408186e-07 0 3.771789304408186e-07 0 3.771889304408186e-07 0.00021 3.771989304408186e-07 0 3.773426368912363e-07 0 3.773526368912363e-07 0.00021 3.7736263689123633e-07 0 3.7736263689123633e-07 0 3.7737263689123634e-07 0.00021 3.7738263689123636e-07 0 3.77438717080672e-07 0 3.77448717080672e-07 0.00021 3.77458717080672e-07 0 3.779400124032551e-07 0 3.779500124032551e-07 0.00021 3.779600124032551e-07 0 3.784444407570736e-07 0 3.784544407570736e-07 0.00021 3.7846444075707363e-07 0 3.7846444075707363e-07 0 3.7847444075707364e-07 0.00021 3.7848444075707365e-07 0 3.787524583295783e-07 0 3.787624583295783e-07 0.00021 3.787724583295783e-07 0 3.7889506531720625e-07 0 3.7890506531720626e-07 0.00021 3.7891506531720627e-07 0 3.7909462476024244e-07 0 3.7910462476024245e-07 0.00021 3.7911462476024246e-07 0 3.791720751048979e-07 0 3.7918207510489793e-07 0.00021 3.7919207510489794e-07 0 3.7975708986596147e-07 0 3.797670898659615e-07 0.00021 3.797770898659615e-07 0 3.7998530131848233e-07 0 3.7999530131848234e-07 0.00021 3.8000530131848235e-07 0 3.805845582815182e-07 0 3.805945582815182e-07 0.00021 3.806045582815182e-07 0 3.8075448169708807e-07 0 3.807644816970881e-07 0.00021 3.807744816970881e-07 0 3.846669727048153e-07 0 3.846769727048153e-07 0.00021 3.8468697270481533e-07 0 3.84741796285068e-07 0 3.84751796285068e-07 0.00021 3.84761796285068e-07 0 3.8519373332214395e-07 0 3.8520373332214396e-07 0.00021 3.85213733322144e-07 0 3.857099269533782e-07 0 3.8571992695337824e-07 0.00021 3.8572992695337825e-07 0 3.8588156330725153e-07 0 3.8589156330725154e-07 0.00021 3.8590156330725155e-07 0 3.8628484621345436e-07 0 3.8629484621345437e-07 0.00021 3.863048462134544e-07 0 3.863823570268841e-07 0 3.863923570268841e-07 0.00021 3.8640235702688413e-07 0 3.867136833583084e-07 0 3.867236833583084e-07 0.00021 3.867336833583084e-07 0 3.8815407469785875e-07 0 3.8816407469785876e-07 0.00021 3.8817407469785877e-07 0 3.886495512357113e-07 0 3.886595512357113e-07 0.00021 3.8866955123571133e-07 0 3.8933678638627694e-07 0 3.8934678638627695e-07 0.00021 3.8935678638627696e-07 0 3.899272632645807e-07 0 3.8993726326458073e-07 0.00021 3.8994726326458074e-07 0 3.8994923418061516e-07 0 3.8995923418061517e-07 0.00021 3.899692341806152e-07 0 3.903919944586573e-07 0 3.904019944586573e-07 0.00021 3.904119944586573e-07 0 3.9099968311523895e-07 0 3.9100968311523896e-07 0.00021 3.9101968311523897e-07 0 3.913852102357995e-07 0 3.9139521023579953e-07 0.00021 3.9140521023579954e-07 0 3.916762701363951e-07 0 3.916862701363951e-07 0.00021 3.9169627013639514e-07 0 3.9170993147078067e-07 0 3.917199314707807e-07 0.00021 3.917299314707807e-07 0 3.921214688148154e-07 0 3.921314688148154e-07 0.00021 3.921414688148154e-07 0 3.927811851664855e-07 0 3.927911851664855e-07 0.00021 3.928011851664855e-07 0 3.9295605084827164e-07 0 3.9296605084827165e-07 0.00021 3.9297605084827166e-07 0 3.9308252139277596e-07 0 3.93092521392776e-07 0.00021 3.93102521392776e-07 0 3.932507451472886e-07 0 3.932607451472886e-07 0.00021 3.9327074514728863e-07 0 3.948874977572382e-07 0 3.948974977572382e-07 0.00021 3.949074977572382e-07 0 3.952310740139145e-07 0 3.952410740139145e-07 0.00021 3.952510740139145e-07 0 3.9602783296134846e-07 0 3.960378329613485e-07 0.00021 3.960478329613485e-07 0 3.9665564807322165e-07 0 3.9666564807322166e-07 0.00021 3.966756480732217e-07 0 3.9673742224224254e-07 0 3.9674742224224255e-07 0.00021 3.9675742224224256e-07 0 3.9728963139723915e-07 0 3.9729963139723916e-07 0.00021 3.9730963139723917e-07 0 3.979599270391347e-07 0 3.9796992703913473e-07 0.00021 3.9797992703913474e-07 0 3.9822044492956323e-07 0 3.9823044492956324e-07 0.00021 3.9824044492956325e-07 0 3.9835810768899115e-07 0 3.9836810768899116e-07 0.00021 3.9837810768899117e-07 0 3.984134009345111e-07 0 3.984234009345111e-07 0.00021 3.984334009345111e-07 0 3.9850094328105295e-07 0 3.9851094328105296e-07 0.00021 3.98520943281053e-07 0 3.9921354184769715e-07 0 3.9922354184769716e-07 0.00021 3.9923354184769717e-07 0 3.993020079046271e-07 0 3.9931200790462713e-07 0.00021 3.9932200790462714e-07 0 3.9942979051143643e-07 0 3.9943979051143644e-07 0.00021 3.9944979051143645e-07 0 4.001804521988822e-07 0 4.001904521988822e-07 0.00021 4.002004521988822e-07 0 4.0031283782346763e-07 0 4.0032283782346764e-07 0.00021 4.0033283782346765e-07 0 4.0035356743005316e-07 0 4.003635674300532e-07 0.00021 4.003735674300532e-07 0 4.0044411606348804e-07 0 4.0045411606348805e-07 0.00021 4.0046411606348806e-07 0 4.0103640093237704e-07 0 4.0104640093237705e-07 0.00021 4.0105640093237706e-07 0 4.0105640093237706e-07 0 4.0106640093237707e-07 0.00021 4.010764009323771e-07 0 4.0227458096878986e-07 0 4.022845809687899e-07 0.00021 4.022945809687899e-07 0 4.023864557942808e-07 0 4.023964557942808e-07 0.00021 4.024064557942808e-07 0 4.027832196957561e-07 0 4.027932196957561e-07 0.00021 4.028032196957561e-07 0 4.032094652670101e-07 0 4.032194652670101e-07 0.00021 4.032294652670101e-07 0 4.0364640889937284e-07 0 4.0365640889937286e-07 0.00021 4.0366640889937287e-07 0 4.042473901047692e-07 0 4.042573901047692e-07 0.00021 4.042673901047692e-07 0 4.0475287441767535e-07 0 4.0476287441767536e-07 0.00021 4.047728744176754e-07 0 4.04847980995091e-07 0 4.04857980995091e-07 0.00021 4.04867980995091e-07 0 4.065322133078917e-07 0 4.0654221330789173e-07 0.00021 4.0655221330789174e-07 0 4.0745212385998904e-07 0 4.0746212385998905e-07 0.00021 4.0747212385998906e-07 0 4.0880130013650853e-07 0 4.0881130013650854e-07 0.00021 4.0882130013650855e-07 0 4.091986742036337e-07 0 4.092086742036337e-07 0.00021 4.092186742036337e-07 0 4.0930904653687715e-07 0 4.0931904653687716e-07 0.00021 4.093290465368772e-07 0 4.093290465368772e-07 0 4.093390465368772e-07 0.00021 4.093490465368772e-07 0 4.095670968584008e-07 0 4.095770968584008e-07 0.00021 4.095870968584008e-07 0 4.096866356139965e-07 0 4.096966356139965e-07 0.00021 4.097066356139965e-07 0 4.098590503038253e-07 0 4.098690503038253e-07 0.00021 4.0987905030382533e-07 0 4.114720347579469e-07 0 4.114820347579469e-07 0.00021 4.114920347579469e-07 0 4.114920347579469e-07 0 4.115020347579469e-07 0.00021 4.115120347579469e-07 0 4.1272914151430027e-07 0 4.127391415143003e-07 0.00021 4.127491415143003e-07 0 4.1287874418577505e-07 0 4.1288874418577506e-07 0.00021 4.1289874418577507e-07 0 4.13145975263369e-07 0 4.13155975263369e-07 0.00021 4.13165975263369e-07 0 4.134284315112735e-07 0 4.1343843151127354e-07 0.00021 4.1344843151127355e-07 0 4.1386488544670846e-07 0 4.1387488544670847e-07 0.00021 4.138848854467085e-07 0 4.142377101135699e-07 0 4.142477101135699e-07 0.00021 4.142577101135699e-07 0 4.145600523154484e-07 0 4.145700523154484e-07 0.00021 4.1458005231544844e-07 0 4.1471823116672175e-07 0 4.1472823116672176e-07 0.00021 4.1473823116672177e-07 0 4.1643168593059e-07 0 4.1644168593059e-07 0.00021 4.1645168593059e-07 0 4.165301534355152e-07 0 4.165401534355152e-07 0.00021 4.165501534355152e-07 0 4.169142216917299e-07 0 4.169242216917299e-07 0.00021 4.169342216917299e-07 0 4.1710517860624217e-07 0 4.171151786062422e-07 0.00021 4.171251786062422e-07 0 4.1794430090626356e-07 0 4.1795430090626357e-07 0.00021 4.179643009062636e-07 0 4.187189118206694e-07 0 4.1872891182066943e-07 0.00021 4.1873891182066944e-07 0 4.187548394489679e-07 0 4.187648394489679e-07 0.00021 4.187748394489679e-07 0 4.187748394489679e-07 0 4.1878483944896793e-07 0.00021 4.1879483944896794e-07 0 4.191129451019586e-07 0 4.191229451019586e-07 0.00021 4.1913294510195864e-07 0 4.1968946777744797e-07 0 4.19699467777448e-07 0.00021 4.19709467777448e-07 0 4.210476225118162e-07 0 4.210576225118162e-07 0.00021 4.210676225118162e-07 0 4.211042919590391e-07 0 4.211142919590391e-07 0.00021 4.2112429195903913e-07 0 4.217056143847987e-07 0 4.217156143847987e-07 0.00021 4.2172561438479873e-07 0 4.222902183651932e-07 0 4.223002183651932e-07 0.00021 4.223102183651932e-07 0 4.2248059069100363e-07 0 4.2249059069100364e-07 0.00021 4.2250059069100366e-07 0 4.232888188744071e-07 0 4.2329881887440713e-07 0.00021 4.2330881887440714e-07 0 4.239441977672901e-07 0 4.239541977672901e-07 0.00021 4.239641977672901e-07 0 4.2431246875183896e-07 0 4.24322468751839e-07 0.00021 4.24332468751839e-07 0 4.243384373414064e-07 0 4.2434843734140643e-07 0.00021 4.2435843734140644e-07 0 4.2460329144873985e-07 0 4.2461329144873986e-07 0.00021 4.2462329144873987e-07 0 4.246737531747707e-07 0 4.246837531747707e-07 0.00021 4.246937531747707e-07 0 4.258745249983415e-07 0 4.258845249983415e-07 0.00021 4.258945249983415e-07 0 4.262157555935088e-07 0 4.262257555935088e-07 0.00021 4.2623575559350883e-07 0 4.2630353359151784e-07 0 4.2631353359151785e-07 0.00021 4.2632353359151786e-07 0 4.267619882377196e-07 0 4.267719882377196e-07 0.00021 4.267819882377196e-07 0 4.2731033143825354e-07 0 4.2732033143825355e-07 0.00021 4.2733033143825356e-07 0 4.278694425336699e-07 0 4.278794425336699e-07 0.00021 4.278894425336699e-07 0 4.285035283234922e-07 0 4.285135283234922e-07 0.00021 4.285235283234922e-07 0 4.2869500098268764e-07 0 4.2870500098268766e-07 0.00021 4.2871500098268767e-07 0 4.2883349806459457e-07 0 4.288434980645946e-07 0.00021 4.288534980645946e-07 0 4.2942396704939307e-07 0 4.294339670493931e-07 0.00021 4.294439670493931e-07 0 4.29715190394293e-07 0 4.2972519039429304e-07 0.00021 4.2973519039429305e-07 0 4.30197329477084e-07 0 4.30207329477084e-07 0.00021 4.30217329477084e-07 0 4.303880979528339e-07 0 4.303980979528339e-07 0.00021 4.304080979528339e-07 0 4.3069747958369837e-07 0 4.307074795836984e-07 0.00021 4.307174795836984e-07 0 4.308561146936714e-07 0 4.308661146936714e-07 0.00021 4.3087611469367143e-07 0 4.3117313176596437e-07 0 4.311831317659644e-07 0.00021 4.311931317659644e-07 0 4.3161185990887647e-07 0 4.316218599088765e-07 0.00021 4.316318599088765e-07 0 4.32112893687922e-07 0 4.3212289368792204e-07 0.00021 4.3213289368792205e-07 0 4.321983717003435e-07 0 4.322083717003435e-07 0.00021 4.322183717003435e-07 0 4.323042721283188e-07 0 4.323142721283188e-07 0.00021 4.323242721283188e-07 0 4.324866924769769e-07 0 4.324966924769769e-07 0.00021 4.325066924769769e-07 0 4.332913325001597e-07 0 4.3330133250015973e-07 0.00021 4.3331133250015974e-07 0 4.34179786453335e-07 0 4.34189786453335e-07 0.00021 4.34199786453335e-07 0 4.3485007930002926e-07 0 4.348600793000293e-07 0.00021 4.348700793000293e-07 0 4.3515028957045013e-07 0 4.3516028957045014e-07 0.00021 4.3517028957045016e-07 0 4.3548907070562493e-07 0 4.3549907070562494e-07 0.00021 4.3550907070562495e-07 0 4.359041968582781e-07 0 4.359141968582781e-07 0.00021 4.3592419685827813e-07 0 4.363408878193959e-07 0 4.363508878193959e-07 0.00021 4.363608878193959e-07 0 4.372005085723304e-07 0 4.372105085723304e-07 0.00021 4.372205085723304e-07 0 4.377491772938467e-07 0 4.377591772938467e-07 0.00021 4.377691772938467e-07 0 4.3783259826223473e-07 0 4.3784259826223474e-07 0.00021 4.3785259826223475e-07 0 4.3830094459234024e-07 0 4.3831094459234025e-07 0.00021 4.3832094459234026e-07 0 4.3832094459234026e-07 0 4.3833094459234027e-07 0.00021 4.383409445923403e-07 0 4.3916619356144037e-07 0 4.391761935614404e-07 0.00021 4.391861935614404e-07 0 4.3971476341498445e-07 0 4.3972476341498446e-07 0.00021 4.3973476341498447e-07 0 4.3983772949997143e-07 0 4.3984772949997145e-07 0.00021 4.3985772949997146e-07 0 4.4041164163722154e-07 0 4.4042164163722156e-07 0.00021 4.4043164163722157e-07 0 4.40622668313168e-07 0 4.40632668313168e-07 0.00021 4.4064266831316804e-07 0 4.4093169164953897e-07 0 4.40941691649539e-07 0.00021 4.40951691649539e-07 0 4.41812977014419e-07 0 4.41822977014419e-07 0.00021 4.41832977014419e-07 0 4.419332865648537e-07 0 4.419432865648537e-07 0.00021 4.4195328656485373e-07 0 4.4250094640200585e-07 0 4.4251094640200586e-07 0.00021 4.4252094640200587e-07 0 4.435733451661374e-07 0 4.4358334516613743e-07 0.00021 4.4359334516613744e-07 0 4.4444233545122867e-07 0 4.444523354512287e-07 0.00021 4.444623354512287e-07 0 4.446407438726193e-07 0 4.446507438726193e-07 0.00021 4.4466074387261933e-07 0 4.461969144670756e-07 0 4.462069144670756e-07 0.00021 4.4621691446707563e-07 0 4.4621691446707563e-07 0 4.4622691446707564e-07 0.00021 4.4623691446707565e-07 0 4.463944124998941e-07 0 4.464044124998941e-07 0.00021 4.464144124998941e-07 0 4.4690907774885564e-07 0 4.4691907774885566e-07 0.00021 4.4692907774885567e-07 0 4.472894048677988e-07 0 4.472994048677988e-07 0.00021 4.473094048677988e-07 0 4.4820829139543427e-07 0 4.482182913954343e-07 0.00021 4.482282913954343e-07 0 4.487220019785615e-07 0 4.487320019785615e-07 0.00021 4.4874200197856153e-07 0 4.491113713963913e-07 0 4.491213713963913e-07 0.00021 4.491313713963913e-07 0 4.4916297338577943e-07 0 4.4917297338577944e-07 0.00021 4.4918297338577945e-07 0 4.4923687648172025e-07 0 4.4924687648172026e-07 0.00021 4.492568764817203e-07 0 4.495378079088943e-07 0 4.495478079088943e-07 0.00021 4.495578079088943e-07 0 4.498239089924829e-07 0 4.498339089924829e-07 0.00021 4.498439089924829e-07 0 4.5136980892493953e-07 0 4.5137980892493954e-07 0.00021 4.5138980892493956e-07 0 4.523059417240548e-07 0 4.5231594172405484e-07 0.00021 4.5232594172405485e-07 0 4.5492201756264255e-07 0 4.5493201756264256e-07 0.00021 4.5494201756264257e-07 0 4.5497875538809594e-07 0 4.5498875538809595e-07 0.00021 4.5499875538809596e-07 0 4.558122844081672e-07 0 4.558222844081672e-07 0.00021 4.5583228440816723e-07 0 4.559439502993787e-07 0 4.559539502993787e-07 0.00021 4.559639502993787e-07 0 4.56226564128213e-07 0 4.56236564128213e-07 0.00021 4.56246564128213e-07 0 4.564830901964323e-07 0 4.564930901964323e-07 0.00021 4.565030901964323e-07 0 4.5682665459295227e-07 0 4.568366545929523e-07 0.00021 4.568466545929523e-07 0 4.569695892569086e-07 0 4.5697958925690864e-07 0.00021 4.5698958925690865e-07 0 4.5719440141812395e-07 0 4.5720440141812397e-07 0.00021 4.57214401418124e-07 0 4.572177536640096e-07 0 4.572277536640096e-07 0.00021 4.572377536640096e-07 0 4.583012555317103e-07 0 4.583112555317103e-07 0.00021 4.583212555317103e-07 0 4.584934760528032e-07 0 4.5850347605280323e-07 0.00021 4.5851347605280324e-07 0 4.601479807391465e-07 0 4.601579807391465e-07 0.00021 4.601679807391465e-07 0 4.6052174631861576e-07 0 4.6053174631861577e-07 0.00021 4.605417463186158e-07 0 4.609165044599023e-07 0 4.609265044599023e-07 0.00021 4.6093650445990233e-07 0 4.6119710698357583e-07 0 4.6120710698357585e-07 0.00021 4.6121710698357586e-07 0 4.6132808420285343e-07 0 4.6133808420285344e-07 0.00021 4.6134808420285346e-07 0 4.619509652746993e-07 0 4.619609652746993e-07 0.00021 4.619709652746993e-07 0 4.620574687685616e-07 0 4.620674687685616e-07 0.00021 4.6207746876856164e-07 0 4.6288632452790835e-07 0 4.6289632452790836e-07 0.00021 4.629063245279084e-07 0 4.6435094861553127e-07 0 4.643609486155313e-07 0.00021 4.643709486155313e-07 0 4.6543920046986434e-07 0 4.6544920046986435e-07 0.00021 4.6545920046986437e-07 0 4.6638582277962826e-07 0 4.6639582277962827e-07 0.00021 4.664058227796283e-07 0 4.6667412960532456e-07 0 4.6668412960532457e-07 0.00021 4.666941296053246e-07 0 4.6704762299671954e-07 0 4.6705762299671956e-07 0.00021 4.6706762299671957e-07 0 4.6792795096196485e-07 0 4.6793795096196486e-07 0.00021 4.6794795096196487e-07 0 4.681394454979615e-07 0 4.6814944549796153e-07 0.00021 4.6815944549796154e-07 0 4.685575765265732e-07 0 4.685675765265732e-07 0.00021 4.685775765265732e-07 0 4.689862190870066e-07 0 4.689962190870066e-07 0.00021 4.6900621908700663e-07 0 4.696546556481662e-07 0 4.696646556481662e-07 0.00021 4.6967465564816623e-07 0 4.7002317424545294e-07 0 4.7003317424545295e-07 0.00021 4.7004317424545296e-07 0 4.7026341341092514e-07 0 4.7027341341092515e-07 0.00021 4.7028341341092516e-07 0 4.705542525606989e-07 0 4.7056425256069893e-07 0.00021 4.7057425256069894e-07 0 4.710689250848167e-07 0 4.710789250848167e-07 0.00021 4.7108892508481673e-07 0 4.717649137982449e-07 0 4.7177491379824494e-07 0.00021 4.7178491379824495e-07 0 4.718130807449738e-07 0 4.718230807449738e-07 0.00021 4.718330807449738e-07 0 4.7236073179675644e-07 0 4.7237073179675645e-07 0.00021 4.7238073179675646e-07 0 4.731330361165102e-07 0 4.731430361165102e-07 0.00021 4.731530361165102e-07 0 4.734585714119402e-07 0 4.734685714119402e-07 0.00021 4.734785714119402e-07 0 4.7355146349877574e-07 0 4.7356146349877575e-07 0.00021 4.7357146349877576e-07 0 4.741075374738024e-07 0 4.741175374738024e-07 0.00021 4.741275374738024e-07 0 4.7448836584948024e-07 0 4.7449836584948026e-07 0.00021 4.7450836584948027e-07 0 4.7475122891526684e-07 0 4.7476122891526686e-07 0.00021 4.7477122891526687e-07 0 4.7499382598432084e-07 0 4.7500382598432085e-07 0.00021 4.7501382598432086e-07 0 4.7520264327055553e-07 0 4.7521264327055554e-07 0.00021 4.7522264327055555e-07 0 4.752536587472428e-07 0 4.752636587472428e-07 0.00021 4.752736587472428e-07 0 4.756621437764082e-07 0 4.756721437764082e-07 0.00021 4.756821437764082e-07 0 4.7602637179197784e-07 0 4.7603637179197785e-07 0.00021 4.7604637179197787e-07 0 4.760791242229065e-07 0 4.7608912422290654e-07 0.00021 4.7609912422290655e-07 0 4.761994199654674e-07 0 4.7620941996546743e-07 0.00021 4.7621941996546745e-07 0 4.763172480226151e-07 0 4.763272480226151e-07 0.00021 4.763372480226151e-07 0 4.7659962798783967e-07 0 4.766096279878397e-07 0.00021 4.766196279878397e-07 0 4.766196279878397e-07 0 4.766296279878397e-07 0.00021 4.766396279878397e-07 0 4.773365056490886e-07 0 4.773465056490885e-07 0.00021 4.773565056490885e-07 0 4.776293681713396e-07 0 4.776393681713396e-07 0.00021 4.776493681713395e-07 0 4.778617002475818e-07 0 4.778717002475818e-07 0.00021 4.778817002475817e-07 0 4.780956658211307e-07 0 4.781056658211306e-07 0.00021 4.781156658211306e-07 0 4.787720963091984e-07 0 4.787820963091984e-07 0.00021 4.787920963091984e-07 0 4.79067340531837e-07 0 4.790773405318369e-07 0.00021 4.790873405318369e-07 0 4.79087340531837e-07 0 4.790973405318369e-07 0.00021 4.791073405318369e-07 0 4.794999514642545e-07 0 4.795099514642544e-07 0.00021 4.795199514642544e-07 0 4.795239510869773e-07 0 4.795339510869773e-07 0.00021 4.795439510869773e-07 0 4.795450313935761e-07 0 4.79555031393576e-07 0.00021 4.79565031393576e-07 0 4.798976177012716e-07 0 4.799076177012715e-07 0.00021 4.799176177012715e-07 0 4.800494749073172e-07 0 4.800594749073172e-07 0.00021 4.800694749073171e-07 0 4.802968790734438e-07 0 4.803068790734437e-07 0.00021 4.803168790734437e-07 0 4.806144921695816e-07 0 4.806244921695815e-07 0.00021 4.806344921695815e-07 0 4.806595146102618e-07 0 4.806695146102618e-07 0.00021 4.806795146102617e-07 0 4.808843217156693e-07 0 4.808943217156692e-07 0.00021 4.809043217156692e-07 0 4.824947152029091e-07 0 4.825047152029091e-07 0.00021 4.82514715202909e-07 0 4.832612328341143e-07 0 4.832712328341142e-07 0.00021 4.832812328341142e-07 0 4.836630493345645e-07 0 4.836730493345644e-07 0.00021 4.836830493345644e-07 0 4.842819722832118e-07 0 4.842919722832118e-07 0.00021 4.843019722832117e-07 0 4.843257453533521e-07 0 4.843357453533521e-07 0.00021 4.843457453533521e-07 0 4.844878766365596e-07 0 4.844978766365596e-07 0.00021 4.845078766365595e-07 0 4.84833190398932e-07 0 4.84843190398932e-07 0.00021 4.848531903989319e-07 0 4.850383204506186e-07 0 4.850483204506185e-07 0.00021 4.850583204506185e-07 0 4.851744842133169e-07 0 4.851844842133169e-07 0.00021 4.851944842133168e-07 0 4.854138919747772e-07 0 4.854238919747772e-07 0.00021 4.854338919747771e-07 0 4.860568069983391e-07 0 4.86066806998339e-07 0.00021 4.86076806998339e-07 0 4.867203801656829e-07 0 4.867303801656828e-07 0.00021 4.867403801656828e-07 0 4.869888114343112e-07 0 4.869988114343111e-07 0.00021 4.870088114343111e-07 0 4.880627691104998e-07 0 4.880727691104997e-07 0.00021 4.880827691104997e-07 0 4.884267894742611e-07 0 4.88436789474261e-07 0.00021 4.88446789474261e-07 0 4.898503761923509e-07 0 4.898603761923508e-07 0.00021 4.898703761923508e-07 0 4.905737182710353e-07 0 4.905837182710352e-07 0.00021 4.905937182710352e-07 0 4.908376240019266e-07 0 4.908476240019266e-07 0.00021 4.908576240019265e-07 0 4.910517816242482e-07 0 4.910617816242481e-07 0.00021 4.910717816242481e-07 0 4.914782258666062e-07 0 4.914882258666061e-07 0.00021 4.914982258666061e-07 0 4.93363745879396e-07 0 4.933737458793959e-07 0.00021 4.933837458793959e-07 0 4.934688501382208e-07 0 4.934788501382208e-07 0.00021 4.934888501382208e-07 0 4.935250310084672e-07 0 4.935350310084672e-07 0.00021 4.935450310084671e-07 0 4.936863082526704e-07 0 4.936963082526703e-07 0.00021 4.937063082526703e-07 0 4.937717523784128e-07 0 4.937817523784127e-07 0.00021 4.937917523784127e-07 0 4.939030895672524e-07 0 4.939130895672523e-07 0.00021 4.939230895672523e-07 0 4.939798899270053e-07 0 4.939898899270053e-07 0.00021 4.939998899270052e-07 0 4.95228978729636e-07 0 4.95238978729636e-07 0.00021 4.952489787296359e-07 0 4.959406640477845e-07 0 4.959506640477845e-07 0.00021 4.959606640477844e-07 0 4.963134018058436e-07 0 4.963234018058435e-07 0.00021 4.963334018058435e-07 0 4.964832935750517e-07 0 4.964932935750517e-07 0.00021 4.965032935750516e-07 0 4.966077032817971e-07 0 4.96617703281797e-07 0.00021 4.96627703281797e-07 0 4.971528799233763e-07 0 4.971628799233762e-07 0.00021 4.971728799233762e-07 0 4.974025116473497e-07 0 4.974125116473496e-07 0.00021 4.974225116473496e-07 0 4.975752892468313e-07 0 4.975852892468312e-07 0.00021 4.975952892468312e-07 0 4.979558269658967e-07 0 4.979658269658966e-07 0.00021 4.979758269658966e-07 0 4.984015247018153e-07 0 4.984115247018152e-07 0.00021 4.984215247018152e-07 0 4.993169847731192e-07 0 4.993269847731191e-07 0.00021 4.993369847731191e-07 0 4.993517128894772e-07 0 4.993617128894772e-07 0.00021 4.993717128894772e-07 0 )
VIN5 5 0 pwl(0 0)
X6 SPLITTER 1 6 7
X8 SPLITTER 6 8 9
X9 SPLITTER 7 10 11
X10 SPLITTER 2 14 15
X12 SPLITTER 14 16 17
X13 SPLITTER 15 18 19
X14 SPLITTER 3 22 23
X16 SPLITTER 22 24 25
X17 SPLITTER 23 26 27
X18 SPLITTER 4 30 31
X20 SPLITTER 30 32 33
X21 SPLITTER 31 34 35
IB36 0 36 pwl(0 0 5p 225.3u)
X37 SYNAPSE 8 36 1037
X1037 JTL 1037 37
IB38 0 38 pwl(0 0 5p 400.0u)
X39 SYNAPSE 16 38 1039
X1039 JTL 1039 39
IB40 0 40 pwl(0 0 5p 269.1u)
X41 SYNAPSE 24 40 1041
X1041 JTL 1041 41
IB42 0 42 pwl(0 0 5p 400.0u)
X43 SYNAPSE 32 42 1043
X1043 JTL 1043 43
IB44 0 44 pwl(0 0 5p 150.9u)
VIN45 45 0 pwl(0 0 6.699319039689096e-10 0 6.799319039689096e-10 0.00021 6.899319039689096e-10 0 1.6895290054347743e-09 0 1.6995290054347742e-09 0.00021 1.7095290054347742e-09 0 1.7095290054347742e-09 0 1.7195290054347742e-09 0.00021 1.7295290054347741e-09 0 1.7295290054347741e-09 0 1.739529005434774e-09 0.00021 1.749529005434774e-09 0 2.261947867344106e-09 0 2.2719478673441063e-09 0.00021 2.2819478673441065e-09 0 3.891888302002492e-09 0 3.901888302002492e-09 0.00021 3.9118883020024915e-09 0 4.565471254669724e-09 0 4.575471254669723e-09 0.00021 4.585471254669723e-09 0 5.320772612495115e-09 0 5.330772612495115e-09 0.00021 5.340772612495115e-09 0 8.13755859157084e-09 0 8.14755859157084e-09 0.00021 8.15755859157084e-09 0 1.4195311672013414e-08 0 1.4205311672013413e-08 0.00021 1.4215311672013413e-08 0 1.7481739929907154e-08 0 1.7491739929907155e-08 0.00021 1.7501739929907157e-08 0 1.7501739929907153e-08 0 1.7511739929907155e-08 0.00021 1.7521739929907156e-08 0 1.9752122344508886e-08 0 1.9762122344508888e-08 0.00021 1.977212234450889e-08 0 1.982462002942878e-08 0 1.983462002942878e-08 0.00021 1.984462002942878e-08 0 2.0894020331596096e-08 0 2.0904020331596097e-08 0.00021 2.09140203315961e-08 0 2.1742953361140633e-08 0 2.1752953361140634e-08 0.00021 2.1762953361140636e-08 0 2.4892862013879127e-08 0 2.4902862013879128e-08 0.00021 2.491286201387913e-08 0 2.5246872056072377e-08 0 2.5256872056072378e-08 0.00021 2.526687205607238e-08 0 2.5553983195700722e-08 0 2.5563983195700723e-08 0.00021 2.5573983195700725e-08 0 2.7046202608826746e-08 0 2.7056202608826748e-08 0.00021 2.706620260882675e-08 0 2.7083206807612435e-08 0 2.7093206807612437e-08 0.00021 2.7103206807612438e-08 0 2.7218537619829642e-08 0 2.7228537619829643e-08 0.00021 2.7238537619829645e-08 0 2.8248735726482085e-08 0 2.8258735726482087e-08 0.00021 2.8268735726482088e-08 0 2.902328394445528e-08 0 2.9033283944455282e-08 0.00021 2.9043283944455284e-08 0 3.076096245449594e-08 0 3.0770962454495935e-08 0.00021 3.0780962454495933e-08 0 3.117463254033064e-08 0 3.118463254033064e-08 0.00021 3.119463254033064e-08 0 3.162284330367877e-08 0 3.163284330367877e-08 0.00021 3.164284330367877e-08 0 3.3474935656659066e-08 0 3.3484935656659064e-08 0.00021 3.349493565665906e-08 0 3.5200149266782075e-08 0 3.521014926678207e-08 0.00021 3.522014926678207e-08 0 3.552360854033267e-08 0 3.5533608540332667e-08 0.00021 3.5543608540332665e-08 0 3.573436996121096e-08 0 3.574436996121096e-08 0.00021 3.5754369961210956e-08 0 3.695766392097994e-08 0 3.6967663920979935e-08 0.00021 3.697766392097993e-08 0 3.749598812425032e-08 0 3.750598812425032e-08 0.00021 3.7515988124250316e-08 0 3.8350673217967685e-08 0 3.8360673217967683e-08 0.00021 3.837067321796768e-08 0 3.939939542823749e-08 0 3.940939542823749e-08 0.00021 3.9419395428237485e-08 0 4.063156607213525e-08 0 4.0641566072135246e-08 0.00021 4.0651566072135244e-08 0 4.355973538544831e-08 0 4.356973538544831e-08 0.00021 4.357973538544831e-08 0 4.371342414403645e-08 0 4.372342414403645e-08 0.00021 4.3733424144036445e-08 0 4.517922905922227e-08 0 4.5189229059222266e-08 0.00021 4.5199229059222264e-08 0 4.630346658829152e-08 0 4.6313466588291516e-08 0.00021 4.6323466588291514e-08 0 4.820151700662107e-08 0 4.821151700662107e-08 0.00021 4.8221517006621066e-08 0 4.880050898076728e-08 0 4.8810508980767275e-08 0.00021 4.882050898076727e-08 0 4.9269193645087165e-08 0 4.927919364508716e-08 0.00021 4.928919364508716e-08 0 5.008630096156474e-08 0 5.0096300961564736e-08 0.00021 5.0106300961564734e-08 0 5.035077023991867e-08 0 5.036077023991867e-08 0.00021 5.037077023991867e-08 0 5.109659272892389e-08 0 5.110659272892389e-08 0.00021 5.111659272892389e-08 0 5.120265478490252e-08 0 5.121265478490252e-08 0.00021 5.1222654784902515e-08 0 5.284960217857285e-08 0 5.2859602178572846e-08 0.00021 5.2869602178572844e-08 0 5.512884034615215e-08 0 5.513884034615215e-08 0.00021 5.5148840346152145e-08 0 5.568094282069005e-08 0 5.569094282069005e-08 0.00021 5.570094282069005e-08 0 5.8843673773400524e-08 0 5.885367377340052e-08 0.00021 5.886367377340052e-08 0 5.895137640484927e-08 0 5.8961376404849266e-08 0.00021 5.8971376404849264e-08 0 5.9230919195574786e-08 0 5.9240919195574784e-08 0.00021 5.925091919557478e-08 0 5.9528167878607205e-08 0 5.95381678786072e-08 0.00021 5.95481678786072e-08 0 6.029172481553576e-08 0 6.030172481553576e-08 0.00021 6.031172481553576e-08 0 6.12274700760351e-08 0 6.12374700760351e-08 0.00021 6.12474700760351e-08 0 6.176341288681853e-08 0 6.177341288681853e-08 0.00021 6.178341288681853e-08 0 6.188796692092078e-08 0 6.189796692092078e-08 0.00021 6.190796692092078e-08 0 6.388595827749053e-08 0 6.389595827749053e-08 0.00021 6.390595827749053e-08 0 6.438342219294889e-08 0 6.439342219294889e-08 0.00021 6.440342219294888e-08 0 6.449699210760943e-08 0 6.450699210760943e-08 0.00021 6.451699210760943e-08 0 6.526822853514719e-08 0 6.527822853514719e-08 0.00021 6.528822853514719e-08 0 6.556472817772882e-08 0 6.557472817772882e-08 0.00021 6.558472817772881e-08 0 6.598065030284667e-08 0 6.599065030284666e-08 0.00021 6.600065030284666e-08 0 6.62325211788612e-08 0 6.62425211788612e-08 0.00021 6.62525211788612e-08 0 6.674768758786636e-08 0 6.675768758786635e-08 0.00021 6.676768758786635e-08 0 6.774539224721535e-08 0 6.775539224721535e-08 0.00021 6.776539224721534e-08 0 6.784221741644163e-08 0 6.785221741644163e-08 0.00021 6.786221741644163e-08 0 6.902474684710386e-08 0 6.903474684710386e-08 0.00021 6.904474684710386e-08 0 7.190484960985245e-08 0 7.191484960985245e-08 0.00021 7.192484960985244e-08 0 7.276959298957967e-08 0 7.277959298957967e-08 0.00021 7.278959298957967e-08 0 7.646712067583677e-08 0 7.647712067583676e-08 0.00021 7.648712067583676e-08 0 7.697401784230865e-08 0 7.698401784230865e-08 0.00021 7.699401784230865e-08 0 7.825986561981289e-08 0 7.826986561981289e-08 0.00021 7.827986561981289e-08 0 8.027868974753474e-08 0 8.028868974753474e-08 0.00021 8.029868974753473e-08 0 8.112468146048189e-08 0 8.113468146048189e-08 0.00021 8.114468146048189e-08 0 8.186874622174683e-08 0 8.187874622174683e-08 0.00021 8.188874622174682e-08 0 8.246946863539442e-08 0 8.247946863539442e-08 0.00021 8.248946863539442e-08 0 8.254214583146155e-08 0 8.255214583146155e-08 0.00021 8.256214583146155e-08 0 8.699472991542627e-08 0 8.700472991542627e-08 0.00021 8.701472991542626e-08 0 8.866505015088902e-08 0 8.867505015088902e-08 0.00021 8.868505015088902e-08 0 8.91869822937137e-08 0 8.919698229371369e-08 0.00021 8.920698229371369e-08 0 9.094201468264473e-08 0 9.095201468264473e-08 0.00021 9.096201468264473e-08 0 9.195692511932562e-08 0 9.196692511932562e-08 0.00021 9.197692511932562e-08 0 9.197692511932562e-08 0 9.198692511932562e-08 0.00021 9.199692511932561e-08 0 9.333929821912134e-08 0 9.334929821912134e-08 0.00021 9.335929821912134e-08 0 9.475297135582801e-08 0 9.4762971355828e-08 0.00021 9.4772971355828e-08 0 9.525811756539421e-08 0 9.52681175653942e-08 0.00021 9.52781175653942e-08 0 9.52781175653942e-08 0 9.52881175653942e-08 0.00021 9.52981175653942e-08 0 9.800406095409949e-08 0 9.801406095409949e-08 0.00021 9.802406095409948e-08 0 1.0009134506599038e-07 0 1.0010134506599038e-07 0.00021 1.0011134506599037e-07 0 1.0389587845295402e-07 0 1.0390587845295402e-07 0.00021 1.0391587845295401e-07 0 1.0394167291838885e-07 0 1.0395167291838885e-07 0.00021 1.0396167291838885e-07 0 1.0683167191300012e-07 0 1.0684167191300012e-07 0.00021 1.0685167191300012e-07 0 1.0947596213425331e-07 0 1.094859621342533e-07 0.00021 1.094959621342533e-07 0 1.1266135944953272e-07 0 1.1267135944953272e-07 0.00021 1.1268135944953271e-07 0 1.1484997817489126e-07 0 1.1485997817489126e-07 0.00021 1.1486997817489126e-07 0 1.1519597164737891e-07 0 1.1520597164737891e-07 0.00021 1.1521597164737891e-07 0 1.1753788495616977e-07 0 1.1754788495616977e-07 0.00021 1.1755788495616977e-07 0 1.1805423120924228e-07 0 1.1806423120924228e-07 0.00021 1.1807423120924228e-07 0 1.1866352099764441e-07 0 1.186735209976444e-07 0.00021 1.186835209976444e-07 0 1.201011684007608e-07 0 1.201111684007608e-07 0.00021 1.2012116840076082e-07 0 1.209394996980026e-07 0 1.209494996980026e-07 0.00021 1.209594996980026e-07 0 1.2180397048888528e-07 0 1.218139704888853e-07 0.00021 1.218239704888853e-07 0 1.219078684770303e-07 0 1.219178684770303e-07 0.00021 1.2192786847703032e-07 0 1.226188560231865e-07 0 1.226288560231865e-07 0.00021 1.2263885602318652e-07 0 1.2639366641868642e-07 0 1.2640366641868643e-07 0.00021 1.2641366641868644e-07 0 1.264834159474255e-07 0 1.264934159474255e-07 0.00021 1.2650341594742552e-07 0 1.2803592079524524e-07 0 1.2804592079524526e-07 0.00021 1.2805592079524527e-07 0 1.2805592079524524e-07 0 1.2806592079524525e-07 0.00021 1.2807592079524526e-07 0 1.2976160639850578e-07 0 1.297716063985058e-07 0.00021 1.297816063985058e-07 0 1.303752695501023e-07 0 1.303852695501023e-07 0.00021 1.303952695501023e-07 0 1.3142689838603717e-07 0 1.3143689838603719e-07 0.00021 1.314468983860372e-07 0 1.3158160274114605e-07 0 1.3159160274114606e-07 0.00021 1.3160160274114607e-07 0 1.325793415938943e-07 0 1.325893415938943e-07 0.00021 1.3259934159389432e-07 0 1.3277749946825337e-07 0 1.3278749946825339e-07 0.00021 1.327974994682534e-07 0 1.3338783407200205e-07 0 1.3339783407200206e-07 0.00021 1.3340783407200207e-07 0 1.3427690905860377e-07 0 1.3428690905860378e-07 0.00021 1.342969090586038e-07 0 1.3473240743772157e-07 0 1.3474240743772158e-07 0.00021 1.347524074377216e-07 0 1.3491757214683464e-07 0 1.3492757214683466e-07 0.00021 1.3493757214683467e-07 0 1.355586249120745e-07 0 1.3556862491207452e-07 0.00021 1.3557862491207453e-07 0 1.3586385964756592e-07 0 1.3587385964756593e-07 0.00021 1.3588385964756595e-07 0 1.3595791588616017e-07 0 1.3596791588616018e-07 0.00021 1.359779158861602e-07 0 1.3846556235010687e-07 0 1.3847556235010688e-07 0.00021 1.384855623501069e-07 0 1.400416236440301e-07 0 1.4005162364403012e-07 0.00021 1.4006162364403013e-07 0 1.408281354875143e-07 0 1.408381354875143e-07 0.00021 1.4084813548751432e-07 0 1.428887576129631e-07 0 1.428987576129631e-07 0.00021 1.429087576129631e-07 0 1.4337910393653384e-07 0 1.4338910393653385e-07 0.00021 1.4339910393653387e-07 0 1.4366540421831104e-07 0 1.4367540421831105e-07 0.00021 1.4368540421831106e-07 0 1.4409731998523817e-07 0 1.4410731998523818e-07 0.00021 1.441173199852382e-07 0 1.4692501834886194e-07 0 1.4693501834886195e-07 0.00021 1.4694501834886196e-07 0 1.4736317346284703e-07 0 1.4737317346284704e-07 0.00021 1.4738317346284705e-07 0 1.491659438386626e-07 0 1.491759438386626e-07 0.00021 1.4918594383866262e-07 0 1.5028298491549766e-07 0 1.5029298491549767e-07 0.00021 1.5030298491549768e-07 0 1.5059867381019817e-07 0 1.5060867381019818e-07 0.00021 1.506186738101982e-07 0 1.5115650067671487e-07 0 1.5116650067671488e-07 0.00021 1.511765006767149e-07 0 1.514844653083634e-07 0 1.5149446530836342e-07 0.00021 1.5150446530836343e-07 0 1.517743075100446e-07 0 1.517843075100446e-07 0.00021 1.517943075100446e-07 0 1.5304869256092928e-07 0 1.530586925609293e-07 0.00021 1.530686925609293e-07 0 1.547098345922072e-07 0 1.5471983459220722e-07 0.00021 1.5472983459220723e-07 0 1.547298345922072e-07 0 1.5473983459220722e-07 0.00021 1.5474983459220723e-07 0 1.5695081620803477e-07 0 1.5696081620803478e-07 0.00021 1.569708162080348e-07 0 1.5788097027147158e-07 0 1.578909702714716e-07 0.00021 1.579009702714716e-07 0 1.6009453379174142e-07 0 1.6010453379174143e-07 0.00021 1.6011453379174144e-07 0 1.6013637593369692e-07 0 1.6014637593369693e-07 0.00021 1.6015637593369694e-07 0 1.6151598428860408e-07 0 1.615259842886041e-07 0.00021 1.615359842886041e-07 0 1.6160667974851576e-07 0 1.6161667974851577e-07 0.00021 1.6162667974851578e-07 0 1.6253304302582507e-07 0 1.6254304302582508e-07 0.00021 1.625530430258251e-07 0 1.6491474080543492e-07 0 1.6492474080543493e-07 0.00021 1.6493474080543494e-07 0 1.6592019607321516e-07 0 1.6593019607321517e-07 0.00021 1.6594019607321518e-07 0 1.695307361972255e-07 0 1.695407361972255e-07 0.00021 1.695507361972255e-07 0 1.6980448307333435e-07 0 1.6981448307333436e-07 0.00021 1.6982448307333437e-07 0 1.7374764471703336e-07 0 1.7375764471703337e-07 0.00021 1.7376764471703338e-07 0 1.7391013720909704e-07 0 1.7392013720909705e-07 0.00021 1.7393013720909706e-07 0 1.7614988429018047e-07 0 1.7615988429018048e-07 0.00021 1.761698842901805e-07 0 1.7685705062088532e-07 0 1.7686705062088533e-07 0.00021 1.7687705062088534e-07 0 1.7765537733165517e-07 0 1.7766537733165518e-07 0.00021 1.776753773316552e-07 0 1.7834699016486318e-07 0 1.783569901648632e-07 0.00021 1.783669901648632e-07 0 1.7898343666692402e-07 0 1.7899343666692403e-07 0.00021 1.7900343666692404e-07 0 1.8182024708518205e-07 0 1.8183024708518206e-07 0.00021 1.8184024708518207e-07 0 1.8302114832054325e-07 0 1.8303114832054326e-07 0.00021 1.8304114832054327e-07 0 1.8353900758935598e-07 0 1.83549007589356e-07 0.00021 1.83559007589356e-07 0 1.8383280099300226e-07 0 1.8384280099300227e-07 0.00021 1.8385280099300228e-07 0 1.8393044575542398e-07 0 1.83940445755424e-07 0.00021 1.83950445755424e-07 0 1.8647898792633942e-07 0 1.8648898792633943e-07 0.00021 1.8649898792633944e-07 0 1.890980218835486e-07 0 1.8910802188354862e-07 0.00021 1.8911802188354863e-07 0 1.8978240005794449e-07 0 1.897924000579445e-07 0.00021 1.898024000579445e-07 0 1.907440009210097e-07 0 1.9075400092100972e-07 0.00021 1.9076400092100973e-07 0 1.926989495392079e-07 0 1.9270894953920792e-07 0.00021 1.9271894953920793e-07 0 1.944637946907495e-07 0 1.944737946907495e-07 0.00021 1.9448379469074952e-07 0 1.9536414296457122e-07 0 1.9537414296457123e-07 0.00021 1.9538414296457125e-07 0 1.9574971177071528e-07 0 1.957597117707153e-07 0.00021 1.957697117707153e-07 0 1.9644729702940054e-07 0 1.9645729702940056e-07 0.00021 1.9646729702940057e-07 0 1.9889248372520304e-07 0 1.9890248372520306e-07 0.00021 1.9891248372520307e-07 0 2.0056546227992753e-07 0 2.0057546227992754e-07 0.00021 2.0058546227992756e-07 0 2.007617629481266e-07 0 2.0077176294812662e-07 0.00021 2.0078176294812664e-07 0 2.0131871743469965e-07 0 2.0132871743469966e-07 0.00021 2.0133871743469967e-07 0 2.0539685601084605e-07 0 2.0540685601084606e-07 0.00021 2.0541685601084607e-07 0 2.059721165692491e-07 0 2.0598211656924912e-07 0.00021 2.0599211656924913e-07 0 2.0722051010000875e-07 0 2.0723051010000876e-07 0.00021 2.0724051010000878e-07 0 2.0789148720561024e-07 0 2.0790148720561026e-07 0.00021 2.0791148720561027e-07 0 2.0849254769975097e-07 0 2.0850254769975099e-07 0.00021 2.08512547699751e-07 0 2.0897296403937674e-07 0 2.0898296403937675e-07 0.00021 2.0899296403937676e-07 0 2.095902693091763e-07 0 2.096002693091763e-07 0.00021 2.0961026930917632e-07 0 2.119063137695519e-07 0 2.119163137695519e-07 0.00021 2.1192631376955192e-07 0 2.1302833056222198e-07 0 2.13038330562222e-07 0.00021 2.13048330562222e-07 0 2.1305315484158144e-07 0 2.1306315484158145e-07 0.00021 2.1307315484158146e-07 0 2.1419456529261902e-07 0 2.1420456529261903e-07 0.00021 2.1421456529261905e-07 0 2.1536534132005504e-07 0 2.1537534132005505e-07 0.00021 2.1538534132005506e-07 0 2.1626448073995597e-07 0 2.1627448073995598e-07 0.00021 2.16284480739956e-07 0 2.1751861177923844e-07 0 2.1752861177923845e-07 0.00021 2.1753861177923846e-07 0 2.18235928061955e-07 0 2.1824592806195502e-07 0.00021 2.1825592806195503e-07 0 2.1950007085769608e-07 0 2.195100708576961e-07 0.00021 2.195200708576961e-07 0 2.1994020071676387e-07 0 2.1995020071676388e-07 0.00021 2.199602007167639e-07 0 2.2032452846570633e-07 0 2.2033452846570634e-07 0.00021 2.2034452846570635e-07 0 2.2183371018958168e-07 0 2.218437101895817e-07 0.00021 2.218537101895817e-07 0 2.2352719076015247e-07 0 2.2353719076015249e-07 0.00021 2.235471907601525e-07 0 2.2374379743489398e-07 0 2.23753797434894e-07 0.00021 2.23763797434894e-07 0 2.248800150878361e-07 0 2.2489001508783612e-07 0.00021 2.2490001508783614e-07 0 2.2582757429458458e-07 0 2.258375742945846e-07 0.00021 2.258475742945846e-07 0 2.2653198077245197e-07 0 2.2654198077245199e-07 0.00021 2.26551980772452e-07 0 2.2772659772177576e-07 0 2.2773659772177577e-07 0.00021 2.2774659772177578e-07 0 2.2813405856632532e-07 0 2.2814405856632534e-07 0.00021 2.2815405856632535e-07 0 2.2908253849887528e-07 0 2.290925384988753e-07 0.00021 2.291025384988753e-07 0 2.293710045252055e-07 0 2.293810045252055e-07 0.00021 2.293910045252055e-07 0 2.2943624507970147e-07 0 2.2944624507970148e-07 0.00021 2.294562450797015e-07 0 2.3051980260614247e-07 0 2.3052980260614248e-07 0.00021 2.305398026061425e-07 0 2.3083401747475736e-07 0 2.3084401747475737e-07 0.00021 2.3085401747475738e-07 0 2.3191631827034217e-07 0 2.3192631827034218e-07 0.00021 2.319363182703422e-07 0 2.3534778913810306e-07 0 2.3535778913810307e-07 0.00021 2.3536778913810308e-07 0 2.3710635044579223e-07 0 2.3711635044579224e-07 0.00021 2.3712635044579225e-07 0 2.3727140832276387e-07 0 2.3728140832276388e-07 0.00021 2.372914083227639e-07 0 2.3737081953617116e-07 0 2.3738081953617117e-07 0.00021 2.3739081953617118e-07 0 2.3753794074524882e-07 0 2.3754794074524883e-07 0.00021 2.3755794074524885e-07 0 2.3935948526882987e-07 0 2.393694852688299e-07 0.00021 2.393794852688299e-07 0 2.407689229688701e-07 0 2.4077892296887014e-07 0.00021 2.4078892296887015e-07 0 2.4154958791670895e-07 0 2.4155958791670896e-07 0.00021 2.4156958791670897e-07 0 2.416926679410866e-07 0 2.417026679410866e-07 0.00021 2.4171266794108664e-07 0 2.419820660565896e-07 0 2.419920660565896e-07 0.00021 2.4200206605658964e-07 0 2.4218998740844133e-07 0 2.4219998740844134e-07 0.00021 2.4220998740844135e-07 0 2.425336277947305e-07 0 2.425436277947305e-07 0.00021 2.425536277947305e-07 0 2.43039843071683e-07 0 2.4304984307168303e-07 0.00021 2.4305984307168304e-07 0 2.4386857810316163e-07 0 2.4387857810316164e-07 0.00021 2.4388857810316165e-07 0 2.444735963864237e-07 0 2.4448359638642373e-07 0.00021 2.4449359638642375e-07 0 2.4486343471557804e-07 0 2.4487343471557805e-07 0.00021 2.4488343471557806e-07 0 2.456651648912621e-07 0 2.456751648912621e-07 0.00021 2.456851648912621e-07 0 2.461830326663305e-07 0 2.4619303266633053e-07 0.00021 2.4620303266633055e-07 0 2.472032349502763e-07 0 2.472132349502763e-07 0.00021 2.472232349502763e-07 0 2.4776709219454223e-07 0 2.4777709219454224e-07 0.00021 2.4778709219454225e-07 0 2.5006452143910854e-07 0 2.5007452143910855e-07 0.00021 2.5008452143910857e-07 0 2.502324295999543e-07 0 2.502424295999543e-07 0.00021 2.502524295999543e-07 0 2.517932587696283e-07 0 2.518032587696283e-07 0.00021 2.518132587696283e-07 0 2.565043683639393e-07 0 2.5651436836393933e-07 0.00021 2.5652436836393934e-07 0 2.5730223226362286e-07 0 2.573122322636229e-07 0.00021 2.573222322636229e-07 0 2.5938870643492374e-07 0 2.5939870643492376e-07 0.00021 2.5940870643492377e-07 0 2.612445045776056e-07 0 2.612545045776056e-07 0.00021 2.612645045776056e-07 0 2.6408408993326575e-07 0 2.6409408993326576e-07 0.00021 2.6410408993326577e-07 0 2.659857324743446e-07 0 2.659957324743446e-07 0.00021 2.660057324743446e-07 0 2.66028406597631e-07 0 2.6603840659763104e-07 0.00021 2.6604840659763105e-07 0 2.677536432091508e-07 0 2.677636432091508e-07 0.00021 2.677736432091508e-07 0 2.685541141580712e-07 0 2.6856411415807124e-07 0.00021 2.6857411415807125e-07 0 2.6925171819722754e-07 0 2.6926171819722755e-07 0.00021 2.6927171819722756e-07 0 2.7130555724596173e-07 0 2.7131555724596174e-07 0.00021 2.7132555724596176e-07 0 2.7337745341582933e-07 0 2.7338745341582935e-07 0.00021 2.7339745341582936e-07 0 2.736447026008455e-07 0 2.736547026008455e-07 0.00021 2.736647026008455e-07 0 2.7417181696059513e-07 0 2.7418181696059514e-07 0.00021 2.7419181696059515e-07 0 2.769282059457115e-07 0 2.7693820594571154e-07 0.00021 2.7694820594571155e-07 0 2.779020852293439e-07 0 2.7791208522934394e-07 0.00021 2.7792208522934395e-07 0 2.781274804727846e-07 0 2.781374804727846e-07 0.00021 2.781474804727846e-07 0 2.850559450264362e-07 0 2.850659450264362e-07 0.00021 2.8507594502643623e-07 0 2.85208425587032e-07 0 2.85218425587032e-07 0.00021 2.85228425587032e-07 0 2.856658078280284e-07 0 2.856758078280284e-07 0.00021 2.8568580782802844e-07 0 2.860265266640539e-07 0 2.860365266640539e-07 0.00021 2.860465266640539e-07 0 2.8680125364885963e-07 0 2.8681125364885964e-07 0.00021 2.8682125364885965e-07 0 2.8725488497863425e-07 0 2.8726488497863426e-07 0.00021 2.8727488497863427e-07 0 2.878372042045353e-07 0 2.878472042045353e-07 0.00021 2.8785720420453533e-07 0 2.8785720420453533e-07 0 2.8786720420453534e-07 0.00021 2.8787720420453535e-07 0 2.879398987344334e-07 0 2.879498987344334e-07 0.00021 2.879598987344334e-07 0 2.9112125394280873e-07 0 2.9113125394280874e-07 0.00021 2.9114125394280875e-07 0 2.9132974762678007e-07 0 2.913397476267801e-07 0.00021 2.913497476267801e-07 0 2.9313474989326173e-07 0 2.9314474989326174e-07 0.00021 2.9315474989326175e-07 0 2.9669377498564287e-07 0 2.967037749856429e-07 0.00021 2.967137749856429e-07 0 2.979549157839136e-07 0 2.9796491578391363e-07 0.00021 2.9797491578391364e-07 0 3.0048407922852025e-07 0 3.0049407922852026e-07 0.00021 3.005040792285203e-07 0 3.015468691995361e-07 0 3.015568691995361e-07 0.00021 3.015668691995361e-07 0 3.030055843490482e-07 0 3.030155843490482e-07 0.00021 3.030255843490482e-07 0 3.052190212042465e-07 0 3.052290212042465e-07 0.00021 3.0523902120424653e-07 0 3.071000174363338e-07 0 3.071100174363338e-07 0.00021 3.071200174363338e-07 0 3.0845540505023763e-07 0 3.0846540505023765e-07 0.00021 3.0847540505023766e-07 0 3.0993652253650804e-07 0 3.0994652253650805e-07 0.00021 3.0995652253650806e-07 0 3.110765562808823e-07 0 3.1108655628088233e-07 0.00021 3.1109655628088235e-07 0 3.137356187556843e-07 0 3.137456187556843e-07 0.00021 3.137556187556843e-07 0 3.1442453597303716e-07 0 3.144345359730372e-07 0.00021 3.144445359730372e-07 0 3.1462343556578557e-07 0 3.146334355657856e-07 0.00021 3.146434355657856e-07 0 3.157574642068975e-07 0 3.157674642068975e-07 0.00021 3.1577746420689754e-07 0 3.1794063564390616e-07 0 3.179506356439062e-07 0.00021 3.179606356439062e-07 0 3.180622174017109e-07 0 3.180722174017109e-07 0.00021 3.1808221740171093e-07 0 3.1873576041630354e-07 0 3.1874576041630356e-07 0.00021 3.1875576041630357e-07 0 3.190921462904973e-07 0 3.191021462904973e-07 0.00021 3.191121462904973e-07 0 3.197626012272499e-07 0 3.197726012272499e-07 0.00021 3.197826012272499e-07 0 3.200909354671324e-07 0 3.201009354671324e-07 0.00021 3.201109354671324e-07 0 3.2145709869806005e-07 0 3.2146709869806006e-07 0.00021 3.214770986980601e-07 0 3.228714878023408e-07 0 3.228814878023408e-07 0.00021 3.2289148780234084e-07 0 3.230498826992058e-07 0 3.230598826992058e-07 0.00021 3.2306988269920583e-07 0 3.2475449010369396e-07 0 3.2476449010369397e-07 0.00021 3.24774490103694e-07 0 3.2604970689732074e-07 0 3.2605970689732075e-07 0.00021 3.2606970689732076e-07 0 3.2802207762443905e-07 0 3.2803207762443906e-07 0.00021 3.280420776244391e-07 0 3.312226045204065e-07 0 3.312326045204065e-07 0.00021 3.312426045204065e-07 0 3.315698482853284e-07 0 3.3157984828532843e-07 0.00021 3.3158984828532845e-07 0 3.3163957694093096e-07 0 3.31649576940931e-07 0.00021 3.31659576940931e-07 0 3.3223130832182375e-07 0 3.3224130832182376e-07 0.00021 3.3225130832182377e-07 0 3.339673436197919e-07 0 3.3397734361979193e-07 0.00021 3.3398734361979194e-07 0 3.349558387716958e-07 0 3.349658387716958e-07 0.00021 3.349758387716958e-07 0 3.367951624822747e-07 0 3.368051624822747e-07 0.00021 3.368151624822747e-07 0 3.3700144864853805e-07 0 3.3701144864853807e-07 0.00021 3.370214486485381e-07 0 3.4513020295519843e-07 0 3.4514020295519844e-07 0.00021 3.4515020295519845e-07 0 3.451798894645128e-07 0 3.451898894645128e-07 0.00021 3.4519988946451283e-07 0 3.459546115254856e-07 0 3.459646115254856e-07 0.00021 3.459746115254856e-07 0 3.469892494651749e-07 0 3.4699924946517493e-07 0.00021 3.4700924946517494e-07 0 3.4755829564028706e-07 0 3.4756829564028707e-07 0.00021 3.475782956402871e-07 0 3.488376981867025e-07 0 3.488476981867025e-07 0.00021 3.488576981867025e-07 0 3.492873138237428e-07 0 3.492973138237428e-07 0.00021 3.493073138237428e-07 0 3.497018019892401e-07 0 3.497118019892401e-07 0.00021 3.497218019892401e-07 0 3.51277128541241e-07 0 3.51287128541241e-07 0.00021 3.51297128541241e-07 0 3.527134951818813e-07 0 3.527234951818813e-07 0.00021 3.527334951818813e-07 0 3.5322031181023926e-07 0 3.532303118102393e-07 0.00021 3.532403118102393e-07 0 3.5339105119488737e-07 0 3.534010511948874e-07 0.00021 3.534110511948874e-07 0 3.54300688793913e-07 0 3.5431068879391303e-07 0.00021 3.5432068879391304e-07 0 3.550685212932968e-07 0 3.550785212932968e-07 0.00021 3.550885212932968e-07 0 3.556184201346119e-07 0 3.556284201346119e-07 0.00021 3.556384201346119e-07 0 3.5628825658894306e-07 0 3.562982565889431e-07 0.00021 3.563082565889431e-07 0 3.565085461937499e-07 0 3.5651854619374993e-07 0.00021 3.5652854619374994e-07 0 3.570075046833531e-07 0 3.570175046833531e-07 0.00021 3.570275046833531e-07 0 3.590706469881986e-07 0 3.5908064698819864e-07 0.00021 3.5909064698819865e-07 0 3.5909064698819865e-07 0 3.5910064698819866e-07 0.00021 3.5911064698819867e-07 0 3.5919896596864527e-07 0 3.592089659686453e-07 0.00021 3.592189659686453e-07 0 3.593868439652468e-07 0 3.593968439652468e-07 0.00021 3.594068439652468e-07 0 3.6045341489658615e-07 0 3.6046341489658616e-07 0.00021 3.6047341489658617e-07 0 3.613975375575079e-07 0 3.614075375575079e-07 0.00021 3.614175375575079e-07 0 3.6195073896974405e-07 0 3.6196073896974406e-07 0.00021 3.619707389697441e-07 0 3.621407616084656e-07 0 3.621507616084656e-07 0.00021 3.621607616084656e-07 0 3.621607616084656e-07 0 3.621707616084656e-07 0.00021 3.6218076160846563e-07 0 3.633601965463313e-07 0 3.633701965463313e-07 0.00021 3.633801965463313e-07 0 3.6378687004425406e-07 0 3.6379687004425407e-07 0.00021 3.638068700442541e-07 0 3.65055471630763e-07 0 3.65065471630763e-07 0.00021 3.65075471630763e-07 0 3.675180713424342e-07 0 3.675280713424342e-07 0.00021 3.675380713424342e-07 0 3.6755370597592423e-07 0 3.6756370597592424e-07 0.00021 3.6757370597592425e-07 0 3.6792638831391386e-07 0 3.679363883139139e-07 0.00021 3.679463883139139e-07 0 3.7064620794357136e-07 0 3.706562079435714e-07 0.00021 3.706662079435714e-07 0 3.707986076339846e-07 0 3.708086076339846e-07 0.00021 3.7081860763398464e-07 0 3.726633055572702e-07 0 3.726733055572702e-07 0.00021 3.726833055572702e-07 0 3.751875437934598e-07 0 3.751975437934598e-07 0.00021 3.752075437934598e-07 0 3.7539811404287286e-07 0 3.754081140428729e-07 0.00021 3.754181140428729e-07 0 3.784549873501555e-07 0 3.7846498735015553e-07 0.00021 3.7847498735015554e-07 0 3.788694362550302e-07 0 3.788794362550302e-07 0.00021 3.7888943625503023e-07 0 3.791577922620349e-07 0 3.791677922620349e-07 0.00021 3.791777922620349e-07 0 3.7920071320140204e-07 0 3.7921071320140205e-07 0.00021 3.7922071320140206e-07 0 3.800887705266648e-07 0 3.800987705266648e-07 0.00021 3.8010877052666483e-07 0 3.812462276439575e-07 0 3.812562276439575e-07 0.00021 3.8126622764395754e-07 0 3.8306535470068115e-07 0 3.8307535470068116e-07 0.00021 3.8308535470068117e-07 0 3.8387442657722084e-07 0 3.8388442657722085e-07 0.00021 3.8389442657722087e-07 0 3.849573786350134e-07 0 3.849673786350134e-07 0.00021 3.849773786350134e-07 0 3.8629666247665824e-07 0 3.8630666247665825e-07 0.00021 3.8631666247665826e-07 0 3.8721899489215704e-07 0 3.8722899489215705e-07 0.00021 3.8723899489215706e-07 0 3.8738940795153045e-07 0 3.8739940795153046e-07 0.00021 3.8740940795153047e-07 0 3.8743437885200706e-07 0 3.874443788520071e-07 0.00021 3.874543788520071e-07 0 3.874543788520071e-07 0 3.874643788520071e-07 0.00021 3.874743788520071e-07 0 3.8916431045005983e-07 0 3.8917431045005984e-07 0.00021 3.8918431045005985e-07 0 3.8925162621917056e-07 0 3.8926162621917057e-07 0.00021 3.892716262191706e-07 0 3.9072709336222045e-07 0 3.9073709336222046e-07 0.00021 3.907470933622205e-07 0 3.907845311148958e-07 0 3.9079453111489583e-07 0.00021 3.9080453111489584e-07 0 3.909593167680887e-07 0 3.909693167680887e-07 0.00021 3.909793167680887e-07 0 3.9159896814956225e-07 0 3.9160896814956226e-07 0.00021 3.9161896814956227e-07 0 3.924876825325274e-07 0 3.924976825325274e-07 0.00021 3.925076825325274e-07 0 3.9350796434000184e-07 0 3.9351796434000185e-07 0.00021 3.9352796434000186e-07 0 3.9414693555828875e-07 0 3.9415693555828876e-07 0.00021 3.9416693555828877e-07 0 3.968572986031864e-07 0 3.9686729860318643e-07 0.00021 3.9687729860318644e-07 0 3.971908688161828e-07 0 3.972008688161828e-07 0.00021 3.972108688161828e-07 0 3.981869193243574e-07 0 3.981969193243574e-07 0.00021 3.982069193243574e-07 0 3.9846472741454007e-07 0 3.984747274145401e-07 0.00021 3.984847274145401e-07 0 3.9904138852511073e-07 0 3.9905138852511074e-07 0.00021 3.9906138852511075e-07 0 3.9906258622348423e-07 0 3.9907258622348424e-07 0.00021 3.9908258622348425e-07 0 3.991686843406582e-07 0 3.991786843406582e-07 0.00021 3.9918868434065824e-07 0 4.0153686957963053e-07 0 4.0154686957963054e-07 0.00021 4.0155686957963055e-07 0 4.017904914344307e-07 0 4.018004914344307e-07 0.00021 4.018104914344307e-07 0 4.0425782007489034e-07 0 4.0426782007489035e-07 0.00021 4.0427782007489036e-07 0 4.0573677639794993e-07 0 4.0574677639794994e-07 0.00021 4.0575677639794996e-07 0 4.0618811240818236e-07 0 4.061981124081824e-07 0.00021 4.062081124081824e-07 0 4.067114278689894e-07 0 4.0672142786898944e-07 0.00021 4.0673142786898945e-07 0 4.0797724086881427e-07 0 4.079872408688143e-07 0.00021 4.079972408688143e-07 0 4.0861655665867814e-07 0 4.0862655665867815e-07 0.00021 4.0863655665867816e-07 0 4.1051856053339143e-07 0 4.1052856053339145e-07 0.00021 4.1053856053339146e-07 0 4.1300854730127605e-07 0 4.1301854730127607e-07 0.00021 4.130285473012761e-07 0 4.1353817884860985e-07 0 4.1354817884860986e-07 0.00021 4.1355817884860987e-07 0 4.1425771735916186e-07 0 4.1426771735916187e-07 0.00021 4.142777173591619e-07 0 4.162426546644969e-07 0 4.162526546644969e-07 0.00021 4.162626546644969e-07 0 4.1701879179907163e-07 0 4.1702879179907164e-07 0.00021 4.1703879179907165e-07 0 4.1803834943353533e-07 0 4.1804834943353535e-07 0.00021 4.1805834943353536e-07 0 4.182733109568072e-07 0 4.182833109568072e-07 0.00021 4.182933109568072e-07 0 4.196729693280082e-07 0 4.196829693280082e-07 0.00021 4.196929693280082e-07 0 4.2242683751925896e-07 0 4.2243683751925897e-07 0.00021 4.22446837519259e-07 0 4.225471858777105e-07 0 4.225571858777105e-07 0.00021 4.2256718587771053e-07 0 4.2632526325038696e-07 0 4.26335263250387e-07 0.00021 4.26345263250387e-07 0 4.264173185340453e-07 0 4.264273185340453e-07 0.00021 4.2643731853404534e-07 0 4.2643731853404534e-07 0 4.2644731853404535e-07 0.00021 4.2645731853404536e-07 0 4.275739205709493e-07 0 4.2758392057094933e-07 0.00021 4.2759392057094935e-07 0 4.315648469105334e-07 0 4.315748469105334e-07 0.00021 4.315848469105334e-07 0 4.32371688821095e-07 0 4.32381688821095e-07 0.00021 4.32391688821095e-07 0 4.3303394013226415e-07 0 4.3304394013226416e-07 0.00021 4.3305394013226417e-07 0 4.331307673959151e-07 0 4.331407673959151e-07 0.00021 4.331507673959151e-07 0 4.3396925563488223e-07 0 4.3397925563488224e-07 0.00021 4.3398925563488225e-07 0 4.3649877369164133e-07 0 4.3650877369164134e-07 0.00021 4.3651877369164135e-07 0 4.3727153739151235e-07 0 4.3728153739151237e-07 0.00021 4.372915373915124e-07 0 4.374936713213958e-07 0 4.375036713213958e-07 0.00021 4.3751367132139583e-07 0 4.415669788609778e-07 0 4.415769788609778e-07 0.00021 4.4158697886097783e-07 0 4.431634807404694e-07 0 4.431734807404694e-07 0.00021 4.431834807404694e-07 0 4.4505516741119085e-07 0 4.4506516741119087e-07 0.00021 4.450751674111909e-07 0 4.4774186976295663e-07 0 4.4775186976295664e-07 0.00021 4.4776186976295665e-07 0 4.4952502833853084e-07 0 4.4953502833853086e-07 0.00021 4.4954502833853087e-07 0 4.5057477651262254e-07 0 4.5058477651262256e-07 0.00021 4.5059477651262257e-07 0 4.5133680387456227e-07 0 4.513468038745623e-07 0.00021 4.513568038745623e-07 0 4.515495381016658e-07 0 4.5155953810166584e-07 0.00021 4.5156953810166585e-07 0 4.5753438656139345e-07 0 4.5754438656139346e-07 0.00021 4.5755438656139347e-07 0 4.576977644312412e-07 0 4.5770776443124123e-07 0.00021 4.5771776443124124e-07 0 4.5893462833200166e-07 0 4.5894462833200167e-07 0.00021 4.589546283320017e-07 0 4.5923424973730435e-07 0 4.5924424973730436e-07 0.00021 4.592542497373044e-07 0 4.6008987377206005e-07 0 4.6009987377206006e-07 0.00021 4.601098737720601e-07 0 4.6124908418509405e-07 0 4.6125908418509406e-07 0.00021 4.612690841850941e-07 0 4.61514032627379e-07 0 4.61524032627379e-07 0.00021 4.6153403262737903e-07 0 4.6268872902543086e-07 0 4.6269872902543087e-07 0.00021 4.627087290254309e-07 0 4.63643512828246e-07 0 4.63653512828246e-07 0.00021 4.63663512828246e-07 0 4.6478962470113934e-07 0 4.6479962470113935e-07 0.00021 4.6480962470113936e-07 0 4.65620176620758e-07 0 4.65630176620758e-07 0.00021 4.6564017662075803e-07 0 4.668566079521195e-07 0 4.6686660795211953e-07 0.00021 4.6687660795211954e-07 0 4.6725736480839785e-07 0 4.6726736480839786e-07 0.00021 4.672773648083979e-07 0 4.7010860641720205e-07 0 4.7011860641720206e-07 0.00021 4.7012860641720207e-07 0 4.707977970545275e-07 0 4.708077970545275e-07 0.00021 4.708177970545275e-07 0 4.7117250663530254e-07 0 4.7118250663530256e-07 0.00021 4.7119250663530257e-07 0 4.7141711715800716e-07 0 4.7142711715800717e-07 0.00021 4.714371171580072e-07 0 4.719727026010081e-07 0 4.7198270260100813e-07 0.00021 4.7199270260100814e-07 0 4.723785303131776e-07 0 4.723885303131776e-07 0.00021 4.723985303131776e-07 0 4.728465719632227e-07 0 4.728565719632227e-07 0.00021 4.728665719632227e-07 0 4.745948265901252e-07 0 4.746048265901252e-07 0.00021 4.7461482659012523e-07 0 4.766243177597558e-07 0 4.7663431775975583e-07 0.00021 4.7664431775975584e-07 0 4.777543672694652e-07 0 4.777643672694651e-07 0.00021 4.777743672694651e-07 0 4.786883731419148e-07 0 4.786983731419148e-07 0.00021 4.787083731419147e-07 0 4.794184905500471e-07 0 4.79428490550047e-07 0.00021 4.79438490550047e-07 0 4.809105486176305e-07 0 4.809205486176305e-07 0.00021 4.809305486176305e-07 0 4.810794097065684e-07 0 4.810894097065684e-07 0.00021 4.810994097065683e-07 0 4.814767568051773e-07 0 4.814867568051772e-07 0.00021 4.814967568051772e-07 0 4.81643126924069e-07 0 4.81653126924069e-07 0.00021 4.81663126924069e-07 0 4.825622708841467e-07 0 4.825722708841467e-07 0.00021 4.825822708841466e-07 0 4.833587391293588e-07 0 4.833687391293588e-07 0.00021 4.833787391293587e-07 0 4.838081751423143e-07 0 4.838181751423142e-07 0.00021 4.838281751423142e-07 0 4.844784622484099e-07 0 4.844884622484098e-07 0.00021 4.844984622484098e-07 0 4.847934664923255e-07 0 4.848034664923255e-07 0.00021 4.848134664923254e-07 0 4.854378812126383e-07 0 4.854478812126383e-07 0.00021 4.854578812126382e-07 0 4.855285157539212e-07 0 4.855385157539212e-07 0.00021 4.855485157539211e-07 0 4.856015684954276e-07 0 4.856115684954275e-07 0.00021 4.856215684954275e-07 0 4.875652517877694e-07 0 4.875752517877693e-07 0.00021 4.875852517877693e-07 0 4.893221788582382e-07 0 4.893321788582382e-07 0.00021 4.893421788582382e-07 0 4.894077359568227e-07 0 4.894177359568227e-07 0.00021 4.894277359568227e-07 0 4.896257067858277e-07 0 4.896357067858277e-07 0.00021 4.896457067858277e-07 0 4.905071241688221e-07 0 4.905171241688221e-07 0.00021 4.905271241688221e-07 0 4.922735558583491e-07 0 4.922835558583491e-07 0.00021 4.92293555858349e-07 0 4.946235293344569e-07 0 4.946335293344569e-07 0.00021 4.946435293344568e-07 0 4.949110457422516e-07 0 4.949210457422516e-07 0.00021 4.949310457422516e-07 0 4.951226731448942e-07 0 4.951326731448942e-07 0.00021 4.951426731448941e-07 0 4.963619007803629e-07 0 4.963719007803628e-07 0.00021 4.963819007803628e-07 0 4.978836591242253e-07 0 4.978936591242252e-07 0.00021 4.979036591242252e-07 0 4.982145348254781e-07 0 4.982245348254781e-07 0.00021 4.98234534825478e-07 0 4.982851011294611e-07 0 4.98295101129461e-07 0.00021 4.98305101129461e-07 0 4.997319463759376e-07 0 4.997419463759375e-07 0.00021 4.997519463759375e-07 0 4.999656896104611e-07 0 4.999756896104611e-07 0.00021 4.99985689610461e-07 0 )
X46 SYNAPSE 45 44 1046
X1046 JTL 1046 46
VIN48 48 0 pwl(0 0)
VIN50 50 0 pwl(0 0)
VIN52 52 0 pwl(0 0)
X61 LIF_NEURON 39 48 50 52 37 41 43 46 61
IB62 0 62 pwl(0 0 5p 169.10000000000002u)
X63 SYNAPSE 9 62 1063
X1063 JTL 1063 63
IB64 0 64 pwl(0 0 5p 181.10000000000002u)
X65 SYNAPSE 17 64 1065
X1065 JTL 1065 65
IB66 0 66 pwl(0 0 5p 168.3u)
X67 SYNAPSE 25 66 1067
X1067 JTL 1067 67
IB68 0 68 pwl(0 0 5p 166.4u)
X69 SYNAPSE 33 68 1069
X1069 JTL 1069 69
IB70 0 70 pwl(0 0 5p 148.8u)
VIN71 71 0 pwl(0 0 6.699319039689096e-10 0 6.799319039689096e-10 0.00021 6.899319039689096e-10 0 1.6895290054347743e-09 0 1.6995290054347742e-09 0.00021 1.7095290054347742e-09 0 1.7095290054347742e-09 0 1.7195290054347742e-09 0.00021 1.7295290054347741e-09 0 1.7295290054347741e-09 0 1.739529005434774e-09 0.00021 1.749529005434774e-09 0 2.261947867344106e-09 0 2.2719478673441063e-09 0.00021 2.2819478673441065e-09 0 3.891888302002492e-09 0 3.901888302002492e-09 0.00021 3.9118883020024915e-09 0 4.565471254669724e-09 0 4.575471254669723e-09 0.00021 4.585471254669723e-09 0 5.320772612495115e-09 0 5.330772612495115e-09 0.00021 5.340772612495115e-09 0 8.13755859157084e-09 0 8.14755859157084e-09 0.00021 8.15755859157084e-09 0 1.4195311672013414e-08 0 1.4205311672013413e-08 0.00021 1.4215311672013413e-08 0 1.7481739929907154e-08 0 1.7491739929907155e-08 0.00021 1.7501739929907157e-08 0 1.7501739929907153e-08 0 1.7511739929907155e-08 0.00021 1.7521739929907156e-08 0 1.9752122344508886e-08 0 1.9762122344508888e-08 0.00021 1.977212234450889e-08 0 1.982462002942878e-08 0 1.983462002942878e-08 0.00021 1.984462002942878e-08 0 2.0894020331596096e-08 0 2.0904020331596097e-08 0.00021 2.09140203315961e-08 0 2.1742953361140633e-08 0 2.1752953361140634e-08 0.00021 2.1762953361140636e-08 0 2.4892862013879127e-08 0 2.4902862013879128e-08 0.00021 2.491286201387913e-08 0 2.5246872056072377e-08 0 2.5256872056072378e-08 0.00021 2.526687205607238e-08 0 2.5553983195700722e-08 0 2.5563983195700723e-08 0.00021 2.5573983195700725e-08 0 2.7046202608826746e-08 0 2.7056202608826748e-08 0.00021 2.706620260882675e-08 0 2.7083206807612435e-08 0 2.7093206807612437e-08 0.00021 2.7103206807612438e-08 0 2.7218537619829642e-08 0 2.7228537619829643e-08 0.00021 2.7238537619829645e-08 0 2.8248735726482085e-08 0 2.8258735726482087e-08 0.00021 2.8268735726482088e-08 0 2.902328394445528e-08 0 2.9033283944455282e-08 0.00021 2.9043283944455284e-08 0 3.076096245449594e-08 0 3.0770962454495935e-08 0.00021 3.0780962454495933e-08 0 3.117463254033064e-08 0 3.118463254033064e-08 0.00021 3.119463254033064e-08 0 3.162284330367877e-08 0 3.163284330367877e-08 0.00021 3.164284330367877e-08 0 3.3474935656659066e-08 0 3.3484935656659064e-08 0.00021 3.349493565665906e-08 0 3.5200149266782075e-08 0 3.521014926678207e-08 0.00021 3.522014926678207e-08 0 3.552360854033267e-08 0 3.5533608540332667e-08 0.00021 3.5543608540332665e-08 0 3.573436996121096e-08 0 3.574436996121096e-08 0.00021 3.5754369961210956e-08 0 3.695766392097994e-08 0 3.6967663920979935e-08 0.00021 3.697766392097993e-08 0 3.749598812425032e-08 0 3.750598812425032e-08 0.00021 3.7515988124250316e-08 0 3.8350673217967685e-08 0 3.8360673217967683e-08 0.00021 3.837067321796768e-08 0 3.939939542823749e-08 0 3.940939542823749e-08 0.00021 3.9419395428237485e-08 0 4.063156607213525e-08 0 4.0641566072135246e-08 0.00021 4.0651566072135244e-08 0 4.355973538544831e-08 0 4.356973538544831e-08 0.00021 4.357973538544831e-08 0 4.371342414403645e-08 0 4.372342414403645e-08 0.00021 4.3733424144036445e-08 0 4.517922905922227e-08 0 4.5189229059222266e-08 0.00021 4.5199229059222264e-08 0 4.630346658829152e-08 0 4.6313466588291516e-08 0.00021 4.6323466588291514e-08 0 4.820151700662107e-08 0 4.821151700662107e-08 0.00021 4.8221517006621066e-08 0 4.880050898076728e-08 0 4.8810508980767275e-08 0.00021 4.882050898076727e-08 0 4.9269193645087165e-08 0 4.927919364508716e-08 0.00021 4.928919364508716e-08 0 5.008630096156474e-08 0 5.0096300961564736e-08 0.00021 5.0106300961564734e-08 0 5.035077023991867e-08 0 5.036077023991867e-08 0.00021 5.037077023991867e-08 0 5.109659272892389e-08 0 5.110659272892389e-08 0.00021 5.111659272892389e-08 0 5.120265478490252e-08 0 5.121265478490252e-08 0.00021 5.1222654784902515e-08 0 5.284960217857285e-08 0 5.2859602178572846e-08 0.00021 5.2869602178572844e-08 0 5.512884034615215e-08 0 5.513884034615215e-08 0.00021 5.5148840346152145e-08 0 5.568094282069005e-08 0 5.569094282069005e-08 0.00021 5.570094282069005e-08 0 5.8843673773400524e-08 0 5.885367377340052e-08 0.00021 5.886367377340052e-08 0 5.895137640484927e-08 0 5.8961376404849266e-08 0.00021 5.8971376404849264e-08 0 5.9230919195574786e-08 0 5.9240919195574784e-08 0.00021 5.925091919557478e-08 0 5.9528167878607205e-08 0 5.95381678786072e-08 0.00021 5.95481678786072e-08 0 6.029172481553576e-08 0 6.030172481553576e-08 0.00021 6.031172481553576e-08 0 6.12274700760351e-08 0 6.12374700760351e-08 0.00021 6.12474700760351e-08 0 6.176341288681853e-08 0 6.177341288681853e-08 0.00021 6.178341288681853e-08 0 6.188796692092078e-08 0 6.189796692092078e-08 0.00021 6.190796692092078e-08 0 6.388595827749053e-08 0 6.389595827749053e-08 0.00021 6.390595827749053e-08 0 6.438342219294889e-08 0 6.439342219294889e-08 0.00021 6.440342219294888e-08 0 6.449699210760943e-08 0 6.450699210760943e-08 0.00021 6.451699210760943e-08 0 6.526822853514719e-08 0 6.527822853514719e-08 0.00021 6.528822853514719e-08 0 6.556472817772882e-08 0 6.557472817772882e-08 0.00021 6.558472817772881e-08 0 6.598065030284667e-08 0 6.599065030284666e-08 0.00021 6.600065030284666e-08 0 6.62325211788612e-08 0 6.62425211788612e-08 0.00021 6.62525211788612e-08 0 6.674768758786636e-08 0 6.675768758786635e-08 0.00021 6.676768758786635e-08 0 6.774539224721535e-08 0 6.775539224721535e-08 0.00021 6.776539224721534e-08 0 6.784221741644163e-08 0 6.785221741644163e-08 0.00021 6.786221741644163e-08 0 6.902474684710386e-08 0 6.903474684710386e-08 0.00021 6.904474684710386e-08 0 7.190484960985245e-08 0 7.191484960985245e-08 0.00021 7.192484960985244e-08 0 7.276959298957967e-08 0 7.277959298957967e-08 0.00021 7.278959298957967e-08 0 7.646712067583677e-08 0 7.647712067583676e-08 0.00021 7.648712067583676e-08 0 7.697401784230865e-08 0 7.698401784230865e-08 0.00021 7.699401784230865e-08 0 7.825986561981289e-08 0 7.826986561981289e-08 0.00021 7.827986561981289e-08 0 8.027868974753474e-08 0 8.028868974753474e-08 0.00021 8.029868974753473e-08 0 8.112468146048189e-08 0 8.113468146048189e-08 0.00021 8.114468146048189e-08 0 8.186874622174683e-08 0 8.187874622174683e-08 0.00021 8.188874622174682e-08 0 8.246946863539442e-08 0 8.247946863539442e-08 0.00021 8.248946863539442e-08 0 8.254214583146155e-08 0 8.255214583146155e-08 0.00021 8.256214583146155e-08 0 8.699472991542627e-08 0 8.700472991542627e-08 0.00021 8.701472991542626e-08 0 8.866505015088902e-08 0 8.867505015088902e-08 0.00021 8.868505015088902e-08 0 8.91869822937137e-08 0 8.919698229371369e-08 0.00021 8.920698229371369e-08 0 9.094201468264473e-08 0 9.095201468264473e-08 0.00021 9.096201468264473e-08 0 9.195692511932562e-08 0 9.196692511932562e-08 0.00021 9.197692511932562e-08 0 9.197692511932562e-08 0 9.198692511932562e-08 0.00021 9.199692511932561e-08 0 9.333929821912134e-08 0 9.334929821912134e-08 0.00021 9.335929821912134e-08 0 9.475297135582801e-08 0 9.4762971355828e-08 0.00021 9.4772971355828e-08 0 9.525811756539421e-08 0 9.52681175653942e-08 0.00021 9.52781175653942e-08 0 9.52781175653942e-08 0 9.52881175653942e-08 0.00021 9.52981175653942e-08 0 9.800406095409949e-08 0 9.801406095409949e-08 0.00021 9.802406095409948e-08 0 1.0009134506599038e-07 0 1.0010134506599038e-07 0.00021 1.0011134506599037e-07 0 1.0389587845295402e-07 0 1.0390587845295402e-07 0.00021 1.0391587845295401e-07 0 1.0394167291838885e-07 0 1.0395167291838885e-07 0.00021 1.0396167291838885e-07 0 1.0683167191300012e-07 0 1.0684167191300012e-07 0.00021 1.0685167191300012e-07 0 1.0947596213425331e-07 0 1.094859621342533e-07 0.00021 1.094959621342533e-07 0 1.1266135944953272e-07 0 1.1267135944953272e-07 0.00021 1.1268135944953271e-07 0 1.1484997817489126e-07 0 1.1485997817489126e-07 0.00021 1.1486997817489126e-07 0 1.1519597164737891e-07 0 1.1520597164737891e-07 0.00021 1.1521597164737891e-07 0 1.1753788495616977e-07 0 1.1754788495616977e-07 0.00021 1.1755788495616977e-07 0 1.1805423120924228e-07 0 1.1806423120924228e-07 0.00021 1.1807423120924228e-07 0 1.1866352099764441e-07 0 1.186735209976444e-07 0.00021 1.186835209976444e-07 0 1.201011684007608e-07 0 1.201111684007608e-07 0.00021 1.2012116840076082e-07 0 1.209394996980026e-07 0 1.209494996980026e-07 0.00021 1.209594996980026e-07 0 1.2180397048888528e-07 0 1.218139704888853e-07 0.00021 1.218239704888853e-07 0 1.219078684770303e-07 0 1.219178684770303e-07 0.00021 1.2192786847703032e-07 0 1.226188560231865e-07 0 1.226288560231865e-07 0.00021 1.2263885602318652e-07 0 1.2639366641868642e-07 0 1.2640366641868643e-07 0.00021 1.2641366641868644e-07 0 1.264834159474255e-07 0 1.264934159474255e-07 0.00021 1.2650341594742552e-07 0 1.2803592079524524e-07 0 1.2804592079524526e-07 0.00021 1.2805592079524527e-07 0 1.2805592079524524e-07 0 1.2806592079524525e-07 0.00021 1.2807592079524526e-07 0 1.2976160639850578e-07 0 1.297716063985058e-07 0.00021 1.297816063985058e-07 0 1.303752695501023e-07 0 1.303852695501023e-07 0.00021 1.303952695501023e-07 0 1.3142689838603717e-07 0 1.3143689838603719e-07 0.00021 1.314468983860372e-07 0 1.3158160274114605e-07 0 1.3159160274114606e-07 0.00021 1.3160160274114607e-07 0 1.325793415938943e-07 0 1.325893415938943e-07 0.00021 1.3259934159389432e-07 0 1.3277749946825337e-07 0 1.3278749946825339e-07 0.00021 1.327974994682534e-07 0 1.3338783407200205e-07 0 1.3339783407200206e-07 0.00021 1.3340783407200207e-07 0 1.3427690905860377e-07 0 1.3428690905860378e-07 0.00021 1.342969090586038e-07 0 1.3473240743772157e-07 0 1.3474240743772158e-07 0.00021 1.347524074377216e-07 0 1.3491757214683464e-07 0 1.3492757214683466e-07 0.00021 1.3493757214683467e-07 0 1.355586249120745e-07 0 1.3556862491207452e-07 0.00021 1.3557862491207453e-07 0 1.3586385964756592e-07 0 1.3587385964756593e-07 0.00021 1.3588385964756595e-07 0 1.3595791588616017e-07 0 1.3596791588616018e-07 0.00021 1.359779158861602e-07 0 1.3846556235010687e-07 0 1.3847556235010688e-07 0.00021 1.384855623501069e-07 0 1.400416236440301e-07 0 1.4005162364403012e-07 0.00021 1.4006162364403013e-07 0 1.408281354875143e-07 0 1.408381354875143e-07 0.00021 1.4084813548751432e-07 0 1.428887576129631e-07 0 1.428987576129631e-07 0.00021 1.429087576129631e-07 0 1.4337910393653384e-07 0 1.4338910393653385e-07 0.00021 1.4339910393653387e-07 0 1.4366540421831104e-07 0 1.4367540421831105e-07 0.00021 1.4368540421831106e-07 0 1.4409731998523817e-07 0 1.4410731998523818e-07 0.00021 1.441173199852382e-07 0 1.4692501834886194e-07 0 1.4693501834886195e-07 0.00021 1.4694501834886196e-07 0 1.4736317346284703e-07 0 1.4737317346284704e-07 0.00021 1.4738317346284705e-07 0 1.491659438386626e-07 0 1.491759438386626e-07 0.00021 1.4918594383866262e-07 0 1.5028298491549766e-07 0 1.5029298491549767e-07 0.00021 1.5030298491549768e-07 0 1.5059867381019817e-07 0 1.5060867381019818e-07 0.00021 1.506186738101982e-07 0 1.5115650067671487e-07 0 1.5116650067671488e-07 0.00021 1.511765006767149e-07 0 1.514844653083634e-07 0 1.5149446530836342e-07 0.00021 1.5150446530836343e-07 0 1.517743075100446e-07 0 1.517843075100446e-07 0.00021 1.517943075100446e-07 0 1.5304869256092928e-07 0 1.530586925609293e-07 0.00021 1.530686925609293e-07 0 1.547098345922072e-07 0 1.5471983459220722e-07 0.00021 1.5472983459220723e-07 0 1.547298345922072e-07 0 1.5473983459220722e-07 0.00021 1.5474983459220723e-07 0 1.5695081620803477e-07 0 1.5696081620803478e-07 0.00021 1.569708162080348e-07 0 1.5788097027147158e-07 0 1.578909702714716e-07 0.00021 1.579009702714716e-07 0 1.6009453379174142e-07 0 1.6010453379174143e-07 0.00021 1.6011453379174144e-07 0 1.6013637593369692e-07 0 1.6014637593369693e-07 0.00021 1.6015637593369694e-07 0 1.6151598428860408e-07 0 1.615259842886041e-07 0.00021 1.615359842886041e-07 0 1.6160667974851576e-07 0 1.6161667974851577e-07 0.00021 1.6162667974851578e-07 0 1.6253304302582507e-07 0 1.6254304302582508e-07 0.00021 1.625530430258251e-07 0 1.6491474080543492e-07 0 1.6492474080543493e-07 0.00021 1.6493474080543494e-07 0 1.6592019607321516e-07 0 1.6593019607321517e-07 0.00021 1.6594019607321518e-07 0 1.695307361972255e-07 0 1.695407361972255e-07 0.00021 1.695507361972255e-07 0 1.6980448307333435e-07 0 1.6981448307333436e-07 0.00021 1.6982448307333437e-07 0 1.7374764471703336e-07 0 1.7375764471703337e-07 0.00021 1.7376764471703338e-07 0 1.7391013720909704e-07 0 1.7392013720909705e-07 0.00021 1.7393013720909706e-07 0 1.7614988429018047e-07 0 1.7615988429018048e-07 0.00021 1.761698842901805e-07 0 1.7685705062088532e-07 0 1.7686705062088533e-07 0.00021 1.7687705062088534e-07 0 1.7765537733165517e-07 0 1.7766537733165518e-07 0.00021 1.776753773316552e-07 0 1.7834699016486318e-07 0 1.783569901648632e-07 0.00021 1.783669901648632e-07 0 1.7898343666692402e-07 0 1.7899343666692403e-07 0.00021 1.7900343666692404e-07 0 1.8182024708518205e-07 0 1.8183024708518206e-07 0.00021 1.8184024708518207e-07 0 1.8302114832054325e-07 0 1.8303114832054326e-07 0.00021 1.8304114832054327e-07 0 1.8353900758935598e-07 0 1.83549007589356e-07 0.00021 1.83559007589356e-07 0 1.8383280099300226e-07 0 1.8384280099300227e-07 0.00021 1.8385280099300228e-07 0 1.8393044575542398e-07 0 1.83940445755424e-07 0.00021 1.83950445755424e-07 0 1.8647898792633942e-07 0 1.8648898792633943e-07 0.00021 1.8649898792633944e-07 0 1.890980218835486e-07 0 1.8910802188354862e-07 0.00021 1.8911802188354863e-07 0 1.8978240005794449e-07 0 1.897924000579445e-07 0.00021 1.898024000579445e-07 0 1.907440009210097e-07 0 1.9075400092100972e-07 0.00021 1.9076400092100973e-07 0 1.926989495392079e-07 0 1.9270894953920792e-07 0.00021 1.9271894953920793e-07 0 1.944637946907495e-07 0 1.944737946907495e-07 0.00021 1.9448379469074952e-07 0 1.9536414296457122e-07 0 1.9537414296457123e-07 0.00021 1.9538414296457125e-07 0 1.9574971177071528e-07 0 1.957597117707153e-07 0.00021 1.957697117707153e-07 0 1.9644729702940054e-07 0 1.9645729702940056e-07 0.00021 1.9646729702940057e-07 0 1.9889248372520304e-07 0 1.9890248372520306e-07 0.00021 1.9891248372520307e-07 0 2.0056546227992753e-07 0 2.0057546227992754e-07 0.00021 2.0058546227992756e-07 0 2.007617629481266e-07 0 2.0077176294812662e-07 0.00021 2.0078176294812664e-07 0 2.0131871743469965e-07 0 2.0132871743469966e-07 0.00021 2.0133871743469967e-07 0 2.0539685601084605e-07 0 2.0540685601084606e-07 0.00021 2.0541685601084607e-07 0 2.059721165692491e-07 0 2.0598211656924912e-07 0.00021 2.0599211656924913e-07 0 2.0722051010000875e-07 0 2.0723051010000876e-07 0.00021 2.0724051010000878e-07 0 2.0789148720561024e-07 0 2.0790148720561026e-07 0.00021 2.0791148720561027e-07 0 2.0849254769975097e-07 0 2.0850254769975099e-07 0.00021 2.08512547699751e-07 0 2.0897296403937674e-07 0 2.0898296403937675e-07 0.00021 2.0899296403937676e-07 0 2.095902693091763e-07 0 2.096002693091763e-07 0.00021 2.0961026930917632e-07 0 2.119063137695519e-07 0 2.119163137695519e-07 0.00021 2.1192631376955192e-07 0 2.1302833056222198e-07 0 2.13038330562222e-07 0.00021 2.13048330562222e-07 0 2.1305315484158144e-07 0 2.1306315484158145e-07 0.00021 2.1307315484158146e-07 0 2.1419456529261902e-07 0 2.1420456529261903e-07 0.00021 2.1421456529261905e-07 0 2.1536534132005504e-07 0 2.1537534132005505e-07 0.00021 2.1538534132005506e-07 0 2.1626448073995597e-07 0 2.1627448073995598e-07 0.00021 2.16284480739956e-07 0 2.1751861177923844e-07 0 2.1752861177923845e-07 0.00021 2.1753861177923846e-07 0 2.18235928061955e-07 0 2.1824592806195502e-07 0.00021 2.1825592806195503e-07 0 2.1950007085769608e-07 0 2.195100708576961e-07 0.00021 2.195200708576961e-07 0 2.1994020071676387e-07 0 2.1995020071676388e-07 0.00021 2.199602007167639e-07 0 2.2032452846570633e-07 0 2.2033452846570634e-07 0.00021 2.2034452846570635e-07 0 2.2183371018958168e-07 0 2.218437101895817e-07 0.00021 2.218537101895817e-07 0 2.2352719076015247e-07 0 2.2353719076015249e-07 0.00021 2.235471907601525e-07 0 2.2374379743489398e-07 0 2.23753797434894e-07 0.00021 2.23763797434894e-07 0 2.248800150878361e-07 0 2.2489001508783612e-07 0.00021 2.2490001508783614e-07 0 2.2582757429458458e-07 0 2.258375742945846e-07 0.00021 2.258475742945846e-07 0 2.2653198077245197e-07 0 2.2654198077245199e-07 0.00021 2.26551980772452e-07 0 2.2772659772177576e-07 0 2.2773659772177577e-07 0.00021 2.2774659772177578e-07 0 2.2813405856632532e-07 0 2.2814405856632534e-07 0.00021 2.2815405856632535e-07 0 2.2908253849887528e-07 0 2.290925384988753e-07 0.00021 2.291025384988753e-07 0 2.293710045252055e-07 0 2.293810045252055e-07 0.00021 2.293910045252055e-07 0 2.2943624507970147e-07 0 2.2944624507970148e-07 0.00021 2.294562450797015e-07 0 2.3051980260614247e-07 0 2.3052980260614248e-07 0.00021 2.305398026061425e-07 0 2.3083401747475736e-07 0 2.3084401747475737e-07 0.00021 2.3085401747475738e-07 0 2.3191631827034217e-07 0 2.3192631827034218e-07 0.00021 2.319363182703422e-07 0 2.3534778913810306e-07 0 2.3535778913810307e-07 0.00021 2.3536778913810308e-07 0 2.3710635044579223e-07 0 2.3711635044579224e-07 0.00021 2.3712635044579225e-07 0 2.3727140832276387e-07 0 2.3728140832276388e-07 0.00021 2.372914083227639e-07 0 2.3737081953617116e-07 0 2.3738081953617117e-07 0.00021 2.3739081953617118e-07 0 2.3753794074524882e-07 0 2.3754794074524883e-07 0.00021 2.3755794074524885e-07 0 2.3935948526882987e-07 0 2.393694852688299e-07 0.00021 2.393794852688299e-07 0 2.407689229688701e-07 0 2.4077892296887014e-07 0.00021 2.4078892296887015e-07 0 2.4154958791670895e-07 0 2.4155958791670896e-07 0.00021 2.4156958791670897e-07 0 2.416926679410866e-07 0 2.417026679410866e-07 0.00021 2.4171266794108664e-07 0 2.419820660565896e-07 0 2.419920660565896e-07 0.00021 2.4200206605658964e-07 0 2.4218998740844133e-07 0 2.4219998740844134e-07 0.00021 2.4220998740844135e-07 0 2.425336277947305e-07 0 2.425436277947305e-07 0.00021 2.425536277947305e-07 0 2.43039843071683e-07 0 2.4304984307168303e-07 0.00021 2.4305984307168304e-07 0 2.4386857810316163e-07 0 2.4387857810316164e-07 0.00021 2.4388857810316165e-07 0 2.444735963864237e-07 0 2.4448359638642373e-07 0.00021 2.4449359638642375e-07 0 2.4486343471557804e-07 0 2.4487343471557805e-07 0.00021 2.4488343471557806e-07 0 2.456651648912621e-07 0 2.456751648912621e-07 0.00021 2.456851648912621e-07 0 2.461830326663305e-07 0 2.4619303266633053e-07 0.00021 2.4620303266633055e-07 0 2.472032349502763e-07 0 2.472132349502763e-07 0.00021 2.472232349502763e-07 0 2.4776709219454223e-07 0 2.4777709219454224e-07 0.00021 2.4778709219454225e-07 0 2.5006452143910854e-07 0 2.5007452143910855e-07 0.00021 2.5008452143910857e-07 0 2.502324295999543e-07 0 2.502424295999543e-07 0.00021 2.502524295999543e-07 0 2.517932587696283e-07 0 2.518032587696283e-07 0.00021 2.518132587696283e-07 0 2.565043683639393e-07 0 2.5651436836393933e-07 0.00021 2.5652436836393934e-07 0 2.5730223226362286e-07 0 2.573122322636229e-07 0.00021 2.573222322636229e-07 0 2.5938870643492374e-07 0 2.5939870643492376e-07 0.00021 2.5940870643492377e-07 0 2.612445045776056e-07 0 2.612545045776056e-07 0.00021 2.612645045776056e-07 0 2.6408408993326575e-07 0 2.6409408993326576e-07 0.00021 2.6410408993326577e-07 0 2.659857324743446e-07 0 2.659957324743446e-07 0.00021 2.660057324743446e-07 0 2.66028406597631e-07 0 2.6603840659763104e-07 0.00021 2.6604840659763105e-07 0 2.677536432091508e-07 0 2.677636432091508e-07 0.00021 2.677736432091508e-07 0 2.685541141580712e-07 0 2.6856411415807124e-07 0.00021 2.6857411415807125e-07 0 2.6925171819722754e-07 0 2.6926171819722755e-07 0.00021 2.6927171819722756e-07 0 2.7130555724596173e-07 0 2.7131555724596174e-07 0.00021 2.7132555724596176e-07 0 2.7337745341582933e-07 0 2.7338745341582935e-07 0.00021 2.7339745341582936e-07 0 2.736447026008455e-07 0 2.736547026008455e-07 0.00021 2.736647026008455e-07 0 2.7417181696059513e-07 0 2.7418181696059514e-07 0.00021 2.7419181696059515e-07 0 2.769282059457115e-07 0 2.7693820594571154e-07 0.00021 2.7694820594571155e-07 0 2.779020852293439e-07 0 2.7791208522934394e-07 0.00021 2.7792208522934395e-07 0 2.781274804727846e-07 0 2.781374804727846e-07 0.00021 2.781474804727846e-07 0 2.850559450264362e-07 0 2.850659450264362e-07 0.00021 2.8507594502643623e-07 0 2.85208425587032e-07 0 2.85218425587032e-07 0.00021 2.85228425587032e-07 0 2.856658078280284e-07 0 2.856758078280284e-07 0.00021 2.8568580782802844e-07 0 2.860265266640539e-07 0 2.860365266640539e-07 0.00021 2.860465266640539e-07 0 2.8680125364885963e-07 0 2.8681125364885964e-07 0.00021 2.8682125364885965e-07 0 2.8725488497863425e-07 0 2.8726488497863426e-07 0.00021 2.8727488497863427e-07 0 2.878372042045353e-07 0 2.878472042045353e-07 0.00021 2.8785720420453533e-07 0 2.8785720420453533e-07 0 2.8786720420453534e-07 0.00021 2.8787720420453535e-07 0 2.879398987344334e-07 0 2.879498987344334e-07 0.00021 2.879598987344334e-07 0 2.9112125394280873e-07 0 2.9113125394280874e-07 0.00021 2.9114125394280875e-07 0 2.9132974762678007e-07 0 2.913397476267801e-07 0.00021 2.913497476267801e-07 0 2.9313474989326173e-07 0 2.9314474989326174e-07 0.00021 2.9315474989326175e-07 0 2.9669377498564287e-07 0 2.967037749856429e-07 0.00021 2.967137749856429e-07 0 2.979549157839136e-07 0 2.9796491578391363e-07 0.00021 2.9797491578391364e-07 0 3.0048407922852025e-07 0 3.0049407922852026e-07 0.00021 3.005040792285203e-07 0 3.015468691995361e-07 0 3.015568691995361e-07 0.00021 3.015668691995361e-07 0 3.030055843490482e-07 0 3.030155843490482e-07 0.00021 3.030255843490482e-07 0 3.052190212042465e-07 0 3.052290212042465e-07 0.00021 3.0523902120424653e-07 0 3.071000174363338e-07 0 3.071100174363338e-07 0.00021 3.071200174363338e-07 0 3.0845540505023763e-07 0 3.0846540505023765e-07 0.00021 3.0847540505023766e-07 0 3.0993652253650804e-07 0 3.0994652253650805e-07 0.00021 3.0995652253650806e-07 0 3.110765562808823e-07 0 3.1108655628088233e-07 0.00021 3.1109655628088235e-07 0 3.137356187556843e-07 0 3.137456187556843e-07 0.00021 3.137556187556843e-07 0 3.1442453597303716e-07 0 3.144345359730372e-07 0.00021 3.144445359730372e-07 0 3.1462343556578557e-07 0 3.146334355657856e-07 0.00021 3.146434355657856e-07 0 3.157574642068975e-07 0 3.157674642068975e-07 0.00021 3.1577746420689754e-07 0 3.1794063564390616e-07 0 3.179506356439062e-07 0.00021 3.179606356439062e-07 0 3.180622174017109e-07 0 3.180722174017109e-07 0.00021 3.1808221740171093e-07 0 3.1873576041630354e-07 0 3.1874576041630356e-07 0.00021 3.1875576041630357e-07 0 3.190921462904973e-07 0 3.191021462904973e-07 0.00021 3.191121462904973e-07 0 3.197626012272499e-07 0 3.197726012272499e-07 0.00021 3.197826012272499e-07 0 3.200909354671324e-07 0 3.201009354671324e-07 0.00021 3.201109354671324e-07 0 3.2145709869806005e-07 0 3.2146709869806006e-07 0.00021 3.214770986980601e-07 0 3.228714878023408e-07 0 3.228814878023408e-07 0.00021 3.2289148780234084e-07 0 3.230498826992058e-07 0 3.230598826992058e-07 0.00021 3.2306988269920583e-07 0 3.2475449010369396e-07 0 3.2476449010369397e-07 0.00021 3.24774490103694e-07 0 3.2604970689732074e-07 0 3.2605970689732075e-07 0.00021 3.2606970689732076e-07 0 3.2802207762443905e-07 0 3.2803207762443906e-07 0.00021 3.280420776244391e-07 0 3.312226045204065e-07 0 3.312326045204065e-07 0.00021 3.312426045204065e-07 0 3.315698482853284e-07 0 3.3157984828532843e-07 0.00021 3.3158984828532845e-07 0 3.3163957694093096e-07 0 3.31649576940931e-07 0.00021 3.31659576940931e-07 0 3.3223130832182375e-07 0 3.3224130832182376e-07 0.00021 3.3225130832182377e-07 0 3.339673436197919e-07 0 3.3397734361979193e-07 0.00021 3.3398734361979194e-07 0 3.349558387716958e-07 0 3.349658387716958e-07 0.00021 3.349758387716958e-07 0 3.367951624822747e-07 0 3.368051624822747e-07 0.00021 3.368151624822747e-07 0 3.3700144864853805e-07 0 3.3701144864853807e-07 0.00021 3.370214486485381e-07 0 3.4513020295519843e-07 0 3.4514020295519844e-07 0.00021 3.4515020295519845e-07 0 3.451798894645128e-07 0 3.451898894645128e-07 0.00021 3.4519988946451283e-07 0 3.459546115254856e-07 0 3.459646115254856e-07 0.00021 3.459746115254856e-07 0 3.469892494651749e-07 0 3.4699924946517493e-07 0.00021 3.4700924946517494e-07 0 3.4755829564028706e-07 0 3.4756829564028707e-07 0.00021 3.475782956402871e-07 0 3.488376981867025e-07 0 3.488476981867025e-07 0.00021 3.488576981867025e-07 0 3.492873138237428e-07 0 3.492973138237428e-07 0.00021 3.493073138237428e-07 0 3.497018019892401e-07 0 3.497118019892401e-07 0.00021 3.497218019892401e-07 0 3.51277128541241e-07 0 3.51287128541241e-07 0.00021 3.51297128541241e-07 0 3.527134951818813e-07 0 3.527234951818813e-07 0.00021 3.527334951818813e-07 0 3.5322031181023926e-07 0 3.532303118102393e-07 0.00021 3.532403118102393e-07 0 3.5339105119488737e-07 0 3.534010511948874e-07 0.00021 3.534110511948874e-07 0 3.54300688793913e-07 0 3.5431068879391303e-07 0.00021 3.5432068879391304e-07 0 3.550685212932968e-07 0 3.550785212932968e-07 0.00021 3.550885212932968e-07 0 3.556184201346119e-07 0 3.556284201346119e-07 0.00021 3.556384201346119e-07 0 3.5628825658894306e-07 0 3.562982565889431e-07 0.00021 3.563082565889431e-07 0 3.565085461937499e-07 0 3.5651854619374993e-07 0.00021 3.5652854619374994e-07 0 3.570075046833531e-07 0 3.570175046833531e-07 0.00021 3.570275046833531e-07 0 3.590706469881986e-07 0 3.5908064698819864e-07 0.00021 3.5909064698819865e-07 0 3.5909064698819865e-07 0 3.5910064698819866e-07 0.00021 3.5911064698819867e-07 0 3.5919896596864527e-07 0 3.592089659686453e-07 0.00021 3.592189659686453e-07 0 3.593868439652468e-07 0 3.593968439652468e-07 0.00021 3.594068439652468e-07 0 3.6045341489658615e-07 0 3.6046341489658616e-07 0.00021 3.6047341489658617e-07 0 3.613975375575079e-07 0 3.614075375575079e-07 0.00021 3.614175375575079e-07 0 3.6195073896974405e-07 0 3.6196073896974406e-07 0.00021 3.619707389697441e-07 0 3.621407616084656e-07 0 3.621507616084656e-07 0.00021 3.621607616084656e-07 0 3.621607616084656e-07 0 3.621707616084656e-07 0.00021 3.6218076160846563e-07 0 3.633601965463313e-07 0 3.633701965463313e-07 0.00021 3.633801965463313e-07 0 3.6378687004425406e-07 0 3.6379687004425407e-07 0.00021 3.638068700442541e-07 0 3.65055471630763e-07 0 3.65065471630763e-07 0.00021 3.65075471630763e-07 0 3.675180713424342e-07 0 3.675280713424342e-07 0.00021 3.675380713424342e-07 0 3.6755370597592423e-07 0 3.6756370597592424e-07 0.00021 3.6757370597592425e-07 0 3.6792638831391386e-07 0 3.679363883139139e-07 0.00021 3.679463883139139e-07 0 3.7064620794357136e-07 0 3.706562079435714e-07 0.00021 3.706662079435714e-07 0 3.707986076339846e-07 0 3.708086076339846e-07 0.00021 3.7081860763398464e-07 0 3.726633055572702e-07 0 3.726733055572702e-07 0.00021 3.726833055572702e-07 0 3.751875437934598e-07 0 3.751975437934598e-07 0.00021 3.752075437934598e-07 0 3.7539811404287286e-07 0 3.754081140428729e-07 0.00021 3.754181140428729e-07 0 3.784549873501555e-07 0 3.7846498735015553e-07 0.00021 3.7847498735015554e-07 0 3.788694362550302e-07 0 3.788794362550302e-07 0.00021 3.7888943625503023e-07 0 3.791577922620349e-07 0 3.791677922620349e-07 0.00021 3.791777922620349e-07 0 3.7920071320140204e-07 0 3.7921071320140205e-07 0.00021 3.7922071320140206e-07 0 3.800887705266648e-07 0 3.800987705266648e-07 0.00021 3.8010877052666483e-07 0 3.812462276439575e-07 0 3.812562276439575e-07 0.00021 3.8126622764395754e-07 0 3.8306535470068115e-07 0 3.8307535470068116e-07 0.00021 3.8308535470068117e-07 0 3.8387442657722084e-07 0 3.8388442657722085e-07 0.00021 3.8389442657722087e-07 0 3.849573786350134e-07 0 3.849673786350134e-07 0.00021 3.849773786350134e-07 0 3.8629666247665824e-07 0 3.8630666247665825e-07 0.00021 3.8631666247665826e-07 0 3.8721899489215704e-07 0 3.8722899489215705e-07 0.00021 3.8723899489215706e-07 0 3.8738940795153045e-07 0 3.8739940795153046e-07 0.00021 3.8740940795153047e-07 0 3.8743437885200706e-07 0 3.874443788520071e-07 0.00021 3.874543788520071e-07 0 3.874543788520071e-07 0 3.874643788520071e-07 0.00021 3.874743788520071e-07 0 3.8916431045005983e-07 0 3.8917431045005984e-07 0.00021 3.8918431045005985e-07 0 3.8925162621917056e-07 0 3.8926162621917057e-07 0.00021 3.892716262191706e-07 0 3.9072709336222045e-07 0 3.9073709336222046e-07 0.00021 3.907470933622205e-07 0 3.907845311148958e-07 0 3.9079453111489583e-07 0.00021 3.9080453111489584e-07 0 3.909593167680887e-07 0 3.909693167680887e-07 0.00021 3.909793167680887e-07 0 3.9159896814956225e-07 0 3.9160896814956226e-07 0.00021 3.9161896814956227e-07 0 3.924876825325274e-07 0 3.924976825325274e-07 0.00021 3.925076825325274e-07 0 3.9350796434000184e-07 0 3.9351796434000185e-07 0.00021 3.9352796434000186e-07 0 3.9414693555828875e-07 0 3.9415693555828876e-07 0.00021 3.9416693555828877e-07 0 3.968572986031864e-07 0 3.9686729860318643e-07 0.00021 3.9687729860318644e-07 0 3.971908688161828e-07 0 3.972008688161828e-07 0.00021 3.972108688161828e-07 0 3.981869193243574e-07 0 3.981969193243574e-07 0.00021 3.982069193243574e-07 0 3.9846472741454007e-07 0 3.984747274145401e-07 0.00021 3.984847274145401e-07 0 3.9904138852511073e-07 0 3.9905138852511074e-07 0.00021 3.9906138852511075e-07 0 3.9906258622348423e-07 0 3.9907258622348424e-07 0.00021 3.9908258622348425e-07 0 3.991686843406582e-07 0 3.991786843406582e-07 0.00021 3.9918868434065824e-07 0 4.0153686957963053e-07 0 4.0154686957963054e-07 0.00021 4.0155686957963055e-07 0 4.017904914344307e-07 0 4.018004914344307e-07 0.00021 4.018104914344307e-07 0 4.0425782007489034e-07 0 4.0426782007489035e-07 0.00021 4.0427782007489036e-07 0 4.0573677639794993e-07 0 4.0574677639794994e-07 0.00021 4.0575677639794996e-07 0 4.0618811240818236e-07 0 4.061981124081824e-07 0.00021 4.062081124081824e-07 0 4.067114278689894e-07 0 4.0672142786898944e-07 0.00021 4.0673142786898945e-07 0 4.0797724086881427e-07 0 4.079872408688143e-07 0.00021 4.079972408688143e-07 0 4.0861655665867814e-07 0 4.0862655665867815e-07 0.00021 4.0863655665867816e-07 0 4.1051856053339143e-07 0 4.1052856053339145e-07 0.00021 4.1053856053339146e-07 0 4.1300854730127605e-07 0 4.1301854730127607e-07 0.00021 4.130285473012761e-07 0 4.1353817884860985e-07 0 4.1354817884860986e-07 0.00021 4.1355817884860987e-07 0 4.1425771735916186e-07 0 4.1426771735916187e-07 0.00021 4.142777173591619e-07 0 4.162426546644969e-07 0 4.162526546644969e-07 0.00021 4.162626546644969e-07 0 4.1701879179907163e-07 0 4.1702879179907164e-07 0.00021 4.1703879179907165e-07 0 4.1803834943353533e-07 0 4.1804834943353535e-07 0.00021 4.1805834943353536e-07 0 4.182733109568072e-07 0 4.182833109568072e-07 0.00021 4.182933109568072e-07 0 4.196729693280082e-07 0 4.196829693280082e-07 0.00021 4.196929693280082e-07 0 4.2242683751925896e-07 0 4.2243683751925897e-07 0.00021 4.22446837519259e-07 0 4.225471858777105e-07 0 4.225571858777105e-07 0.00021 4.2256718587771053e-07 0 4.2632526325038696e-07 0 4.26335263250387e-07 0.00021 4.26345263250387e-07 0 4.264173185340453e-07 0 4.264273185340453e-07 0.00021 4.2643731853404534e-07 0 4.2643731853404534e-07 0 4.2644731853404535e-07 0.00021 4.2645731853404536e-07 0 4.275739205709493e-07 0 4.2758392057094933e-07 0.00021 4.2759392057094935e-07 0 4.315648469105334e-07 0 4.315748469105334e-07 0.00021 4.315848469105334e-07 0 4.32371688821095e-07 0 4.32381688821095e-07 0.00021 4.32391688821095e-07 0 4.3303394013226415e-07 0 4.3304394013226416e-07 0.00021 4.3305394013226417e-07 0 4.331307673959151e-07 0 4.331407673959151e-07 0.00021 4.331507673959151e-07 0 4.3396925563488223e-07 0 4.3397925563488224e-07 0.00021 4.3398925563488225e-07 0 4.3649877369164133e-07 0 4.3650877369164134e-07 0.00021 4.3651877369164135e-07 0 4.3727153739151235e-07 0 4.3728153739151237e-07 0.00021 4.372915373915124e-07 0 4.374936713213958e-07 0 4.375036713213958e-07 0.00021 4.3751367132139583e-07 0 4.415669788609778e-07 0 4.415769788609778e-07 0.00021 4.4158697886097783e-07 0 4.431634807404694e-07 0 4.431734807404694e-07 0.00021 4.431834807404694e-07 0 4.4505516741119085e-07 0 4.4506516741119087e-07 0.00021 4.450751674111909e-07 0 4.4774186976295663e-07 0 4.4775186976295664e-07 0.00021 4.4776186976295665e-07 0 4.4952502833853084e-07 0 4.4953502833853086e-07 0.00021 4.4954502833853087e-07 0 4.5057477651262254e-07 0 4.5058477651262256e-07 0.00021 4.5059477651262257e-07 0 4.5133680387456227e-07 0 4.513468038745623e-07 0.00021 4.513568038745623e-07 0 4.515495381016658e-07 0 4.5155953810166584e-07 0.00021 4.5156953810166585e-07 0 4.5753438656139345e-07 0 4.5754438656139346e-07 0.00021 4.5755438656139347e-07 0 4.576977644312412e-07 0 4.5770776443124123e-07 0.00021 4.5771776443124124e-07 0 4.5893462833200166e-07 0 4.5894462833200167e-07 0.00021 4.589546283320017e-07 0 4.5923424973730435e-07 0 4.5924424973730436e-07 0.00021 4.592542497373044e-07 0 4.6008987377206005e-07 0 4.6009987377206006e-07 0.00021 4.601098737720601e-07 0 4.6124908418509405e-07 0 4.6125908418509406e-07 0.00021 4.612690841850941e-07 0 4.61514032627379e-07 0 4.61524032627379e-07 0.00021 4.6153403262737903e-07 0 4.6268872902543086e-07 0 4.6269872902543087e-07 0.00021 4.627087290254309e-07 0 4.63643512828246e-07 0 4.63653512828246e-07 0.00021 4.63663512828246e-07 0 4.6478962470113934e-07 0 4.6479962470113935e-07 0.00021 4.6480962470113936e-07 0 4.65620176620758e-07 0 4.65630176620758e-07 0.00021 4.6564017662075803e-07 0 4.668566079521195e-07 0 4.6686660795211953e-07 0.00021 4.6687660795211954e-07 0 4.6725736480839785e-07 0 4.6726736480839786e-07 0.00021 4.672773648083979e-07 0 4.7010860641720205e-07 0 4.7011860641720206e-07 0.00021 4.7012860641720207e-07 0 4.707977970545275e-07 0 4.708077970545275e-07 0.00021 4.708177970545275e-07 0 4.7117250663530254e-07 0 4.7118250663530256e-07 0.00021 4.7119250663530257e-07 0 4.7141711715800716e-07 0 4.7142711715800717e-07 0.00021 4.714371171580072e-07 0 4.719727026010081e-07 0 4.7198270260100813e-07 0.00021 4.7199270260100814e-07 0 4.723785303131776e-07 0 4.723885303131776e-07 0.00021 4.723985303131776e-07 0 4.728465719632227e-07 0 4.728565719632227e-07 0.00021 4.728665719632227e-07 0 4.745948265901252e-07 0 4.746048265901252e-07 0.00021 4.7461482659012523e-07 0 4.766243177597558e-07 0 4.7663431775975583e-07 0.00021 4.7664431775975584e-07 0 4.777543672694652e-07 0 4.777643672694651e-07 0.00021 4.777743672694651e-07 0 4.786883731419148e-07 0 4.786983731419148e-07 0.00021 4.787083731419147e-07 0 4.794184905500471e-07 0 4.79428490550047e-07 0.00021 4.79438490550047e-07 0 4.809105486176305e-07 0 4.809205486176305e-07 0.00021 4.809305486176305e-07 0 4.810794097065684e-07 0 4.810894097065684e-07 0.00021 4.810994097065683e-07 0 4.814767568051773e-07 0 4.814867568051772e-07 0.00021 4.814967568051772e-07 0 4.81643126924069e-07 0 4.81653126924069e-07 0.00021 4.81663126924069e-07 0 4.825622708841467e-07 0 4.825722708841467e-07 0.00021 4.825822708841466e-07 0 4.833587391293588e-07 0 4.833687391293588e-07 0.00021 4.833787391293587e-07 0 4.838081751423143e-07 0 4.838181751423142e-07 0.00021 4.838281751423142e-07 0 4.844784622484099e-07 0 4.844884622484098e-07 0.00021 4.844984622484098e-07 0 4.847934664923255e-07 0 4.848034664923255e-07 0.00021 4.848134664923254e-07 0 4.854378812126383e-07 0 4.854478812126383e-07 0.00021 4.854578812126382e-07 0 4.855285157539212e-07 0 4.855385157539212e-07 0.00021 4.855485157539211e-07 0 4.856015684954276e-07 0 4.856115684954275e-07 0.00021 4.856215684954275e-07 0 4.875652517877694e-07 0 4.875752517877693e-07 0.00021 4.875852517877693e-07 0 4.893221788582382e-07 0 4.893321788582382e-07 0.00021 4.893421788582382e-07 0 4.894077359568227e-07 0 4.894177359568227e-07 0.00021 4.894277359568227e-07 0 4.896257067858277e-07 0 4.896357067858277e-07 0.00021 4.896457067858277e-07 0 4.905071241688221e-07 0 4.905171241688221e-07 0.00021 4.905271241688221e-07 0 4.922735558583491e-07 0 4.922835558583491e-07 0.00021 4.92293555858349e-07 0 4.946235293344569e-07 0 4.946335293344569e-07 0.00021 4.946435293344568e-07 0 4.949110457422516e-07 0 4.949210457422516e-07 0.00021 4.949310457422516e-07 0 4.951226731448942e-07 0 4.951326731448942e-07 0.00021 4.951426731448941e-07 0 4.963619007803629e-07 0 4.963719007803628e-07 0.00021 4.963819007803628e-07 0 4.978836591242253e-07 0 4.978936591242252e-07 0.00021 4.979036591242252e-07 0 4.982145348254781e-07 0 4.982245348254781e-07 0.00021 4.98234534825478e-07 0 4.982851011294611e-07 0 4.98295101129461e-07 0.00021 4.98305101129461e-07 0 4.997319463759376e-07 0 4.997419463759375e-07 0.00021 4.997519463759375e-07 0 4.999656896104611e-07 0 4.999756896104611e-07 0.00021 4.99985689610461e-07 0 )
X72 SYNAPSE 71 70 1072
X1072 JTL 1072 72
VIN74 74 0 pwl(0 0)
VIN76 76 0 pwl(0 0)
VIN78 78 0 pwl(0 0)
X87 LIF_NEURON 67 69 72 74 63 65 76 78 87
IB88 0 88 pwl(0 0 5p 260.6u)
X89 SYNAPSE 10 88 1089
X1089 JTL 1089 89
IB90 0 90 pwl(0 0 5p 164.60000000000002u)
X91 SYNAPSE 18 90 1091
X1091 JTL 1091 91
IB92 0 92 pwl(0 0 5p 265.3u)
X93 SYNAPSE 26 92 1093
X1093 JTL 1093 93
IB94 0 94 pwl(0 0 5p 169.5u)
X95 SYNAPSE 34 94 1095
X1095 JTL 1095 95
IB96 0 96 pwl(0 0 5p 147.3u)
VIN97 97 0 pwl(0 0 6.699319039689096e-10 0 6.799319039689096e-10 0.00021 6.899319039689096e-10 0 1.6895290054347743e-09 0 1.6995290054347742e-09 0.00021 1.7095290054347742e-09 0 1.7095290054347742e-09 0 1.7195290054347742e-09 0.00021 1.7295290054347741e-09 0 1.7295290054347741e-09 0 1.739529005434774e-09 0.00021 1.749529005434774e-09 0 2.261947867344106e-09 0 2.2719478673441063e-09 0.00021 2.2819478673441065e-09 0 3.891888302002492e-09 0 3.901888302002492e-09 0.00021 3.9118883020024915e-09 0 4.565471254669724e-09 0 4.575471254669723e-09 0.00021 4.585471254669723e-09 0 5.320772612495115e-09 0 5.330772612495115e-09 0.00021 5.340772612495115e-09 0 8.13755859157084e-09 0 8.14755859157084e-09 0.00021 8.15755859157084e-09 0 1.4195311672013414e-08 0 1.4205311672013413e-08 0.00021 1.4215311672013413e-08 0 1.7481739929907154e-08 0 1.7491739929907155e-08 0.00021 1.7501739929907157e-08 0 1.7501739929907153e-08 0 1.7511739929907155e-08 0.00021 1.7521739929907156e-08 0 1.9752122344508886e-08 0 1.9762122344508888e-08 0.00021 1.977212234450889e-08 0 1.982462002942878e-08 0 1.983462002942878e-08 0.00021 1.984462002942878e-08 0 2.0894020331596096e-08 0 2.0904020331596097e-08 0.00021 2.09140203315961e-08 0 2.1742953361140633e-08 0 2.1752953361140634e-08 0.00021 2.1762953361140636e-08 0 2.4892862013879127e-08 0 2.4902862013879128e-08 0.00021 2.491286201387913e-08 0 2.5246872056072377e-08 0 2.5256872056072378e-08 0.00021 2.526687205607238e-08 0 2.5553983195700722e-08 0 2.5563983195700723e-08 0.00021 2.5573983195700725e-08 0 2.7046202608826746e-08 0 2.7056202608826748e-08 0.00021 2.706620260882675e-08 0 2.7083206807612435e-08 0 2.7093206807612437e-08 0.00021 2.7103206807612438e-08 0 2.7218537619829642e-08 0 2.7228537619829643e-08 0.00021 2.7238537619829645e-08 0 2.8248735726482085e-08 0 2.8258735726482087e-08 0.00021 2.8268735726482088e-08 0 2.902328394445528e-08 0 2.9033283944455282e-08 0.00021 2.9043283944455284e-08 0 3.076096245449594e-08 0 3.0770962454495935e-08 0.00021 3.0780962454495933e-08 0 3.117463254033064e-08 0 3.118463254033064e-08 0.00021 3.119463254033064e-08 0 3.162284330367877e-08 0 3.163284330367877e-08 0.00021 3.164284330367877e-08 0 3.3474935656659066e-08 0 3.3484935656659064e-08 0.00021 3.349493565665906e-08 0 3.5200149266782075e-08 0 3.521014926678207e-08 0.00021 3.522014926678207e-08 0 3.552360854033267e-08 0 3.5533608540332667e-08 0.00021 3.5543608540332665e-08 0 3.573436996121096e-08 0 3.574436996121096e-08 0.00021 3.5754369961210956e-08 0 3.695766392097994e-08 0 3.6967663920979935e-08 0.00021 3.697766392097993e-08 0 3.749598812425032e-08 0 3.750598812425032e-08 0.00021 3.7515988124250316e-08 0 3.8350673217967685e-08 0 3.8360673217967683e-08 0.00021 3.837067321796768e-08 0 3.939939542823749e-08 0 3.940939542823749e-08 0.00021 3.9419395428237485e-08 0 4.063156607213525e-08 0 4.0641566072135246e-08 0.00021 4.0651566072135244e-08 0 4.355973538544831e-08 0 4.356973538544831e-08 0.00021 4.357973538544831e-08 0 4.371342414403645e-08 0 4.372342414403645e-08 0.00021 4.3733424144036445e-08 0 4.517922905922227e-08 0 4.5189229059222266e-08 0.00021 4.5199229059222264e-08 0 4.630346658829152e-08 0 4.6313466588291516e-08 0.00021 4.6323466588291514e-08 0 4.820151700662107e-08 0 4.821151700662107e-08 0.00021 4.8221517006621066e-08 0 4.880050898076728e-08 0 4.8810508980767275e-08 0.00021 4.882050898076727e-08 0 4.9269193645087165e-08 0 4.927919364508716e-08 0.00021 4.928919364508716e-08 0 5.008630096156474e-08 0 5.0096300961564736e-08 0.00021 5.0106300961564734e-08 0 5.035077023991867e-08 0 5.036077023991867e-08 0.00021 5.037077023991867e-08 0 5.109659272892389e-08 0 5.110659272892389e-08 0.00021 5.111659272892389e-08 0 5.120265478490252e-08 0 5.121265478490252e-08 0.00021 5.1222654784902515e-08 0 5.284960217857285e-08 0 5.2859602178572846e-08 0.00021 5.2869602178572844e-08 0 5.512884034615215e-08 0 5.513884034615215e-08 0.00021 5.5148840346152145e-08 0 5.568094282069005e-08 0 5.569094282069005e-08 0.00021 5.570094282069005e-08 0 5.8843673773400524e-08 0 5.885367377340052e-08 0.00021 5.886367377340052e-08 0 5.895137640484927e-08 0 5.8961376404849266e-08 0.00021 5.8971376404849264e-08 0 5.9230919195574786e-08 0 5.9240919195574784e-08 0.00021 5.925091919557478e-08 0 5.9528167878607205e-08 0 5.95381678786072e-08 0.00021 5.95481678786072e-08 0 6.029172481553576e-08 0 6.030172481553576e-08 0.00021 6.031172481553576e-08 0 6.12274700760351e-08 0 6.12374700760351e-08 0.00021 6.12474700760351e-08 0 6.176341288681853e-08 0 6.177341288681853e-08 0.00021 6.178341288681853e-08 0 6.188796692092078e-08 0 6.189796692092078e-08 0.00021 6.190796692092078e-08 0 6.388595827749053e-08 0 6.389595827749053e-08 0.00021 6.390595827749053e-08 0 6.438342219294889e-08 0 6.439342219294889e-08 0.00021 6.440342219294888e-08 0 6.449699210760943e-08 0 6.450699210760943e-08 0.00021 6.451699210760943e-08 0 6.526822853514719e-08 0 6.527822853514719e-08 0.00021 6.528822853514719e-08 0 6.556472817772882e-08 0 6.557472817772882e-08 0.00021 6.558472817772881e-08 0 6.598065030284667e-08 0 6.599065030284666e-08 0.00021 6.600065030284666e-08 0 6.62325211788612e-08 0 6.62425211788612e-08 0.00021 6.62525211788612e-08 0 6.674768758786636e-08 0 6.675768758786635e-08 0.00021 6.676768758786635e-08 0 6.774539224721535e-08 0 6.775539224721535e-08 0.00021 6.776539224721534e-08 0 6.784221741644163e-08 0 6.785221741644163e-08 0.00021 6.786221741644163e-08 0 6.902474684710386e-08 0 6.903474684710386e-08 0.00021 6.904474684710386e-08 0 7.190484960985245e-08 0 7.191484960985245e-08 0.00021 7.192484960985244e-08 0 7.276959298957967e-08 0 7.277959298957967e-08 0.00021 7.278959298957967e-08 0 7.646712067583677e-08 0 7.647712067583676e-08 0.00021 7.648712067583676e-08 0 7.697401784230865e-08 0 7.698401784230865e-08 0.00021 7.699401784230865e-08 0 7.825986561981289e-08 0 7.826986561981289e-08 0.00021 7.827986561981289e-08 0 8.027868974753474e-08 0 8.028868974753474e-08 0.00021 8.029868974753473e-08 0 8.112468146048189e-08 0 8.113468146048189e-08 0.00021 8.114468146048189e-08 0 8.186874622174683e-08 0 8.187874622174683e-08 0.00021 8.188874622174682e-08 0 8.246946863539442e-08 0 8.247946863539442e-08 0.00021 8.248946863539442e-08 0 8.254214583146155e-08 0 8.255214583146155e-08 0.00021 8.256214583146155e-08 0 8.699472991542627e-08 0 8.700472991542627e-08 0.00021 8.701472991542626e-08 0 8.866505015088902e-08 0 8.867505015088902e-08 0.00021 8.868505015088902e-08 0 8.91869822937137e-08 0 8.919698229371369e-08 0.00021 8.920698229371369e-08 0 9.094201468264473e-08 0 9.095201468264473e-08 0.00021 9.096201468264473e-08 0 9.195692511932562e-08 0 9.196692511932562e-08 0.00021 9.197692511932562e-08 0 9.197692511932562e-08 0 9.198692511932562e-08 0.00021 9.199692511932561e-08 0 9.333929821912134e-08 0 9.334929821912134e-08 0.00021 9.335929821912134e-08 0 9.475297135582801e-08 0 9.4762971355828e-08 0.00021 9.4772971355828e-08 0 9.525811756539421e-08 0 9.52681175653942e-08 0.00021 9.52781175653942e-08 0 9.52781175653942e-08 0 9.52881175653942e-08 0.00021 9.52981175653942e-08 0 9.800406095409949e-08 0 9.801406095409949e-08 0.00021 9.802406095409948e-08 0 1.0009134506599038e-07 0 1.0010134506599038e-07 0.00021 1.0011134506599037e-07 0 1.0389587845295402e-07 0 1.0390587845295402e-07 0.00021 1.0391587845295401e-07 0 1.0394167291838885e-07 0 1.0395167291838885e-07 0.00021 1.0396167291838885e-07 0 1.0683167191300012e-07 0 1.0684167191300012e-07 0.00021 1.0685167191300012e-07 0 1.0947596213425331e-07 0 1.094859621342533e-07 0.00021 1.094959621342533e-07 0 1.1266135944953272e-07 0 1.1267135944953272e-07 0.00021 1.1268135944953271e-07 0 1.1484997817489126e-07 0 1.1485997817489126e-07 0.00021 1.1486997817489126e-07 0 1.1519597164737891e-07 0 1.1520597164737891e-07 0.00021 1.1521597164737891e-07 0 1.1753788495616977e-07 0 1.1754788495616977e-07 0.00021 1.1755788495616977e-07 0 1.1805423120924228e-07 0 1.1806423120924228e-07 0.00021 1.1807423120924228e-07 0 1.1866352099764441e-07 0 1.186735209976444e-07 0.00021 1.186835209976444e-07 0 1.201011684007608e-07 0 1.201111684007608e-07 0.00021 1.2012116840076082e-07 0 1.209394996980026e-07 0 1.209494996980026e-07 0.00021 1.209594996980026e-07 0 1.2180397048888528e-07 0 1.218139704888853e-07 0.00021 1.218239704888853e-07 0 1.219078684770303e-07 0 1.219178684770303e-07 0.00021 1.2192786847703032e-07 0 1.226188560231865e-07 0 1.226288560231865e-07 0.00021 1.2263885602318652e-07 0 1.2639366641868642e-07 0 1.2640366641868643e-07 0.00021 1.2641366641868644e-07 0 1.264834159474255e-07 0 1.264934159474255e-07 0.00021 1.2650341594742552e-07 0 1.2803592079524524e-07 0 1.2804592079524526e-07 0.00021 1.2805592079524527e-07 0 1.2805592079524524e-07 0 1.2806592079524525e-07 0.00021 1.2807592079524526e-07 0 1.2976160639850578e-07 0 1.297716063985058e-07 0.00021 1.297816063985058e-07 0 1.303752695501023e-07 0 1.303852695501023e-07 0.00021 1.303952695501023e-07 0 1.3142689838603717e-07 0 1.3143689838603719e-07 0.00021 1.314468983860372e-07 0 1.3158160274114605e-07 0 1.3159160274114606e-07 0.00021 1.3160160274114607e-07 0 1.325793415938943e-07 0 1.325893415938943e-07 0.00021 1.3259934159389432e-07 0 1.3277749946825337e-07 0 1.3278749946825339e-07 0.00021 1.327974994682534e-07 0 1.3338783407200205e-07 0 1.3339783407200206e-07 0.00021 1.3340783407200207e-07 0 1.3427690905860377e-07 0 1.3428690905860378e-07 0.00021 1.342969090586038e-07 0 1.3473240743772157e-07 0 1.3474240743772158e-07 0.00021 1.347524074377216e-07 0 1.3491757214683464e-07 0 1.3492757214683466e-07 0.00021 1.3493757214683467e-07 0 1.355586249120745e-07 0 1.3556862491207452e-07 0.00021 1.3557862491207453e-07 0 1.3586385964756592e-07 0 1.3587385964756593e-07 0.00021 1.3588385964756595e-07 0 1.3595791588616017e-07 0 1.3596791588616018e-07 0.00021 1.359779158861602e-07 0 1.3846556235010687e-07 0 1.3847556235010688e-07 0.00021 1.384855623501069e-07 0 1.400416236440301e-07 0 1.4005162364403012e-07 0.00021 1.4006162364403013e-07 0 1.408281354875143e-07 0 1.408381354875143e-07 0.00021 1.4084813548751432e-07 0 1.428887576129631e-07 0 1.428987576129631e-07 0.00021 1.429087576129631e-07 0 1.4337910393653384e-07 0 1.4338910393653385e-07 0.00021 1.4339910393653387e-07 0 1.4366540421831104e-07 0 1.4367540421831105e-07 0.00021 1.4368540421831106e-07 0 1.4409731998523817e-07 0 1.4410731998523818e-07 0.00021 1.441173199852382e-07 0 1.4692501834886194e-07 0 1.4693501834886195e-07 0.00021 1.4694501834886196e-07 0 1.4736317346284703e-07 0 1.4737317346284704e-07 0.00021 1.4738317346284705e-07 0 1.491659438386626e-07 0 1.491759438386626e-07 0.00021 1.4918594383866262e-07 0 1.5028298491549766e-07 0 1.5029298491549767e-07 0.00021 1.5030298491549768e-07 0 1.5059867381019817e-07 0 1.5060867381019818e-07 0.00021 1.506186738101982e-07 0 1.5115650067671487e-07 0 1.5116650067671488e-07 0.00021 1.511765006767149e-07 0 1.514844653083634e-07 0 1.5149446530836342e-07 0.00021 1.5150446530836343e-07 0 1.517743075100446e-07 0 1.517843075100446e-07 0.00021 1.517943075100446e-07 0 1.5304869256092928e-07 0 1.530586925609293e-07 0.00021 1.530686925609293e-07 0 1.547098345922072e-07 0 1.5471983459220722e-07 0.00021 1.5472983459220723e-07 0 1.547298345922072e-07 0 1.5473983459220722e-07 0.00021 1.5474983459220723e-07 0 1.5695081620803477e-07 0 1.5696081620803478e-07 0.00021 1.569708162080348e-07 0 1.5788097027147158e-07 0 1.578909702714716e-07 0.00021 1.579009702714716e-07 0 1.6009453379174142e-07 0 1.6010453379174143e-07 0.00021 1.6011453379174144e-07 0 1.6013637593369692e-07 0 1.6014637593369693e-07 0.00021 1.6015637593369694e-07 0 1.6151598428860408e-07 0 1.615259842886041e-07 0.00021 1.615359842886041e-07 0 1.6160667974851576e-07 0 1.6161667974851577e-07 0.00021 1.6162667974851578e-07 0 1.6253304302582507e-07 0 1.6254304302582508e-07 0.00021 1.625530430258251e-07 0 1.6491474080543492e-07 0 1.6492474080543493e-07 0.00021 1.6493474080543494e-07 0 1.6592019607321516e-07 0 1.6593019607321517e-07 0.00021 1.6594019607321518e-07 0 1.695307361972255e-07 0 1.695407361972255e-07 0.00021 1.695507361972255e-07 0 1.6980448307333435e-07 0 1.6981448307333436e-07 0.00021 1.6982448307333437e-07 0 1.7374764471703336e-07 0 1.7375764471703337e-07 0.00021 1.7376764471703338e-07 0 1.7391013720909704e-07 0 1.7392013720909705e-07 0.00021 1.7393013720909706e-07 0 1.7614988429018047e-07 0 1.7615988429018048e-07 0.00021 1.761698842901805e-07 0 1.7685705062088532e-07 0 1.7686705062088533e-07 0.00021 1.7687705062088534e-07 0 1.7765537733165517e-07 0 1.7766537733165518e-07 0.00021 1.776753773316552e-07 0 1.7834699016486318e-07 0 1.783569901648632e-07 0.00021 1.783669901648632e-07 0 1.7898343666692402e-07 0 1.7899343666692403e-07 0.00021 1.7900343666692404e-07 0 1.8182024708518205e-07 0 1.8183024708518206e-07 0.00021 1.8184024708518207e-07 0 1.8302114832054325e-07 0 1.8303114832054326e-07 0.00021 1.8304114832054327e-07 0 1.8353900758935598e-07 0 1.83549007589356e-07 0.00021 1.83559007589356e-07 0 1.8383280099300226e-07 0 1.8384280099300227e-07 0.00021 1.8385280099300228e-07 0 1.8393044575542398e-07 0 1.83940445755424e-07 0.00021 1.83950445755424e-07 0 1.8647898792633942e-07 0 1.8648898792633943e-07 0.00021 1.8649898792633944e-07 0 1.890980218835486e-07 0 1.8910802188354862e-07 0.00021 1.8911802188354863e-07 0 1.8978240005794449e-07 0 1.897924000579445e-07 0.00021 1.898024000579445e-07 0 1.907440009210097e-07 0 1.9075400092100972e-07 0.00021 1.9076400092100973e-07 0 1.926989495392079e-07 0 1.9270894953920792e-07 0.00021 1.9271894953920793e-07 0 1.944637946907495e-07 0 1.944737946907495e-07 0.00021 1.9448379469074952e-07 0 1.9536414296457122e-07 0 1.9537414296457123e-07 0.00021 1.9538414296457125e-07 0 1.9574971177071528e-07 0 1.957597117707153e-07 0.00021 1.957697117707153e-07 0 1.9644729702940054e-07 0 1.9645729702940056e-07 0.00021 1.9646729702940057e-07 0 1.9889248372520304e-07 0 1.9890248372520306e-07 0.00021 1.9891248372520307e-07 0 2.0056546227992753e-07 0 2.0057546227992754e-07 0.00021 2.0058546227992756e-07 0 2.007617629481266e-07 0 2.0077176294812662e-07 0.00021 2.0078176294812664e-07 0 2.0131871743469965e-07 0 2.0132871743469966e-07 0.00021 2.0133871743469967e-07 0 2.0539685601084605e-07 0 2.0540685601084606e-07 0.00021 2.0541685601084607e-07 0 2.059721165692491e-07 0 2.0598211656924912e-07 0.00021 2.0599211656924913e-07 0 2.0722051010000875e-07 0 2.0723051010000876e-07 0.00021 2.0724051010000878e-07 0 2.0789148720561024e-07 0 2.0790148720561026e-07 0.00021 2.0791148720561027e-07 0 2.0849254769975097e-07 0 2.0850254769975099e-07 0.00021 2.08512547699751e-07 0 2.0897296403937674e-07 0 2.0898296403937675e-07 0.00021 2.0899296403937676e-07 0 2.095902693091763e-07 0 2.096002693091763e-07 0.00021 2.0961026930917632e-07 0 2.119063137695519e-07 0 2.119163137695519e-07 0.00021 2.1192631376955192e-07 0 2.1302833056222198e-07 0 2.13038330562222e-07 0.00021 2.13048330562222e-07 0 2.1305315484158144e-07 0 2.1306315484158145e-07 0.00021 2.1307315484158146e-07 0 2.1419456529261902e-07 0 2.1420456529261903e-07 0.00021 2.1421456529261905e-07 0 2.1536534132005504e-07 0 2.1537534132005505e-07 0.00021 2.1538534132005506e-07 0 2.1626448073995597e-07 0 2.1627448073995598e-07 0.00021 2.16284480739956e-07 0 2.1751861177923844e-07 0 2.1752861177923845e-07 0.00021 2.1753861177923846e-07 0 2.18235928061955e-07 0 2.1824592806195502e-07 0.00021 2.1825592806195503e-07 0 2.1950007085769608e-07 0 2.195100708576961e-07 0.00021 2.195200708576961e-07 0 2.1994020071676387e-07 0 2.1995020071676388e-07 0.00021 2.199602007167639e-07 0 2.2032452846570633e-07 0 2.2033452846570634e-07 0.00021 2.2034452846570635e-07 0 2.2183371018958168e-07 0 2.218437101895817e-07 0.00021 2.218537101895817e-07 0 2.2352719076015247e-07 0 2.2353719076015249e-07 0.00021 2.235471907601525e-07 0 2.2374379743489398e-07 0 2.23753797434894e-07 0.00021 2.23763797434894e-07 0 2.248800150878361e-07 0 2.2489001508783612e-07 0.00021 2.2490001508783614e-07 0 2.2582757429458458e-07 0 2.258375742945846e-07 0.00021 2.258475742945846e-07 0 2.2653198077245197e-07 0 2.2654198077245199e-07 0.00021 2.26551980772452e-07 0 2.2772659772177576e-07 0 2.2773659772177577e-07 0.00021 2.2774659772177578e-07 0 2.2813405856632532e-07 0 2.2814405856632534e-07 0.00021 2.2815405856632535e-07 0 2.2908253849887528e-07 0 2.290925384988753e-07 0.00021 2.291025384988753e-07 0 2.293710045252055e-07 0 2.293810045252055e-07 0.00021 2.293910045252055e-07 0 2.2943624507970147e-07 0 2.2944624507970148e-07 0.00021 2.294562450797015e-07 0 2.3051980260614247e-07 0 2.3052980260614248e-07 0.00021 2.305398026061425e-07 0 2.3083401747475736e-07 0 2.3084401747475737e-07 0.00021 2.3085401747475738e-07 0 2.3191631827034217e-07 0 2.3192631827034218e-07 0.00021 2.319363182703422e-07 0 2.3534778913810306e-07 0 2.3535778913810307e-07 0.00021 2.3536778913810308e-07 0 2.3710635044579223e-07 0 2.3711635044579224e-07 0.00021 2.3712635044579225e-07 0 2.3727140832276387e-07 0 2.3728140832276388e-07 0.00021 2.372914083227639e-07 0 2.3737081953617116e-07 0 2.3738081953617117e-07 0.00021 2.3739081953617118e-07 0 2.3753794074524882e-07 0 2.3754794074524883e-07 0.00021 2.3755794074524885e-07 0 2.3935948526882987e-07 0 2.393694852688299e-07 0.00021 2.393794852688299e-07 0 2.407689229688701e-07 0 2.4077892296887014e-07 0.00021 2.4078892296887015e-07 0 2.4154958791670895e-07 0 2.4155958791670896e-07 0.00021 2.4156958791670897e-07 0 2.416926679410866e-07 0 2.417026679410866e-07 0.00021 2.4171266794108664e-07 0 2.419820660565896e-07 0 2.419920660565896e-07 0.00021 2.4200206605658964e-07 0 2.4218998740844133e-07 0 2.4219998740844134e-07 0.00021 2.4220998740844135e-07 0 2.425336277947305e-07 0 2.425436277947305e-07 0.00021 2.425536277947305e-07 0 2.43039843071683e-07 0 2.4304984307168303e-07 0.00021 2.4305984307168304e-07 0 2.4386857810316163e-07 0 2.4387857810316164e-07 0.00021 2.4388857810316165e-07 0 2.444735963864237e-07 0 2.4448359638642373e-07 0.00021 2.4449359638642375e-07 0 2.4486343471557804e-07 0 2.4487343471557805e-07 0.00021 2.4488343471557806e-07 0 2.456651648912621e-07 0 2.456751648912621e-07 0.00021 2.456851648912621e-07 0 2.461830326663305e-07 0 2.4619303266633053e-07 0.00021 2.4620303266633055e-07 0 2.472032349502763e-07 0 2.472132349502763e-07 0.00021 2.472232349502763e-07 0 2.4776709219454223e-07 0 2.4777709219454224e-07 0.00021 2.4778709219454225e-07 0 2.5006452143910854e-07 0 2.5007452143910855e-07 0.00021 2.5008452143910857e-07 0 2.502324295999543e-07 0 2.502424295999543e-07 0.00021 2.502524295999543e-07 0 2.517932587696283e-07 0 2.518032587696283e-07 0.00021 2.518132587696283e-07 0 2.565043683639393e-07 0 2.5651436836393933e-07 0.00021 2.5652436836393934e-07 0 2.5730223226362286e-07 0 2.573122322636229e-07 0.00021 2.573222322636229e-07 0 2.5938870643492374e-07 0 2.5939870643492376e-07 0.00021 2.5940870643492377e-07 0 2.612445045776056e-07 0 2.612545045776056e-07 0.00021 2.612645045776056e-07 0 2.6408408993326575e-07 0 2.6409408993326576e-07 0.00021 2.6410408993326577e-07 0 2.659857324743446e-07 0 2.659957324743446e-07 0.00021 2.660057324743446e-07 0 2.66028406597631e-07 0 2.6603840659763104e-07 0.00021 2.6604840659763105e-07 0 2.677536432091508e-07 0 2.677636432091508e-07 0.00021 2.677736432091508e-07 0 2.685541141580712e-07 0 2.6856411415807124e-07 0.00021 2.6857411415807125e-07 0 2.6925171819722754e-07 0 2.6926171819722755e-07 0.00021 2.6927171819722756e-07 0 2.7130555724596173e-07 0 2.7131555724596174e-07 0.00021 2.7132555724596176e-07 0 2.7337745341582933e-07 0 2.7338745341582935e-07 0.00021 2.7339745341582936e-07 0 2.736447026008455e-07 0 2.736547026008455e-07 0.00021 2.736647026008455e-07 0 2.7417181696059513e-07 0 2.7418181696059514e-07 0.00021 2.7419181696059515e-07 0 2.769282059457115e-07 0 2.7693820594571154e-07 0.00021 2.7694820594571155e-07 0 2.779020852293439e-07 0 2.7791208522934394e-07 0.00021 2.7792208522934395e-07 0 2.781274804727846e-07 0 2.781374804727846e-07 0.00021 2.781474804727846e-07 0 2.850559450264362e-07 0 2.850659450264362e-07 0.00021 2.8507594502643623e-07 0 2.85208425587032e-07 0 2.85218425587032e-07 0.00021 2.85228425587032e-07 0 2.856658078280284e-07 0 2.856758078280284e-07 0.00021 2.8568580782802844e-07 0 2.860265266640539e-07 0 2.860365266640539e-07 0.00021 2.860465266640539e-07 0 2.8680125364885963e-07 0 2.8681125364885964e-07 0.00021 2.8682125364885965e-07 0 2.8725488497863425e-07 0 2.8726488497863426e-07 0.00021 2.8727488497863427e-07 0 2.878372042045353e-07 0 2.878472042045353e-07 0.00021 2.8785720420453533e-07 0 2.8785720420453533e-07 0 2.8786720420453534e-07 0.00021 2.8787720420453535e-07 0 2.879398987344334e-07 0 2.879498987344334e-07 0.00021 2.879598987344334e-07 0 2.9112125394280873e-07 0 2.9113125394280874e-07 0.00021 2.9114125394280875e-07 0 2.9132974762678007e-07 0 2.913397476267801e-07 0.00021 2.913497476267801e-07 0 2.9313474989326173e-07 0 2.9314474989326174e-07 0.00021 2.9315474989326175e-07 0 2.9669377498564287e-07 0 2.967037749856429e-07 0.00021 2.967137749856429e-07 0 2.979549157839136e-07 0 2.9796491578391363e-07 0.00021 2.9797491578391364e-07 0 3.0048407922852025e-07 0 3.0049407922852026e-07 0.00021 3.005040792285203e-07 0 3.015468691995361e-07 0 3.015568691995361e-07 0.00021 3.015668691995361e-07 0 3.030055843490482e-07 0 3.030155843490482e-07 0.00021 3.030255843490482e-07 0 3.052190212042465e-07 0 3.052290212042465e-07 0.00021 3.0523902120424653e-07 0 3.071000174363338e-07 0 3.071100174363338e-07 0.00021 3.071200174363338e-07 0 3.0845540505023763e-07 0 3.0846540505023765e-07 0.00021 3.0847540505023766e-07 0 3.0993652253650804e-07 0 3.0994652253650805e-07 0.00021 3.0995652253650806e-07 0 3.110765562808823e-07 0 3.1108655628088233e-07 0.00021 3.1109655628088235e-07 0 3.137356187556843e-07 0 3.137456187556843e-07 0.00021 3.137556187556843e-07 0 3.1442453597303716e-07 0 3.144345359730372e-07 0.00021 3.144445359730372e-07 0 3.1462343556578557e-07 0 3.146334355657856e-07 0.00021 3.146434355657856e-07 0 3.157574642068975e-07 0 3.157674642068975e-07 0.00021 3.1577746420689754e-07 0 3.1794063564390616e-07 0 3.179506356439062e-07 0.00021 3.179606356439062e-07 0 3.180622174017109e-07 0 3.180722174017109e-07 0.00021 3.1808221740171093e-07 0 3.1873576041630354e-07 0 3.1874576041630356e-07 0.00021 3.1875576041630357e-07 0 3.190921462904973e-07 0 3.191021462904973e-07 0.00021 3.191121462904973e-07 0 3.197626012272499e-07 0 3.197726012272499e-07 0.00021 3.197826012272499e-07 0 3.200909354671324e-07 0 3.201009354671324e-07 0.00021 3.201109354671324e-07 0 3.2145709869806005e-07 0 3.2146709869806006e-07 0.00021 3.214770986980601e-07 0 3.228714878023408e-07 0 3.228814878023408e-07 0.00021 3.2289148780234084e-07 0 3.230498826992058e-07 0 3.230598826992058e-07 0.00021 3.2306988269920583e-07 0 3.2475449010369396e-07 0 3.2476449010369397e-07 0.00021 3.24774490103694e-07 0 3.2604970689732074e-07 0 3.2605970689732075e-07 0.00021 3.2606970689732076e-07 0 3.2802207762443905e-07 0 3.2803207762443906e-07 0.00021 3.280420776244391e-07 0 3.312226045204065e-07 0 3.312326045204065e-07 0.00021 3.312426045204065e-07 0 3.315698482853284e-07 0 3.3157984828532843e-07 0.00021 3.3158984828532845e-07 0 3.3163957694093096e-07 0 3.31649576940931e-07 0.00021 3.31659576940931e-07 0 3.3223130832182375e-07 0 3.3224130832182376e-07 0.00021 3.3225130832182377e-07 0 3.339673436197919e-07 0 3.3397734361979193e-07 0.00021 3.3398734361979194e-07 0 3.349558387716958e-07 0 3.349658387716958e-07 0.00021 3.349758387716958e-07 0 3.367951624822747e-07 0 3.368051624822747e-07 0.00021 3.368151624822747e-07 0 3.3700144864853805e-07 0 3.3701144864853807e-07 0.00021 3.370214486485381e-07 0 3.4513020295519843e-07 0 3.4514020295519844e-07 0.00021 3.4515020295519845e-07 0 3.451798894645128e-07 0 3.451898894645128e-07 0.00021 3.4519988946451283e-07 0 3.459546115254856e-07 0 3.459646115254856e-07 0.00021 3.459746115254856e-07 0 3.469892494651749e-07 0 3.4699924946517493e-07 0.00021 3.4700924946517494e-07 0 3.4755829564028706e-07 0 3.4756829564028707e-07 0.00021 3.475782956402871e-07 0 3.488376981867025e-07 0 3.488476981867025e-07 0.00021 3.488576981867025e-07 0 3.492873138237428e-07 0 3.492973138237428e-07 0.00021 3.493073138237428e-07 0 3.497018019892401e-07 0 3.497118019892401e-07 0.00021 3.497218019892401e-07 0 3.51277128541241e-07 0 3.51287128541241e-07 0.00021 3.51297128541241e-07 0 3.527134951818813e-07 0 3.527234951818813e-07 0.00021 3.527334951818813e-07 0 3.5322031181023926e-07 0 3.532303118102393e-07 0.00021 3.532403118102393e-07 0 3.5339105119488737e-07 0 3.534010511948874e-07 0.00021 3.534110511948874e-07 0 3.54300688793913e-07 0 3.5431068879391303e-07 0.00021 3.5432068879391304e-07 0 3.550685212932968e-07 0 3.550785212932968e-07 0.00021 3.550885212932968e-07 0 3.556184201346119e-07 0 3.556284201346119e-07 0.00021 3.556384201346119e-07 0 3.5628825658894306e-07 0 3.562982565889431e-07 0.00021 3.563082565889431e-07 0 3.565085461937499e-07 0 3.5651854619374993e-07 0.00021 3.5652854619374994e-07 0 3.570075046833531e-07 0 3.570175046833531e-07 0.00021 3.570275046833531e-07 0 3.590706469881986e-07 0 3.5908064698819864e-07 0.00021 3.5909064698819865e-07 0 3.5909064698819865e-07 0 3.5910064698819866e-07 0.00021 3.5911064698819867e-07 0 3.5919896596864527e-07 0 3.592089659686453e-07 0.00021 3.592189659686453e-07 0 3.593868439652468e-07 0 3.593968439652468e-07 0.00021 3.594068439652468e-07 0 3.6045341489658615e-07 0 3.6046341489658616e-07 0.00021 3.6047341489658617e-07 0 3.613975375575079e-07 0 3.614075375575079e-07 0.00021 3.614175375575079e-07 0 3.6195073896974405e-07 0 3.6196073896974406e-07 0.00021 3.619707389697441e-07 0 3.621407616084656e-07 0 3.621507616084656e-07 0.00021 3.621607616084656e-07 0 3.621607616084656e-07 0 3.621707616084656e-07 0.00021 3.6218076160846563e-07 0 3.633601965463313e-07 0 3.633701965463313e-07 0.00021 3.633801965463313e-07 0 3.6378687004425406e-07 0 3.6379687004425407e-07 0.00021 3.638068700442541e-07 0 3.65055471630763e-07 0 3.65065471630763e-07 0.00021 3.65075471630763e-07 0 3.675180713424342e-07 0 3.675280713424342e-07 0.00021 3.675380713424342e-07 0 3.6755370597592423e-07 0 3.6756370597592424e-07 0.00021 3.6757370597592425e-07 0 3.6792638831391386e-07 0 3.679363883139139e-07 0.00021 3.679463883139139e-07 0 3.7064620794357136e-07 0 3.706562079435714e-07 0.00021 3.706662079435714e-07 0 3.707986076339846e-07 0 3.708086076339846e-07 0.00021 3.7081860763398464e-07 0 3.726633055572702e-07 0 3.726733055572702e-07 0.00021 3.726833055572702e-07 0 3.751875437934598e-07 0 3.751975437934598e-07 0.00021 3.752075437934598e-07 0 3.7539811404287286e-07 0 3.754081140428729e-07 0.00021 3.754181140428729e-07 0 3.784549873501555e-07 0 3.7846498735015553e-07 0.00021 3.7847498735015554e-07 0 3.788694362550302e-07 0 3.788794362550302e-07 0.00021 3.7888943625503023e-07 0 3.791577922620349e-07 0 3.791677922620349e-07 0.00021 3.791777922620349e-07 0 3.7920071320140204e-07 0 3.7921071320140205e-07 0.00021 3.7922071320140206e-07 0 3.800887705266648e-07 0 3.800987705266648e-07 0.00021 3.8010877052666483e-07 0 3.812462276439575e-07 0 3.812562276439575e-07 0.00021 3.8126622764395754e-07 0 3.8306535470068115e-07 0 3.8307535470068116e-07 0.00021 3.8308535470068117e-07 0 3.8387442657722084e-07 0 3.8388442657722085e-07 0.00021 3.8389442657722087e-07 0 3.849573786350134e-07 0 3.849673786350134e-07 0.00021 3.849773786350134e-07 0 3.8629666247665824e-07 0 3.8630666247665825e-07 0.00021 3.8631666247665826e-07 0 3.8721899489215704e-07 0 3.8722899489215705e-07 0.00021 3.8723899489215706e-07 0 3.8738940795153045e-07 0 3.8739940795153046e-07 0.00021 3.8740940795153047e-07 0 3.8743437885200706e-07 0 3.874443788520071e-07 0.00021 3.874543788520071e-07 0 3.874543788520071e-07 0 3.874643788520071e-07 0.00021 3.874743788520071e-07 0 3.8916431045005983e-07 0 3.8917431045005984e-07 0.00021 3.8918431045005985e-07 0 3.8925162621917056e-07 0 3.8926162621917057e-07 0.00021 3.892716262191706e-07 0 3.9072709336222045e-07 0 3.9073709336222046e-07 0.00021 3.907470933622205e-07 0 3.907845311148958e-07 0 3.9079453111489583e-07 0.00021 3.9080453111489584e-07 0 3.909593167680887e-07 0 3.909693167680887e-07 0.00021 3.909793167680887e-07 0 3.9159896814956225e-07 0 3.9160896814956226e-07 0.00021 3.9161896814956227e-07 0 3.924876825325274e-07 0 3.924976825325274e-07 0.00021 3.925076825325274e-07 0 3.9350796434000184e-07 0 3.9351796434000185e-07 0.00021 3.9352796434000186e-07 0 3.9414693555828875e-07 0 3.9415693555828876e-07 0.00021 3.9416693555828877e-07 0 3.968572986031864e-07 0 3.9686729860318643e-07 0.00021 3.9687729860318644e-07 0 3.971908688161828e-07 0 3.972008688161828e-07 0.00021 3.972108688161828e-07 0 3.981869193243574e-07 0 3.981969193243574e-07 0.00021 3.982069193243574e-07 0 3.9846472741454007e-07 0 3.984747274145401e-07 0.00021 3.984847274145401e-07 0 3.9904138852511073e-07 0 3.9905138852511074e-07 0.00021 3.9906138852511075e-07 0 3.9906258622348423e-07 0 3.9907258622348424e-07 0.00021 3.9908258622348425e-07 0 3.991686843406582e-07 0 3.991786843406582e-07 0.00021 3.9918868434065824e-07 0 4.0153686957963053e-07 0 4.0154686957963054e-07 0.00021 4.0155686957963055e-07 0 4.017904914344307e-07 0 4.018004914344307e-07 0.00021 4.018104914344307e-07 0 4.0425782007489034e-07 0 4.0426782007489035e-07 0.00021 4.0427782007489036e-07 0 4.0573677639794993e-07 0 4.0574677639794994e-07 0.00021 4.0575677639794996e-07 0 4.0618811240818236e-07 0 4.061981124081824e-07 0.00021 4.062081124081824e-07 0 4.067114278689894e-07 0 4.0672142786898944e-07 0.00021 4.0673142786898945e-07 0 4.0797724086881427e-07 0 4.079872408688143e-07 0.00021 4.079972408688143e-07 0 4.0861655665867814e-07 0 4.0862655665867815e-07 0.00021 4.0863655665867816e-07 0 4.1051856053339143e-07 0 4.1052856053339145e-07 0.00021 4.1053856053339146e-07 0 4.1300854730127605e-07 0 4.1301854730127607e-07 0.00021 4.130285473012761e-07 0 4.1353817884860985e-07 0 4.1354817884860986e-07 0.00021 4.1355817884860987e-07 0 4.1425771735916186e-07 0 4.1426771735916187e-07 0.00021 4.142777173591619e-07 0 4.162426546644969e-07 0 4.162526546644969e-07 0.00021 4.162626546644969e-07 0 4.1701879179907163e-07 0 4.1702879179907164e-07 0.00021 4.1703879179907165e-07 0 4.1803834943353533e-07 0 4.1804834943353535e-07 0.00021 4.1805834943353536e-07 0 4.182733109568072e-07 0 4.182833109568072e-07 0.00021 4.182933109568072e-07 0 4.196729693280082e-07 0 4.196829693280082e-07 0.00021 4.196929693280082e-07 0 4.2242683751925896e-07 0 4.2243683751925897e-07 0.00021 4.22446837519259e-07 0 4.225471858777105e-07 0 4.225571858777105e-07 0.00021 4.2256718587771053e-07 0 4.2632526325038696e-07 0 4.26335263250387e-07 0.00021 4.26345263250387e-07 0 4.264173185340453e-07 0 4.264273185340453e-07 0.00021 4.2643731853404534e-07 0 4.2643731853404534e-07 0 4.2644731853404535e-07 0.00021 4.2645731853404536e-07 0 4.275739205709493e-07 0 4.2758392057094933e-07 0.00021 4.2759392057094935e-07 0 4.315648469105334e-07 0 4.315748469105334e-07 0.00021 4.315848469105334e-07 0 4.32371688821095e-07 0 4.32381688821095e-07 0.00021 4.32391688821095e-07 0 4.3303394013226415e-07 0 4.3304394013226416e-07 0.00021 4.3305394013226417e-07 0 4.331307673959151e-07 0 4.331407673959151e-07 0.00021 4.331507673959151e-07 0 4.3396925563488223e-07 0 4.3397925563488224e-07 0.00021 4.3398925563488225e-07 0 4.3649877369164133e-07 0 4.3650877369164134e-07 0.00021 4.3651877369164135e-07 0 4.3727153739151235e-07 0 4.3728153739151237e-07 0.00021 4.372915373915124e-07 0 4.374936713213958e-07 0 4.375036713213958e-07 0.00021 4.3751367132139583e-07 0 4.415669788609778e-07 0 4.415769788609778e-07 0.00021 4.4158697886097783e-07 0 4.431634807404694e-07 0 4.431734807404694e-07 0.00021 4.431834807404694e-07 0 4.4505516741119085e-07 0 4.4506516741119087e-07 0.00021 4.450751674111909e-07 0 4.4774186976295663e-07 0 4.4775186976295664e-07 0.00021 4.4776186976295665e-07 0 4.4952502833853084e-07 0 4.4953502833853086e-07 0.00021 4.4954502833853087e-07 0 4.5057477651262254e-07 0 4.5058477651262256e-07 0.00021 4.5059477651262257e-07 0 4.5133680387456227e-07 0 4.513468038745623e-07 0.00021 4.513568038745623e-07 0 4.515495381016658e-07 0 4.5155953810166584e-07 0.00021 4.5156953810166585e-07 0 4.5753438656139345e-07 0 4.5754438656139346e-07 0.00021 4.5755438656139347e-07 0 4.576977644312412e-07 0 4.5770776443124123e-07 0.00021 4.5771776443124124e-07 0 4.5893462833200166e-07 0 4.5894462833200167e-07 0.00021 4.589546283320017e-07 0 4.5923424973730435e-07 0 4.5924424973730436e-07 0.00021 4.592542497373044e-07 0 4.6008987377206005e-07 0 4.6009987377206006e-07 0.00021 4.601098737720601e-07 0 4.6124908418509405e-07 0 4.6125908418509406e-07 0.00021 4.612690841850941e-07 0 4.61514032627379e-07 0 4.61524032627379e-07 0.00021 4.6153403262737903e-07 0 4.6268872902543086e-07 0 4.6269872902543087e-07 0.00021 4.627087290254309e-07 0 4.63643512828246e-07 0 4.63653512828246e-07 0.00021 4.63663512828246e-07 0 4.6478962470113934e-07 0 4.6479962470113935e-07 0.00021 4.6480962470113936e-07 0 4.65620176620758e-07 0 4.65630176620758e-07 0.00021 4.6564017662075803e-07 0 4.668566079521195e-07 0 4.6686660795211953e-07 0.00021 4.6687660795211954e-07 0 4.6725736480839785e-07 0 4.6726736480839786e-07 0.00021 4.672773648083979e-07 0 4.7010860641720205e-07 0 4.7011860641720206e-07 0.00021 4.7012860641720207e-07 0 4.707977970545275e-07 0 4.708077970545275e-07 0.00021 4.708177970545275e-07 0 4.7117250663530254e-07 0 4.7118250663530256e-07 0.00021 4.7119250663530257e-07 0 4.7141711715800716e-07 0 4.7142711715800717e-07 0.00021 4.714371171580072e-07 0 4.719727026010081e-07 0 4.7198270260100813e-07 0.00021 4.7199270260100814e-07 0 4.723785303131776e-07 0 4.723885303131776e-07 0.00021 4.723985303131776e-07 0 4.728465719632227e-07 0 4.728565719632227e-07 0.00021 4.728665719632227e-07 0 4.745948265901252e-07 0 4.746048265901252e-07 0.00021 4.7461482659012523e-07 0 4.766243177597558e-07 0 4.7663431775975583e-07 0.00021 4.7664431775975584e-07 0 4.777543672694652e-07 0 4.777643672694651e-07 0.00021 4.777743672694651e-07 0 4.786883731419148e-07 0 4.786983731419148e-07 0.00021 4.787083731419147e-07 0 4.794184905500471e-07 0 4.79428490550047e-07 0.00021 4.79438490550047e-07 0 4.809105486176305e-07 0 4.809205486176305e-07 0.00021 4.809305486176305e-07 0 4.810794097065684e-07 0 4.810894097065684e-07 0.00021 4.810994097065683e-07 0 4.814767568051773e-07 0 4.814867568051772e-07 0.00021 4.814967568051772e-07 0 4.81643126924069e-07 0 4.81653126924069e-07 0.00021 4.81663126924069e-07 0 4.825622708841467e-07 0 4.825722708841467e-07 0.00021 4.825822708841466e-07 0 4.833587391293588e-07 0 4.833687391293588e-07 0.00021 4.833787391293587e-07 0 4.838081751423143e-07 0 4.838181751423142e-07 0.00021 4.838281751423142e-07 0 4.844784622484099e-07 0 4.844884622484098e-07 0.00021 4.844984622484098e-07 0 4.847934664923255e-07 0 4.848034664923255e-07 0.00021 4.848134664923254e-07 0 4.854378812126383e-07 0 4.854478812126383e-07 0.00021 4.854578812126382e-07 0 4.855285157539212e-07 0 4.855385157539212e-07 0.00021 4.855485157539211e-07 0 4.856015684954276e-07 0 4.856115684954275e-07 0.00021 4.856215684954275e-07 0 4.875652517877694e-07 0 4.875752517877693e-07 0.00021 4.875852517877693e-07 0 4.893221788582382e-07 0 4.893321788582382e-07 0.00021 4.893421788582382e-07 0 4.894077359568227e-07 0 4.894177359568227e-07 0.00021 4.894277359568227e-07 0 4.896257067858277e-07 0 4.896357067858277e-07 0.00021 4.896457067858277e-07 0 4.905071241688221e-07 0 4.905171241688221e-07 0.00021 4.905271241688221e-07 0 4.922735558583491e-07 0 4.922835558583491e-07 0.00021 4.92293555858349e-07 0 4.946235293344569e-07 0 4.946335293344569e-07 0.00021 4.946435293344568e-07 0 4.949110457422516e-07 0 4.949210457422516e-07 0.00021 4.949310457422516e-07 0 4.951226731448942e-07 0 4.951326731448942e-07 0.00021 4.951426731448941e-07 0 4.963619007803629e-07 0 4.963719007803628e-07 0.00021 4.963819007803628e-07 0 4.978836591242253e-07 0 4.978936591242252e-07 0.00021 4.979036591242252e-07 0 4.982145348254781e-07 0 4.982245348254781e-07 0.00021 4.98234534825478e-07 0 4.982851011294611e-07 0 4.98295101129461e-07 0.00021 4.98305101129461e-07 0 4.997319463759376e-07 0 4.997419463759375e-07 0.00021 4.997519463759375e-07 0 4.999656896104611e-07 0 4.999756896104611e-07 0.00021 4.99985689610461e-07 0 )
X98 SYNAPSE 97 96 1098
X1098 JTL 1098 98
VIN100 100 0 pwl(0 0)
VIN102 102 0 pwl(0 0)
VIN104 104 0 pwl(0 0)
X113 LIF_NEURON 89 93 95 98 91 100 102 104 113
R164 11 0 2
R165 19 0 2
R166 27 0 2
R167 35 0 2
R218 61 0 2
R219 87 0 2
R220 113 0 2
.temp 4.2
.model jmitll jj(rtype=1, vg=2.8mV, cap=0.07pF, r0=160, rN=16, icrit=0.15mA)
.tran 0.008 10000p 0 0.008p
.print PHASE 61 0
.print PHASE 87 0
.print PHASE 113 0
.print PHASE 1 0
.print PHASE 2 0
.print PHASE 3 0
.print PHASE 4 0
.print PHASE 37 0
.print PHASE 39 0
.print PHASE 41 0
.print PHASE 43 0
.print PHASE 46 0
.print PHASE 63 0
.print PHASE 65 0
.print PHASE 67 0
.print PHASE 69 0
.print PHASE 72 0
.print PHASE 89 0
.print PHASE 91 0
.print PHASE 93 0
.print PHASE 95 0
.print PHASE 98 0
.end
